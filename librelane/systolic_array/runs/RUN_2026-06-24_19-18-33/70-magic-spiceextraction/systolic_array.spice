* NGSPICE file created from systolic_array.ext - technology: sky130A

* Black-box entry subcircuit for sky130_fd_sc_hd__fill_2 abstract view
.subckt sky130_fd_sc_hd__fill_2 VGND VNB VPB VPWR
.ends

* Black-box entry subcircuit for sky130_fd_sc_hd__decap_3 abstract view
.subckt sky130_fd_sc_hd__decap_3 VGND VNB VPB VPWR
.ends

* Black-box entry subcircuit for sky130_fd_sc_hd__and2_2 abstract view
.subckt sky130_fd_sc_hd__and2_2 A B VGND VNB VPB VPWR X
.ends

* Black-box entry subcircuit for sky130_fd_sc_hd__inv_2 abstract view
.subckt sky130_fd_sc_hd__inv_2 A VGND VNB VPB VPWR Y
.ends

* Black-box entry subcircuit for sky130_fd_sc_hd__dfxtp_2 abstract view
.subckt sky130_fd_sc_hd__dfxtp_2 CLK D VGND VNB VPB VPWR Q
.ends

* Black-box entry subcircuit for sky130_fd_sc_hd__xnor2_2 abstract view
.subckt sky130_fd_sc_hd__xnor2_2 A B VGND VNB VPB VPWR Y
.ends

* Black-box entry subcircuit for sky130_fd_sc_hd__a32o_2 abstract view
.subckt sky130_fd_sc_hd__a32o_2 A1 A2 A3 B1 B2 VGND VNB VPB VPWR X
.ends

* Black-box entry subcircuit for sky130_fd_sc_hd__nand2_2 abstract view
.subckt sky130_fd_sc_hd__nand2_2 A B VGND VNB VPB VPWR Y
.ends

* Black-box entry subcircuit for sky130_fd_sc_hd__o211a_2 abstract view
.subckt sky130_fd_sc_hd__o211a_2 A1 A2 B1 C1 VGND VNB VPB VPWR X
.ends

* Black-box entry subcircuit for sky130_fd_sc_hd__or2_2 abstract view
.subckt sky130_fd_sc_hd__or2_2 A B VGND VNB VPB VPWR X
.ends

* Black-box entry subcircuit for sky130_fd_sc_hd__a21o_2 abstract view
.subckt sky130_fd_sc_hd__a21o_2 A1 A2 B1 VGND VNB VPB VPWR X
.ends

* Black-box entry subcircuit for sky130_fd_sc_hd__xor2_2 abstract view
.subckt sky130_fd_sc_hd__xor2_2 A B VGND VNB VPB VPWR X
.ends

* Black-box entry subcircuit for sky130_fd_sc_hd__nor2b_4 abstract view
.subckt sky130_fd_sc_hd__nor2b_4 A B_N VGND VNB VPB VPWR Y
.ends

* Black-box entry subcircuit for sky130_fd_sc_hd__a22o_2 abstract view
.subckt sky130_fd_sc_hd__a22o_2 A1 A2 B1 B2 VGND VNB VPB VPWR X
.ends

* Black-box entry subcircuit for sky130_fd_sc_hd__fill_1 abstract view
.subckt sky130_fd_sc_hd__fill_1 VGND VNB VPB VPWR
.ends

* Black-box entry subcircuit for sky130_fd_sc_hd__nor2_2 abstract view
.subckt sky130_fd_sc_hd__nor2_2 A B VGND VNB VPB VPWR Y
.ends

* Black-box entry subcircuit for sky130_fd_sc_hd__a31o_2 abstract view
.subckt sky130_fd_sc_hd__a31o_2 A1 A2 A3 B1 VGND VNB VPB VPWR X
.ends

* Black-box entry subcircuit for sky130_fd_sc_hd__buf_6 abstract view
.subckt sky130_fd_sc_hd__buf_6 A VGND VNB VPB VPWR X
.ends

* Black-box entry subcircuit for sky130_fd_sc_hd__tapvpwrvgnd_1 abstract view
.subckt sky130_fd_sc_hd__tapvpwrvgnd_1 VGND VPWR
.ends

* Black-box entry subcircuit for sky130_fd_sc_hd__and2_4 abstract view
.subckt sky130_fd_sc_hd__and2_4 A B VGND VNB VPB VPWR X
.ends

* Black-box entry subcircuit for sky130_fd_sc_hd__or3_2 abstract view
.subckt sky130_fd_sc_hd__or3_2 A B C VGND VNB VPB VPWR X
.ends

* Black-box entry subcircuit for sky130_fd_sc_hd__clkbuf_2 abstract view
.subckt sky130_fd_sc_hd__clkbuf_2 A VGND VNB VPB VPWR X
.ends

* Black-box entry subcircuit for sky130_fd_sc_hd__a21oi_2 abstract view
.subckt sky130_fd_sc_hd__a21oi_2 A1 A2 B1 VGND VNB VPB VPWR Y
.ends

* Black-box entry subcircuit for sky130_fd_sc_hd__nand3_2 abstract view
.subckt sky130_fd_sc_hd__nand3_2 A B C VGND VNB VPB VPWR Y
.ends

* Black-box entry subcircuit for sky130_fd_sc_hd__a21bo_2 abstract view
.subckt sky130_fd_sc_hd__a21bo_2 A1 A2 B1_N VGND VNB VPB VPWR X
.ends

* Black-box entry subcircuit for sky130_fd_sc_hd__and3_2 abstract view
.subckt sky130_fd_sc_hd__and3_2 A B C VGND VNB VPB VPWR X
.ends

* Black-box entry subcircuit for sky130_fd_sc_hd__or2b_2 abstract view
.subckt sky130_fd_sc_hd__or2b_2 A B_N VGND VNB VPB VPWR X
.ends

* Black-box entry subcircuit for sky130_fd_sc_hd__a21boi_2 abstract view
.subckt sky130_fd_sc_hd__a21boi_2 A1 A2 B1_N VGND VNB VPB VPWR Y
.ends

* Black-box entry subcircuit for sky130_fd_sc_hd__and4_2 abstract view
.subckt sky130_fd_sc_hd__and4_2 A B C D VGND VNB VPB VPWR X
.ends

* Black-box entry subcircuit for sky130_fd_sc_hd__and2b_2 abstract view
.subckt sky130_fd_sc_hd__and2b_2 A_N B VGND VNB VPB VPWR X
.ends

* Black-box entry subcircuit for sky130_fd_sc_hd__or3b_2 abstract view
.subckt sky130_fd_sc_hd__or3b_2 A B C_N VGND VNB VPB VPWR X
.ends

* Black-box entry subcircuit for sky130_fd_sc_hd__clkbuf_16 abstract view
.subckt sky130_fd_sc_hd__clkbuf_16 A VGND VNB VPB VPWR X
.ends

* Black-box entry subcircuit for sky130_fd_sc_hd__o31a_2 abstract view
.subckt sky130_fd_sc_hd__o31a_2 A1 A2 A3 B1 VGND VNB VPB VPWR X
.ends

* Black-box entry subcircuit for sky130_fd_sc_hd__nor3_2 abstract view
.subckt sky130_fd_sc_hd__nor3_2 A B C VGND VNB VPB VPWR Y
.ends

* Black-box entry subcircuit for sky130_fd_sc_hd__a32oi_2 abstract view
.subckt sky130_fd_sc_hd__a32oi_2 A1 A2 A3 B1 B2 VGND VNB VPB VPWR Y
.ends

* Black-box entry subcircuit for sky130_fd_sc_hd__o21ai_2 abstract view
.subckt sky130_fd_sc_hd__o21ai_2 A1 A2 B1 VGND VNB VPB VPWR Y
.ends

* Black-box entry subcircuit for sky130_fd_sc_hd__or2_4 abstract view
.subckt sky130_fd_sc_hd__or2_4 A B VGND VNB VPB VPWR X
.ends

* Black-box entry subcircuit for sky130_fd_sc_hd__buf_2 abstract view
.subckt sky130_fd_sc_hd__buf_2 A VGND VNB VPB VPWR X
.ends

* Black-box entry subcircuit for sky130_fd_sc_hd__diode_2 abstract view
.subckt sky130_fd_sc_hd__diode_2 DIODE VGND VNB VPB VPWR
.ends

* Black-box entry subcircuit for sky130_fd_sc_hd__or4_2 abstract view
.subckt sky130_fd_sc_hd__or4_2 A B C D VGND VNB VPB VPWR X
.ends

* Black-box entry subcircuit for sky130_fd_sc_hd__a31oi_2 abstract view
.subckt sky130_fd_sc_hd__a31oi_2 A1 A2 A3 B1 VGND VNB VPB VPWR Y
.ends

* Black-box entry subcircuit for sky130_fd_sc_hd__o22a_2 abstract view
.subckt sky130_fd_sc_hd__o22a_2 A1 A2 B1 B2 VGND VNB VPB VPWR X
.ends

* Black-box entry subcircuit for sky130_fd_sc_hd__o311ai_2 abstract view
.subckt sky130_fd_sc_hd__o311ai_2 A1 A2 A3 B1 C1 VGND VNB VPB VPWR Y
.ends

* Black-box entry subcircuit for sky130_fd_sc_hd__nand3b_2 abstract view
.subckt sky130_fd_sc_hd__nand3b_2 A_N B C VGND VNB VPB VPWR Y
.ends

* Black-box entry subcircuit for sky130_fd_sc_hd__o21ba_2 abstract view
.subckt sky130_fd_sc_hd__o21ba_2 A1 A2 B1_N VGND VNB VPB VPWR X
.ends

* Black-box entry subcircuit for sky130_fd_sc_hd__o2bb2a_2 abstract view
.subckt sky130_fd_sc_hd__o2bb2a_2 A1_N A2_N B1 B2 VGND VNB VPB VPWR X
.ends

* Black-box entry subcircuit for sky130_fd_sc_hd__or3_4 abstract view
.subckt sky130_fd_sc_hd__or3_4 A B C VGND VNB VPB VPWR X
.ends

* Black-box entry subcircuit for sky130_fd_sc_hd__o21a_2 abstract view
.subckt sky130_fd_sc_hd__o21a_2 A1 A2 B1 VGND VNB VPB VPWR X
.ends

* Black-box entry subcircuit for sky130_fd_sc_hd__and3_4 abstract view
.subckt sky130_fd_sc_hd__and3_4 A B C VGND VNB VPB VPWR X
.ends

* Black-box entry subcircuit for sky130_fd_sc_hd__o21bai_2 abstract view
.subckt sky130_fd_sc_hd__o21bai_2 A1 A2 B1_N VGND VNB VPB VPWR Y
.ends

* Black-box entry subcircuit for sky130_fd_sc_hd__a211o_2 abstract view
.subckt sky130_fd_sc_hd__a211o_2 A1 A2 B1 C1 VGND VNB VPB VPWR X
.ends

* Black-box entry subcircuit for sky130_fd_sc_hd__a211oi_2 abstract view
.subckt sky130_fd_sc_hd__a211oi_2 A1 A2 B1 C1 VGND VNB VPB VPWR Y
.ends

* Black-box entry subcircuit for sky130_fd_sc_hd__nand4_2 abstract view
.subckt sky130_fd_sc_hd__nand4_2 A B C D VGND VNB VPB VPWR Y
.ends

* Black-box entry subcircuit for sky130_fd_sc_hd__conb_1 abstract view
.subckt sky130_fd_sc_hd__conb_1 VGND VNB VPB VPWR HI LO
.ends

* Black-box entry subcircuit for sky130_fd_sc_hd__or3b_4 abstract view
.subckt sky130_fd_sc_hd__or3b_4 A B C_N VGND VNB VPB VPWR X
.ends

* Black-box entry subcircuit for sky130_fd_sc_hd__and3b_2 abstract view
.subckt sky130_fd_sc_hd__and3b_2 A_N B C VGND VNB VPB VPWR X
.ends

* Black-box entry subcircuit for sky130_fd_sc_hd__o41a_2 abstract view
.subckt sky130_fd_sc_hd__o41a_2 A1 A2 A3 A4 B1 VGND VNB VPB VPWR X
.ends

* Black-box entry subcircuit for sky130_fd_sc_hd__a311o_2 abstract view
.subckt sky130_fd_sc_hd__a311o_2 A1 A2 A3 B1 C1 VGND VNB VPB VPWR X
.ends

* Black-box entry subcircuit for sky130_fd_sc_hd__o211a_4 abstract view
.subckt sky130_fd_sc_hd__o211a_4 A1 A2 B1 C1 VGND VNB VPB VPWR X
.ends

* Black-box entry subcircuit for sky130_fd_sc_hd__a311oi_2 abstract view
.subckt sky130_fd_sc_hd__a311oi_2 A1 A2 A3 B1 C1 VGND VNB VPB VPWR Y
.ends

* Black-box entry subcircuit for sky130_fd_sc_hd__o211ai_2 abstract view
.subckt sky130_fd_sc_hd__o211ai_2 A1 A2 B1 C1 VGND VNB VPB VPWR Y
.ends

* Black-box entry subcircuit for sky130_fd_sc_hd__and3b_4 abstract view
.subckt sky130_fd_sc_hd__and3b_4 A_N B C VGND VNB VPB VPWR X
.ends

* Black-box entry subcircuit for sky130_fd_sc_hd__or4b_4 abstract view
.subckt sky130_fd_sc_hd__or4b_4 A B C D_N VGND VNB VPB VPWR X
.ends

* Black-box entry subcircuit for sky130_fd_sc_hd__o32a_2 abstract view
.subckt sky130_fd_sc_hd__o32a_2 A1 A2 A3 B1 B2 VGND VNB VPB VPWR X
.ends

* Black-box entry subcircuit for sky130_fd_sc_hd__a311o_4 abstract view
.subckt sky130_fd_sc_hd__a311o_4 A1 A2 A3 B1 C1 VGND VNB VPB VPWR X
.ends

* Black-box entry subcircuit for sky130_fd_sc_hd__a21oi_4 abstract view
.subckt sky130_fd_sc_hd__a21oi_4 A1 A2 B1 VGND VNB VPB VPWR Y
.ends

* Black-box entry subcircuit for sky130_fd_sc_hd__nand2b_4 abstract view
.subckt sky130_fd_sc_hd__nand2b_4 A_N B VGND VNB VPB VPWR Y
.ends

* Black-box entry subcircuit for sky130_fd_sc_hd__nand2b_2 abstract view
.subckt sky130_fd_sc_hd__nand2b_2 A_N B VGND VNB VPB VPWR Y
.ends

* Black-box entry subcircuit for sky130_fd_sc_hd__and4bb_2 abstract view
.subckt sky130_fd_sc_hd__and4bb_2 A_N B_N C D VGND VNB VPB VPWR X
.ends

* Black-box entry subcircuit for sky130_fd_sc_hd__a221o_2 abstract view
.subckt sky130_fd_sc_hd__a221o_2 A1 A2 B1 B2 C1 VGND VNB VPB VPWR X
.ends

* Black-box entry subcircuit for sky130_fd_sc_hd__clkbuf_8 abstract view
.subckt sky130_fd_sc_hd__clkbuf_8 A VGND VNB VPB VPWR X
.ends

* Black-box entry subcircuit for sky130_fd_sc_hd__a22oi_2 abstract view
.subckt sky130_fd_sc_hd__a22oi_2 A1 A2 B1 B2 VGND VNB VPB VPWR Y
.ends

* Black-box entry subcircuit for sky130_fd_sc_hd__a22o_4 abstract view
.subckt sky130_fd_sc_hd__a22o_4 A1 A2 B1 B2 VGND VNB VPB VPWR X
.ends

* Black-box entry subcircuit for sky130_fd_sc_hd__fa_1 abstract view
.subckt sky130_fd_sc_hd__fa_1 A B CIN VGND VNB VPB VPWR COUT SUM
.ends

* Black-box entry subcircuit for sky130_fd_sc_hd__and4_4 abstract view
.subckt sky130_fd_sc_hd__and4_4 A B C D VGND VNB VPB VPWR X
.ends

* Black-box entry subcircuit for sky130_fd_sc_hd__mux2_1 abstract view
.subckt sky130_fd_sc_hd__mux2_1 A0 A1 S VGND VNB VPB VPWR X
.ends

* Black-box entry subcircuit for sky130_fd_sc_hd__or4_4 abstract view
.subckt sky130_fd_sc_hd__or4_4 A B C D VGND VNB VPB VPWR X
.ends

* Black-box entry subcircuit for sky130_fd_sc_hd__o2111ai_2 abstract view
.subckt sky130_fd_sc_hd__o2111ai_2 A1 A2 B1 C1 D1 VGND VNB VPB VPWR Y
.ends

* Black-box entry subcircuit for sky130_fd_sc_hd__nor2_8 abstract view
.subckt sky130_fd_sc_hd__nor2_8 A B VGND VNB VPB VPWR Y
.ends

* Black-box entry subcircuit for sky130_fd_sc_hd__inv_6 abstract view
.subckt sky130_fd_sc_hd__inv_6 A VGND VNB VPB VPWR Y
.ends

* Black-box entry subcircuit for sky130_fd_sc_hd__o22a_4 abstract view
.subckt sky130_fd_sc_hd__o22a_4 A1 A2 B1 B2 VGND VNB VPB VPWR X
.ends

* Black-box entry subcircuit for sky130_fd_sc_hd__a211o_4 abstract view
.subckt sky130_fd_sc_hd__a211o_4 A1 A2 B1 C1 VGND VNB VPB VPWR X
.ends

* Black-box entry subcircuit for sky130_fd_sc_hd__nor2b_2 abstract view
.subckt sky130_fd_sc_hd__nor2b_2 A B_N VGND VNB VPB VPWR Y
.ends

* Black-box entry subcircuit for sky130_fd_sc_hd__a2bb2o_2 abstract view
.subckt sky130_fd_sc_hd__a2bb2o_2 A1_N A2_N B1 B2 VGND VNB VPB VPWR X
.ends

* Black-box entry subcircuit for sky130_fd_sc_hd__o31ai_2 abstract view
.subckt sky130_fd_sc_hd__o31ai_2 A1 A2 A3 B1 VGND VNB VPB VPWR Y
.ends

* Black-box entry subcircuit for sky130_fd_sc_hd__inv_4 abstract view
.subckt sky130_fd_sc_hd__inv_4 A VGND VNB VPB VPWR Y
.ends

* Black-box entry subcircuit for sky130_fd_sc_hd__or4b_2 abstract view
.subckt sky130_fd_sc_hd__or4b_2 A B C D_N VGND VNB VPB VPWR X
.ends

* Black-box entry subcircuit for sky130_fd_sc_hd__o311a_2 abstract view
.subckt sky130_fd_sc_hd__o311a_2 A1 A2 A3 B1 C1 VGND VNB VPB VPWR X
.ends

* Black-box entry subcircuit for sky130_fd_sc_hd__buf_4 abstract view
.subckt sky130_fd_sc_hd__buf_4 A VGND VNB VPB VPWR X
.ends

.subckt systolic_array VGND VPWR a_inputs_flat[0] a_inputs_flat[10] a_inputs_flat[11]
+ a_inputs_flat[12] a_inputs_flat[13] a_inputs_flat[14] a_inputs_flat[15] a_inputs_flat[16]
+ a_inputs_flat[17] a_inputs_flat[18] a_inputs_flat[19] a_inputs_flat[1] a_inputs_flat[20]
+ a_inputs_flat[21] a_inputs_flat[22] a_inputs_flat[23] a_inputs_flat[24] a_inputs_flat[25]
+ a_inputs_flat[26] a_inputs_flat[27] a_inputs_flat[28] a_inputs_flat[29] a_inputs_flat[2]
+ a_inputs_flat[30] a_inputs_flat[31] a_inputs_flat[3] a_inputs_flat[4] a_inputs_flat[5]
+ a_inputs_flat[6] a_inputs_flat[7] a_inputs_flat[8] a_inputs_flat[9] b_inputs_flat[0]
+ b_inputs_flat[10] b_inputs_flat[11] b_inputs_flat[12] b_inputs_flat[13] b_inputs_flat[14]
+ b_inputs_flat[15] b_inputs_flat[16] b_inputs_flat[17] b_inputs_flat[18] b_inputs_flat[19]
+ b_inputs_flat[1] b_inputs_flat[20] b_inputs_flat[21] b_inputs_flat[22] b_inputs_flat[23]
+ b_inputs_flat[24] b_inputs_flat[25] b_inputs_flat[26] b_inputs_flat[27] b_inputs_flat[28]
+ b_inputs_flat[29] b_inputs_flat[2] b_inputs_flat[30] b_inputs_flat[31] b_inputs_flat[3]
+ b_inputs_flat[4] b_inputs_flat[5] b_inputs_flat[6] b_inputs_flat[7] b_inputs_flat[8]
+ b_inputs_flat[9] clear_acc clk compute_enable enable load_weights ready reset results_flat[0]
+ results_flat[10] results_flat[11] results_flat[12] results_flat[13] results_flat[14]
+ results_flat[15] results_flat[16] results_flat[17] results_flat[18] results_flat[19]
+ results_flat[1] results_flat[20] results_flat[21] results_flat[22] results_flat[23]
+ results_flat[24] results_flat[25] results_flat[26] results_flat[27] results_flat[28]
+ results_flat[29] results_flat[2] results_flat[30] results_flat[31] results_flat[32]
+ results_flat[33] results_flat[34] results_flat[35] results_flat[36] results_flat[37]
+ results_flat[38] results_flat[39] results_flat[3] results_flat[40] results_flat[41]
+ results_flat[42] results_flat[43] results_flat[44] results_flat[45] results_flat[46]
+ results_flat[47] results_flat[48] results_flat[49] results_flat[4] results_flat[50]
+ results_flat[51] results_flat[52] results_flat[53] results_flat[54] results_flat[55]
+ results_flat[56] results_flat[57] results_flat[58] results_flat[59] results_flat[5]
+ results_flat[60] results_flat[61] results_flat[62] results_flat[63] results_flat[6]
+ results_flat[7] results_flat[8] results_flat[9]
XFILLER_67_531 VGND VGND VPWR VPWR sky130_fd_sc_hd__fill_2
XFILLER_67_553 VGND VGND VPWR VPWR sky130_fd_sc_hd__decap_3
Xg_row\[1\].g_col\[1\].pe__1554_ g_row\[1\].g_col\[1\].pe__1554_/A g_row\[1\].g_col\[1\].pe__1554_/B
+ VGND VGND VPWR VPWR g_row\[1\].g_col\[1\].pe__1562_/A sky130_fd_sc_hd__and2_2
Xg_row\[1\].g_col\[0\].pe__1538_ g_row\[1\].g_col\[0\].pe__2736_/Q VGND VGND VPWR
+ VPWR g_row\[1\].g_col\[0\].pe__2075_/A sky130_fd_sc_hd__inv_2
XFILLER_67_586 VGND VGND VPWR VPWR sky130_fd_sc_hd__decap_3
Xg_row\[0\].g_col\[0\].pe__2734_ clkbuf_leaf_38_clk/X g_row\[0\].g_col\[0\].pe__2734_/D
+ VGND VGND VPWR VPWR g_row\[0\].g_col\[0\].pe__2734_/Q sky130_fd_sc_hd__dfxtp_2
Xg_row\[0\].g_col\[1\].pe__2750_ clkbuf_leaf_6_clk/X g_row\[0\].g_col\[1\].pe__2750_/D
+ VGND VGND VPWR VPWR g_row\[0\].g_col\[1\].pe__2750_/Q sky130_fd_sc_hd__dfxtp_2
Xg_row\[0\].g_col\[1\].pe__1701_ g_row\[0\].g_col\[1\].pe__1701_/A g_row\[0\].g_col\[1\].pe__1701_/B
+ VGND VGND VPWR VPWR g_row\[0\].g_col\[1\].pe__1827_/B sky130_fd_sc_hd__xnor2_2
Xg_row\[1\].g_col\[1\].pe__1485_ g_row\[1\].g_col\[1\].pe__1608_/A1 g_row\[1\].g_col\[1\].pe__1729_/A2
+ g_row\[1\].g_col\[1\].pe__1729_/A3 g_row\[1\].g_col\[1\].pe__1729_/B1 g_row\[1\].g_col\[1\].pe__1970_/A
+ VGND VGND VPWR VPWR g_row\[1\].g_col\[1\].pe__1486_/B sky130_fd_sc_hd__a32o_2
Xg_row\[1\].g_col\[0\].pe__1469_ g_row\[1\].g_col\[0\].pe__2733_/Q g_row\[1\].g_col\[0\].pe__2250_/A
+ VGND VGND VPWR VPWR g_row\[1\].g_col\[0\].pe__1471_/A sky130_fd_sc_hd__nand2_2
Xg_row\[0\].g_col\[1\].pe__2681_ g_row\[0\].g_col\[1\].pe__2681_/A1 g_row\[0\].g_col\[1\].pe__2680_/B
+ g_row\[0\].g_col\[1\].pe__2680_/Y g_row\[0\].g_col\[1\].pe__2687_/C1 VGND VGND VPWR
+ VPWR g_row\[0\].g_col\[1\].pe__2681_/X sky130_fd_sc_hd__o211a_2
Xg_row\[0\].g_col\[0\].pe__2665_ g_row\[0\].g_col\[0\].pe__2669_/A hold2069/X VGND
+ VGND VPWR VPWR g_row\[0\].g_col\[0\].pe__2665_/X sky130_fd_sc_hd__or2_2
Xg_row\[0\].g_col\[1\].pe__1632_ g_row\[0\].g_col\[1\].pe__1883_/A g_row\[0\].g_col\[1\].pe__1883_/B
+ VGND VGND VPWR VPWR g_row\[0\].g_col\[1\].pe__1633_/B sky130_fd_sc_hd__xnor2_2
XFILLER_82_589 VGND VGND VPWR VPWR sky130_fd_sc_hd__decap_3
Xg_row\[0\].g_col\[0\].pe__1616_ g_row\[0\].g_col\[1\].pe__2635_/C g_row\[0\].g_col\[0\].pe__1616_/A2
+ g_row\[0\].g_col\[0\].pe__2724_/Q VGND VGND VPWR VPWR g_row\[0\].g_col\[0\].pe__1875_/A
+ sky130_fd_sc_hd__a21o_2
XFILLER_50_431 VGND VGND VPWR VPWR sky130_fd_sc_hd__decap_3
Xg_row\[0\].g_col\[0\].pe__1547_ g_row\[0\].g_col\[0\].pe__1547_/A g_row\[0\].g_col\[0\].pe__1547_/B
+ VGND VGND VPWR VPWR g_row\[0\].g_col\[0\].pe__1550_/B sky130_fd_sc_hd__xor2_2
Xg_row\[0\].g_col\[1\].pe__1563_ g_row\[0\].g_col\[1\].pe__1846_/A g_row\[0\].g_col\[1\].pe__1563_/B
+ VGND VGND VPWR VPWR g_row\[0\].g_col\[1\].pe__1587_/A sky130_fd_sc_hd__or2_2
Xg_row\[1\].g_col\[1\].pe__2106_ g_row\[1\].g_col\[1\].pe__2106_/A g_row\[1\].g_col\[1\].pe__2105_/X
+ VGND VGND VPWR VPWR g_row\[1\].g_col\[1\].pe__2107_/B sky130_fd_sc_hd__nor2b_4
XFILLER_22_144 VGND VGND VPWR VPWR sky130_fd_sc_hd__decap_3
XFILLER_50_453 VGND VGND VPWR VPWR sky130_fd_sc_hd__decap_3
Xg_row\[0\].g_col\[1\].pe__1494_ g_row\[0\].g_col\[1\].pe__2019_/B2 g_row\[0\].g_col\[1\].pe__1715_/B
+ g_row\[0\].g_col\[1\].pe__1863_/B1 g_row\[0\].g_col\[1\].pe__1957_/B2 VGND VGND
+ VPWR VPWR g_row\[0\].g_col\[1\].pe__1495_/B sky130_fd_sc_hd__a22o_2
Xg_row\[1\].g_col\[1\].pe__2037_ g_row\[1\].g_col\[1\].pe__2209_/A g_row\[1\].g_col\[1\].pe__2037_/B
+ VGND VGND VPWR VPWR g_row\[1\].g_col\[1\].pe__2038_/C sky130_fd_sc_hd__xnor2_2
XFILLER_10_328 VGND VGND VPWR VPWR sky130_fd_sc_hd__fill_1
XFILLER_50_486 VGND VGND VPWR VPWR sky130_fd_sc_hd__fill_1
Xg_row\[0\].g_col\[0\].pe__1478_ g_row\[0\].g_col\[0\].pe__1478_/A g_row\[0\].g_col\[0\].pe__1478_/B
+ VGND VGND VPWR VPWR g_row\[0\].g_col\[0\].pe__1662_/B sky130_fd_sc_hd__xor2_2
Xg_row\[0\].g_col\[1\].pe__2115_ g_row\[0\].g_col\[1\].pe__2405_/A g_row\[0\].g_col\[1\].pe__2115_/B
+ VGND VGND VPWR VPWR g_row\[0\].g_col\[1\].pe__2744_/D sky130_fd_sc_hd__nor2_2
XFILLER_7_7 VGND VGND VPWR VPWR sky130_fd_sc_hd__fill_2
Xg_row\[0\].g_col\[1\].pe__2046_ g_row\[0\].g_col\[1\].pe__2094_/B g_row\[0\].g_col\[1\].pe__1988_/B
+ g_row\[0\].g_col\[1\].pe__1988_/C g_row\[0\].g_col\[1\].pe__2045_/X VGND VGND VPWR
+ VPWR g_row\[0\].g_col\[1\].pe__2047_/B sky130_fd_sc_hd__a31o_2
XFILLER_2_549 VGND VGND VPWR VPWR sky130_fd_sc_hd__fill_1
Xplace1094 place1094/A VGND VGND VPWR VPWR place1094/X sky130_fd_sc_hd__buf_6
XFILLER_45_225 VGND VGND VPWR VPWR sky130_fd_sc_hd__fill_2
XFILLER_93_36 VGND VGND VPWR VPWR sky130_fd_sc_hd__fill_2
XFILLER_26_461 VGND VGND VPWR VPWR sky130_fd_sc_hd__fill_2
XFILLER_60_206 VGND VGND VPWR VPWR sky130_fd_sc_hd__fill_1
XFILLER_14_645 VGND VGND VPWR VPWR sky130_fd_sc_hd__fill_1
XFILLER_26_85 VGND VGND VPWR VPWR sky130_fd_sc_hd__fill_1
XFILLER_14_689 VGND VGND VPWR VPWR sky130_fd_sc_hd__fill_1
XFILLER_41_453 VGND VGND VPWR VPWR sky130_fd_sc_hd__fill_1
XFILLER_9_126 VGND VGND VPWR VPWR sky130_fd_sc_hd__fill_2
XTAP_TAPCELL_ROW_52_993 VGND VPWR sky130_fd_sc_hd__tapvpwrvgnd_1
X_294_ _294_/CLK _294_/D VGND VGND VPWR VPWR _294_/Q sky130_fd_sc_hd__dfxtp_2
XFILLER_6_833 VGND VGND VPWR VPWR sky130_fd_sc_hd__decap_3
XTAP_TAPCELL_ROW_11_378 VGND VPWR sky130_fd_sc_hd__tapvpwrvgnd_1
XFILLER_5_343 VGND VGND VPWR VPWR sky130_fd_sc_hd__fill_1
Xg_row\[1\].g_col\[0\].pe__2510_ g_row\[1\].g_col\[0\].pe__2516_/B g_row\[1\].g_col\[0\].pe__2507_/Y
+ g_row\[1\].g_col\[0\].pe__2508_/Y g_row\[1\].g_col\[0\].pe__2509_/X VGND VGND VPWR
+ VPWR g_row\[1\].g_col\[0\].pe__2510_/X sky130_fd_sc_hd__a31o_2
XFILLER_3_34 VGND VGND VPWR VPWR sky130_fd_sc_hd__fill_1
Xg_row\[1\].g_col\[0\].pe__2441_ g_row\[1\].g_col\[0\].pe__2745_/Q g_row\[1\].g_col\[0\].pe__2441_/B
+ VGND VGND VPWR VPWR g_row\[1\].g_col\[0\].pe__2443_/B sky130_fd_sc_hd__xnor2_2
XFILLER_92_810 VGND VGND VPWR VPWR sky130_fd_sc_hd__fill_2
Xg_row\[1\].g_col\[0\].pe__2372_ g_row\[1\].g_col\[0\].pe__2372_/A g_row\[1\].g_col\[0\].pe__2386_/A
+ VGND VGND VPWR VPWR g_row\[1\].g_col\[0\].pe__2385_/A sky130_fd_sc_hd__xnor2_2
XFILLER_36_203 VGND VGND VPWR VPWR sky130_fd_sc_hd__fill_2
XFILLER_49_586 VGND VGND VPWR VPWR sky130_fd_sc_hd__decap_3
XFILLER_64_556 VGND VGND VPWR VPWR sky130_fd_sc_hd__fill_1
XTAP_TAPCELL_ROW_19_489 VGND VPWR sky130_fd_sc_hd__tapvpwrvgnd_1
Xg_row\[0\].g_col\[0\].pe__2450_ g_row\[0\].g_col\[0\].pe__2450_/A1 g_row\[0\].g_col\[0\].pe__2742_/Q
+ g_row\[0\].g_col\[0\].pe__2453_/B VGND VGND VPWR VPWR g_row\[0\].g_col\[0\].pe__2451_/B
+ sky130_fd_sc_hd__a21o_2
XFILLER_17_494 VGND VGND VPWR VPWR sky130_fd_sc_hd__fill_1
XFILLER_32_431 VGND VGND VPWR VPWR sky130_fd_sc_hd__fill_2
XFILLER_83_91 VGND VGND VPWR VPWR sky130_fd_sc_hd__fill_1
Xg_row\[0\].g_col\[0\].pe__1401_ g_row\[0\].g_col\[0\].pe__1401_/A1 g_row\[0\].g_col\[0\].pe__2686_/B
+ g_row\[0\].g_col\[0\].pe__1401_/B1 g_row\[0\].g_col\[0\].pe__1377_/Y VGND VGND VPWR
+ VPWR g_row\[0\].g_col\[0\].pe__1401_/X sky130_fd_sc_hd__o211a_2
Xg_row\[0\].g_col\[0\].pe__2381_ g_row\[0\].g_col\[0\].pe__2595_/A g_row\[0\].g_col\[0\].pe__2381_/B
+ VGND VGND VPWR VPWR g_row\[0\].g_col\[0\].pe__2752_/D sky130_fd_sc_hd__and2_4
XFILLER_60_784 VGND VGND VPWR VPWR sky130_fd_sc_hd__fill_1
XTAP_TAPCELL_ROW_30_654 VGND VPWR sky130_fd_sc_hd__tapvpwrvgnd_1
XTAP_TAPCELL_ROW_30_665 VGND VPWR sky130_fd_sc_hd__tapvpwrvgnd_1
XTAP_TAPCELL_ROW_93_1620 VGND VPWR sky130_fd_sc_hd__tapvpwrvgnd_1
Xg_row\[1\].g_col\[1\].pe__2724_ clkload14/A g_row\[1\].g_col\[1\].pe__2724_/D VGND
+ VGND VPWR VPWR g_row\[1\].g_col\[1\].pe__2724_/Q sky130_fd_sc_hd__dfxtp_2
Xg_row\[1\].g_col\[0\].pe__2708_ clkbuf_leaf_44_clk/X g_row\[1\].g_col\[0\].pe__2708_/D
+ VGND VGND VPWR VPWR g_row\[1\].g_col\[0\].pe__2708_/Q sky130_fd_sc_hd__dfxtp_2
XFILLER_87_615 VGND VGND VPWR VPWR sky130_fd_sc_hd__fill_1
XFILLER_87_637 VGND VGND VPWR VPWR sky130_fd_sc_hd__decap_3
Xg_row\[1\].g_col\[1\].pe__2655_ g_row\[1\].g_col\[1\].pe__2676_/A g_row\[1\].g_col\[1\].pe__2655_/B
+ VGND VGND VPWR VPWR g_row\[1\].g_col\[1\].pe__2655_/X sky130_fd_sc_hd__or2_2
Xg_row\[1\].g_col\[1\].pe__1606_ g_row\[1\].g_col\[1\].pe__1606_/A g_row\[1\].g_col\[1\].pe__1848_/B
+ VGND VGND VPWR VPWR g_row\[1\].g_col\[1\].pe__1849_/B sky130_fd_sc_hd__xnor2_2
Xg_row\[1\].g_col\[0\].pe__2639_ g_row\[1\].g_col\[0\].pe__2639_/A hold1766/X VGND
+ VGND VPWR VPWR g_row\[1\].g_col\[0\].pe__2639_/X sky130_fd_sc_hd__or2_2
XFILLER_74_309 VGND VGND VPWR VPWR sky130_fd_sc_hd__decap_3
Xg_row\[1\].g_col\[1\].pe__2586_ g_row\[1\].g_col\[1\].pe__2590_/A g_row\[1\].g_col\[1\].pe__2586_/B
+ g_row\[1\].g_col\[1\].pe__2586_/C VGND VGND VPWR VPWR g_row\[1\].g_col\[1\].pe__2586_/X
+ sky130_fd_sc_hd__or3_2
Xg_row\[0\].g_col\[1\].pe_hold3005 g_row\[0\].g_col\[1\].pe__2737_/Q VGND VGND VPWR
+ VPWR g_row\[0\].g_col\[1\].pe_hold3005/X sky130_fd_sc_hd__clkbuf_2
XFILLER_27_225 VGND VGND VPWR VPWR sky130_fd_sc_hd__decap_3
XFILLER_55_512 VGND VGND VPWR VPWR sky130_fd_sc_hd__decap_3
Xg_row\[1\].g_col\[1\].pe__1537_ g_row\[1\].g_col\[1\].pe__1499_/A g_row\[1\].g_col\[1\].pe__1499_/B
+ g_row\[1\].g_col\[1\].pe__1536_/X VGND VGND VPWR VPWR g_row\[1\].g_col\[1\].pe__1545_/A
+ sky130_fd_sc_hd__a21oi_2
Xg_row\[0\].g_col\[1\].pe_hold3049 g_row\[0\].g_col\[1\].pe__2735_/Q VGND VGND VPWR
+ VPWR g_row\[0\].g_col\[1\].pe_hold3049/X sky130_fd_sc_hd__clkbuf_2
Xg_row\[0\].g_col\[1\].pe_hold2326 g_row\[0\].g_col\[1\].pe__2116_/Y VGND VGND VPWR
+ VPWR g_row\[0\].g_col\[1\].pe__2158_/A2 sky130_fd_sc_hd__clkbuf_2
Xg_row\[0\].g_col\[1\].pe__2733_ clkbuf_leaf_90_clk/X g_row\[0\].g_col\[1\].pe__2733_/D
+ VGND VGND VPWR VPWR g_row\[0\].g_col\[1\].pe__2733_/Q sky130_fd_sc_hd__dfxtp_2
XFILLER_55_567 VGND VGND VPWR VPWR sky130_fd_sc_hd__decap_3
Xg_row\[0\].g_col\[0\].pe__2717_ _322_/CLK g_row\[0\].g_col\[0\].pe__2717_/D VGND
+ VGND VPWR VPWR hold3035/A sky130_fd_sc_hd__dfxtp_2
Xg_row\[0\].g_col\[1\].pe_hold2348 g_row\[0\].g_col\[1\].pe__2679_/X VGND VGND VPWR
+ VPWR g_row\[0\].g_col\[1\].pe__2722_/D sky130_fd_sc_hd__clkbuf_2
Xg_row\[0\].g_col\[1\].pe_hold2337 g_row\[0\].g_col\[1\].pe__2639_/X VGND VGND VPWR
+ VPWR g_row\[0\].g_col\[1\].pe__2640_/B1 sky130_fd_sc_hd__clkbuf_2
XTAP_TAPCELL_ROW_38_776 VGND VPWR sky130_fd_sc_hd__tapvpwrvgnd_1
XTAP_TAPCELL_ROW_38_787 VGND VPWR sky130_fd_sc_hd__tapvpwrvgnd_1
Xg_row\[0\].g_col\[0\].pe__2648_ g_row\[0\].g_col\[0\].pe__2656_/A1 g_row\[0\].g_col\[0\].pe__2648_/A2
+ g_row\[0\].g_col\[0\].pe__2687_/C1 g_row\[0\].g_col\[0\].pe__2647_/X VGND VGND VPWR
+ VPWR g_row\[0\].g_col\[0\].pe__2709_/D sky130_fd_sc_hd__o211a_2
Xg_row\[0\].g_col\[1\].pe__2664_ g_row\[0\].g_col\[1\].pe__2668_/A1 g_row\[0\].g_col\[1\].pe__2664_/A2
+ g_row\[0\].g_col\[1\].pe__2670_/B1 g_row\[0\].g_col\[1\].pe__2663_/X VGND VGND VPWR
+ VPWR g_row\[0\].g_col\[1\].pe__2664_/X sky130_fd_sc_hd__o211a_2
Xg_row\[0\].g_col\[1\].pe__1615_ g_row\[0\].g_col\[1\].pe__1615_/A g_row\[0\].g_col\[1\].pe__1615_/B
+ VGND VGND VPWR VPWR g_row\[0\].g_col\[1\].pe__1629_/A sky130_fd_sc_hd__xor2_2
Xg_row\[1\].g_col\[1\].pe__1399_ g_row\[1\].g_col\[1\].pe__1399_/A1 g_row\[1\].g_col\[1\].pe__1403_/A2
+ g_row\[1\].g_col\[1\].pe__1398_/X g_row\[1\].g_col\[1\].pe__2666_/B1 VGND VGND VPWR
+ VPWR g_row\[1\].g_col\[1\].pe__1399_/X sky130_fd_sc_hd__o211a_2
Xg_row\[0\].g_col\[1\].pe__2595_ g_row\[0\].g_col\[1\].pe__2595_/A g_row\[0\].g_col\[1\].pe__2595_/B
+ VGND VGND VPWR VPWR g_row\[0\].g_col\[1\].pe__2771_/D sky130_fd_sc_hd__and2_2
Xg_row\[0\].g_col\[0\].pe__2579_ g_row\[0\].g_col\[0\].pe__2579_/A g_row\[0\].g_col\[0\].pe__2579_/B
+ g_row\[0\].g_col\[0\].pe__2579_/C VGND VGND VPWR VPWR g_row\[0\].g_col\[0\].pe__2579_/Y
+ sky130_fd_sc_hd__nand3_2
Xg_row\[0\].g_col\[1\].pe__1546_ g_row\[0\].g_col\[1\].pe__1546_/A g_row\[0\].g_col\[1\].pe__1546_/B
+ VGND VGND VPWR VPWR g_row\[0\].g_col\[1\].pe__1547_/B sky130_fd_sc_hd__xnor2_2
XFILLER_11_648 VGND VGND VPWR VPWR sky130_fd_sc_hd__decap_3
XFILLER_50_272 VGND VGND VPWR VPWR sky130_fd_sc_hd__fill_1
Xg_row\[0\].g_col\[1\].pe__1477_ g_row\[0\].g_col\[1\].pe__1676_/A g_row\[0\].g_col\[1\].pe__1477_/B
+ VGND VGND VPWR VPWR g_row\[0\].g_col\[1\].pe__1478_/B sky130_fd_sc_hd__xnor2_2
XFILLER_2_313 VGND VGND VPWR VPWR sky130_fd_sc_hd__decap_3
XFILLER_77_103 VGND VGND VPWR VPWR sky130_fd_sc_hd__fill_1
Xg_row\[0\].g_col\[1\].pe__2029_ g_row\[0\].g_col\[1\].pe__2028_/B g_row\[0\].g_col\[1\].pe__2028_/C
+ g_row\[0\].g_col\[1\].pe__1459_/C VGND VGND VPWR VPWR g_row\[0\].g_col\[1\].pe__2034_/B
+ sky130_fd_sc_hd__a21bo_2
XFILLER_78_659 VGND VGND VPWR VPWR sky130_fd_sc_hd__fill_2
XFILLER_19_748 VGND VGND VPWR VPWR sky130_fd_sc_hd__decap_3
XFILLER_74_821 VGND VGND VPWR VPWR sky130_fd_sc_hd__fill_2
XFILLER_46_589 VGND VGND VPWR VPWR sky130_fd_sc_hd__decap_3
XFILLER_73_364 VGND VGND VPWR VPWR sky130_fd_sc_hd__fill_2
XFILLER_33_228 VGND VGND VPWR VPWR sky130_fd_sc_hd__fill_1
XTAP_TAPCELL_ROW_16_448 VGND VPWR sky130_fd_sc_hd__tapvpwrvgnd_1
Xg_row\[0\].g_col\[0\].pe_hold2004 g_row\[0\].g_col\[0\].pe__1393_/X VGND VGND VPWR
+ VPWR g_row\[0\].g_col\[0\].pe__2732_/D sky130_fd_sc_hd__clkbuf_2
XTAP_TAPCELL_ROW_60_1107 VGND VPWR sky130_fd_sc_hd__tapvpwrvgnd_1
Xg_row\[0\].g_col\[0\].pe_hold2026 g_row\[0\].g_col\[0\].pe_hold2923/X VGND VGND VPWR
+ VPWR g_row\[0\].g_col\[0\].pe__2635_/C sky130_fd_sc_hd__clkbuf_2
X_277_ _277_/CLK _277_/D VGND VGND VPWR VPWR _277_/Q sky130_fd_sc_hd__dfxtp_2
Xg_row\[1\].g_col\[0\].pe__1941_ g_row\[1\].g_col\[0\].pe__1941_/A g_row\[1\].g_col\[0\].pe__1941_/B
+ g_row\[1\].g_col\[0\].pe__1941_/C VGND VGND VPWR VPWR g_row\[1\].g_col\[0\].pe__1942_/B
+ sky130_fd_sc_hd__and3_2
Xg_row\[1\].g_col\[0\].pe__1872_ g_row\[1\].g_col\[0\].pe__1965_/A g_row\[1\].g_col\[0\].pe__1982_/B
+ g_row\[1\].g_col\[0\].pe__1424_/Y place1084/X VGND VGND VPWR VPWR g_row\[1\].g_col\[0\].pe__1873_/B
+ sky130_fd_sc_hd__a22o_2
XFILLER_68_103 VGND VGND VPWR VPWR sky130_fd_sc_hd__fill_2
XFILLER_69_604 VGND VGND VPWR VPWR sky130_fd_sc_hd__fill_2
Xg_row\[0\].g_col\[0\].pe__1950_ g_row\[0\].g_col\[0\].pe__1950_/A g_row\[0\].g_col\[0\].pe__1950_/B
+ VGND VGND VPWR VPWR g_row\[0\].g_col\[0\].pe__1950_/Y sky130_fd_sc_hd__nand2_2
Xg_row\[1\].g_col\[1\].pe_hold2091 g_row\[1\].g_col\[1\].pe_hold2867/X VGND VGND VPWR
+ VPWR g_row\[1\].g_col\[1\].pe__2716_/D sky130_fd_sc_hd__clkbuf_2
XFILLER_69_659 VGND VGND VPWR VPWR sky130_fd_sc_hd__fill_1
XTAP_TAPCELL_ROW_71_1269 VGND VPWR sky130_fd_sc_hd__tapvpwrvgnd_1
Xg_row\[1\].g_col\[1\].pe__2440_ g_row\[1\].g_col\[1\].pe__2763_/Q g_row\[1\].g_col\[1\].pe__2439_/Y
+ VGND VGND VPWR VPWR g_row\[1\].g_col\[1\].pe__2495_/A sky130_fd_sc_hd__or2b_2
XFILLER_56_309 VGND VGND VPWR VPWR sky130_fd_sc_hd__decap_3
Xg_row\[0\].g_col\[0\].pe__1881_ g_row\[0\].g_col\[0\].pe__1936_/A g_row\[0\].g_col\[0\].pe__1936_/B
+ VGND VGND VPWR VPWR g_row\[0\].g_col\[0\].pe__1882_/B sky130_fd_sc_hd__xnor2_2
Xg_row\[1\].g_col\[0\].pe__2424_ g_row\[1\].g_col\[0\].pe__2424_/A g_row\[1\].g_col\[0\].pe__2424_/B
+ VGND VGND VPWR VPWR g_row\[1\].g_col\[0\].pe__2425_/B sky130_fd_sc_hd__and2_2
Xg_row\[1\].g_col\[1\].pe__2371_ g_row\[1\].g_col\[1\].pe__2347_/A g_row\[1\].g_col\[1\].pe__2346_/B
+ g_row\[1\].g_col\[1\].pe__2346_/A VGND VGND VPWR VPWR g_row\[1\].g_col\[1\].pe__2386_/A
+ sky130_fd_sc_hd__a21boi_2
Xg_row\[1\].g_col\[0\].pe__2355_ g_row\[1\].g_col\[0\].pe__2355_/A g_row\[1\].g_col\[0\].pe__2355_/B
+ VGND VGND VPWR VPWR g_row\[1\].g_col\[0\].pe__2356_/B sky130_fd_sc_hd__nor2_2
XFILLER_24_206 VGND VGND VPWR VPWR sky130_fd_sc_hd__decap_3
Xg_row\[0\].g_col\[0\].pe__2502_ g_row\[0\].g_col\[0\].pe__2551_/A g_row\[0\].g_col\[0\].pe__2558_/B
+ g_row\[0\].g_col\[0\].pe__2546_/B g_row\[0\].g_col\[0\].pe__2502_/D VGND VGND VPWR
+ VPWR g_row\[0\].g_col\[0\].pe__2502_/X sky130_fd_sc_hd__and4_2
Xg_row\[1\].g_col\[0\].pe__2286_ g_row\[1\].g_col\[0\].pe__2286_/A g_row\[1\].g_col\[0\].pe__2310_/B
+ VGND VGND VPWR VPWR g_row\[1\].g_col\[0\].pe__2309_/B sky130_fd_sc_hd__xnor2_2
XTAP_TAPCELL_ROW_35_735 VGND VPWR sky130_fd_sc_hd__tapvpwrvgnd_1
Xg_row\[0\].g_col\[0\].pe__2433_ g_row\[0\].g_col\[0\].pe__2474_/B g_row\[0\].g_col\[0\].pe__2766_/Q
+ VGND VGND VPWR VPWR g_row\[0\].g_col\[0\].pe__2487_/B sky130_fd_sc_hd__and2b_2
XFILLER_33_773 VGND VGND VPWR VPWR sky130_fd_sc_hd__decap_3
Xg_row\[0\].g_col\[1\].pe__1400_ g_row\[0\].g_col\[1\].pe__1400_/A g_row\[0\].g_col\[1\].pe__1402_/B
+ VGND VGND VPWR VPWR g_row\[0\].g_col\[1\].pe__1400_/X sky130_fd_sc_hd__or2_2
XFILLER_60_592 VGND VGND VPWR VPWR sky130_fd_sc_hd__decap_3
Xg_row\[0\].g_col\[0\].pe__2364_ g_row\[0\].g_col\[0\].pe__2364_/A g_row\[0\].g_col\[0\].pe__2364_/B
+ VGND VGND VPWR VPWR g_row\[0\].g_col\[0\].pe__2365_/B sky130_fd_sc_hd__xnor2_2
Xg_row\[0\].g_col\[1\].pe__2380_ g_row\[0\].g_col\[1\].pe__2376_/X g_row\[0\].g_col\[1\].pe__2378_/X
+ g_row\[0\].g_col\[1\].pe__2379_/Y g_row\[0\].g_col\[1\].pe__2380_/B1 g_row\[0\].g_col\[1\].pe__1838_/A
+ VGND VGND VPWR VPWR g_row\[0\].g_col\[1\].pe__2380_/X sky130_fd_sc_hd__a32o_2
Xg_row\[0\].g_col\[0\].pe__2295_ g_row\[0\].g_col\[0\].pe__2295_/A g_row\[0\].g_col\[0\].pe__2295_/B
+ g_row\[0\].g_col\[0\].pe__2292_/X VGND VGND VPWR VPWR g_row\[0\].g_col\[0\].pe__2296_/B
+ sky130_fd_sc_hd__or3b_2
Xclkbuf_4_12_0_clk clkbuf_0_clk/X VGND VGND VPWR VPWR clkbuf_4_12_0_clk/X sky130_fd_sc_hd__clkbuf_16
Xg_row\[0\].g_col\[0\].pe_hold1881 g_row\[0\].g_col\[0\].pe__2751_/Q VGND VGND VPWR
+ VPWR g_row\[0\].g_col\[0\].pe__2336_/A sky130_fd_sc_hd__clkbuf_2
Xg_row\[1\].g_col\[1\].pe__2707_ clkbuf_leaf_92_clk/X g_row\[1\].g_col\[1\].pe__2707_/D
+ VGND VGND VPWR VPWR g_row\[1\].g_col\[1\].pe__2707_/Q sky130_fd_sc_hd__dfxtp_2
XFILLER_0_839 VGND VGND VPWR VPWR sky130_fd_sc_hd__fill_1
XFILLER_87_434 VGND VGND VPWR VPWR sky130_fd_sc_hd__fill_1
Xg_row\[1\].g_col\[1\].pe__2638_ g_row\[1\].g_col\[1\].pe__2635_/X g_row\[1\].g_col\[1\].pe__2636_/X
+ g_row\[1\].g_col\[1\].pe__2637_/X hold1766/X VGND VGND VPWR VPWR g_row\[1\].g_col\[1\].pe__2638_/X
+ sky130_fd_sc_hd__o31a_2
XFILLER_28_512 VGND VGND VPWR VPWR sky130_fd_sc_hd__decap_3
XFILLER_56_832 VGND VGND VPWR VPWR sky130_fd_sc_hd__decap_3
XFILLER_68_670 VGND VGND VPWR VPWR sky130_fd_sc_hd__decap_3
Xg_row\[1\].g_col\[1\].pe__2569_ g_row\[1\].g_col\[1\].pe__2569_/A g_row\[1\].g_col\[1\].pe__2569_/B
+ VGND VGND VPWR VPWR g_row\[1\].g_col\[1\].pe__2765_/D sky130_fd_sc_hd__and2_2
Xg_row\[0\].g_col\[1\].pe_hold2134 g_row\[0\].g_col\[1\].pe_hold2972/X VGND VGND VPWR
+ VPWR g_row\[0\].g_col\[1\].pe__2712_/D sky130_fd_sc_hd__clkbuf_2
Xg_row\[0\].g_col\[1\].pe_hold2167 _328_/Q VGND VGND VPWR VPWR g_row\[0\].g_col\[1\].pe_hold2167/X
+ sky130_fd_sc_hd__clkbuf_2
Xg_row\[0\].g_col\[1\].pe_hold2156 g_row\[0\].g_col\[1\].pe__1386_/X VGND VGND VPWR
+ VPWR g_row\[0\].g_col\[1\].pe__2729_/D sky130_fd_sc_hd__clkbuf_2
Xg_row\[0\].g_col\[1\].pe_hold2145 g_row\[0\].g_col\[1\].pe__2646_/X VGND VGND VPWR
+ VPWR g_row\[0\].g_col\[1\].pe__2708_/D sky130_fd_sc_hd__clkbuf_2
Xg_row\[0\].g_col\[1\].pe__2716_ _333_/CLK g_row\[0\].g_col\[1\].pe__2716_/D VGND
+ VGND VPWR VPWR hold2090/A sky130_fd_sc_hd__dfxtp_2
Xg_row\[0\].g_col\[1\].pe_hold2189 g_row\[0\].g_col\[1\].pe__2614_/X VGND VGND VPWR
+ VPWR g_row\[0\].g_col\[1\].pe__2615_/C1 sky130_fd_sc_hd__clkbuf_2
Xg_row\[0\].g_col\[1\].pe__2647_ g_row\[0\].g_col\[1\].pe__2661_/A hold2139/X VGND
+ VGND VPWR VPWR g_row\[0\].g_col\[1\].pe__2647_/X sky130_fd_sc_hd__or2_2
XTAP_TAPCELL_ROW_13_407 VGND VPWR sky130_fd_sc_hd__tapvpwrvgnd_1
Xg_row\[0\].g_col\[1\].pe__1529_ g_row\[0\].g_col\[1\].pe__1554_/A g_row\[0\].g_col\[1\].pe__1554_/B
+ VGND VGND VPWR VPWR g_row\[0\].g_col\[1\].pe__1555_/A sky130_fd_sc_hd__xor2_2
Xg_row\[0\].g_col\[0\].pe_place863 g_row\[0\].g_col\[0\].pe__1761_/B2 VGND VGND VPWR
+ VPWR g_row\[0\].g_col\[0\].pe__1804_/B sky130_fd_sc_hd__buf_6
XFILLER_2_154 VGND VGND VPWR VPWR sky130_fd_sc_hd__fill_2
XFILLER_19_501 VGND VGND VPWR VPWR sky130_fd_sc_hd__decap_3
Xg_row\[1\].g_col\[0\].pe__2140_ g_row\[1\].g_col\[0\].pe__2364_/A g_row\[1\].g_col\[0\].pe__2140_/B
+ VGND VGND VPWR VPWR g_row\[1\].g_col\[0\].pe__2174_/B sky130_fd_sc_hd__xnor2_2
Xg_row\[1\].g_col\[0\].pe__2071_ g_row\[1\].g_col\[0\].pe__2071_/A g_row\[1\].g_col\[0\].pe__2071_/B
+ VGND VGND VPWR VPWR g_row\[1\].g_col\[0\].pe__2078_/A sky130_fd_sc_hd__and2_2
XFILLER_15_751 VGND VGND VPWR VPWR sky130_fd_sc_hd__decap_3
XFILLER_61_389 VGND VGND VPWR VPWR sky130_fd_sc_hd__decap_3
X_329_ _340_/CLK _329_/D VGND VGND VPWR VPWR _329_/Q sky130_fd_sc_hd__dfxtp_2
Xg_row\[0\].g_col\[0\].pe__2080_ g_row\[0\].g_col\[0\].pe__1449_/A g_row\[0\].g_col\[0\].pe__1449_/B
+ g_row\[0\].g_col\[0\].pe__1983_/Y VGND VGND VPWR VPWR g_row\[0\].g_col\[0\].pe__2081_/C
+ sky130_fd_sc_hd__a21o_2
Xg_row\[1\].g_col\[1\].pe__1940_ g_row\[1\].g_col\[1\].pe__1941_/A g_row\[1\].g_col\[1\].pe__1941_/B
+ g_row\[1\].g_col\[1\].pe__1941_/C VGND VGND VPWR VPWR g_row\[1\].g_col\[1\].pe__2005_/A
+ sky130_fd_sc_hd__a21oi_2
Xg_row\[1\].g_col\[0\].pe__1924_ g_row\[1\].g_col\[0\].pe__1924_/A g_row\[1\].g_col\[0\].pe__1924_/B
+ g_row\[1\].g_col\[0\].pe__1924_/C VGND VGND VPWR VPWR g_row\[1\].g_col\[0\].pe__1980_/B
+ sky130_fd_sc_hd__nor3_2
Xg_row\[1\].g_col\[1\].pe__1871_ g_row\[1\].g_col\[1\].pe__1928_/A g_row\[1\].g_col\[1\].pe__1928_/B
+ VGND VGND VPWR VPWR g_row\[1\].g_col\[1\].pe__1874_/A sky130_fd_sc_hd__xor2_2
XFILLER_50_3 VGND VGND VPWR VPWR sky130_fd_sc_hd__decap_3
XTAP_TAPCELL_ROW_73_1309 VGND VPWR sky130_fd_sc_hd__tapvpwrvgnd_1
Xg_row\[1\].g_col\[0\].pe__1855_ g_row\[1\].g_col\[0\].pe__2021_/A g_row\[1\].g_col\[0\].pe__1855_/B
+ VGND VGND VPWR VPWR g_row\[1\].g_col\[0\].pe__1857_/B sky130_fd_sc_hd__xnor2_2
Xhold3008 hold3008/A VGND VGND VPWR VPWR hold3008/X sky130_fd_sc_hd__clkbuf_2
Xg_row\[1\].g_col\[0\].pe__1786_ g_row\[1\].g_col\[0\].pe__1796_/A g_row\[1\].g_col\[0\].pe__1796_/B
+ VGND VGND VPWR VPWR g_row\[1\].g_col\[0\].pe__1797_/A sky130_fd_sc_hd__nand2_2
Xg_row\[0\].g_col\[0\].pe__1933_ g_row\[0\].g_col\[0\].pe__1878_/A g_row\[0\].g_col\[0\].pe__1878_/B
+ g_row\[0\].g_col\[0\].pe__1932_/X VGND VGND VPWR VPWR g_row\[0\].g_col\[0\].pe__1999_/B
+ sky130_fd_sc_hd__a21oi_2
Xhold1606 hold3509/X VGND VGND VPWR VPWR hold3510/A sky130_fd_sc_hd__clkbuf_2
Xhold1617 hold2784/X VGND VGND VPWR VPWR hold2785/A sky130_fd_sc_hd__clkbuf_2
XFILLER_84_415 VGND VGND VPWR VPWR sky130_fd_sc_hd__fill_1
Xg_row\[0\].g_col\[0\].pe__1864_ g_row\[0\].g_col\[0\].pe__1864_/A g_row\[0\].g_col\[0\].pe__1864_/B
+ VGND VGND VPWR VPWR g_row\[0\].g_col\[0\].pe__1899_/B sky130_fd_sc_hd__xnor2_2
Xhold1628 hold3576/X VGND VGND VPWR VPWR hold2813/A sky130_fd_sc_hd__clkbuf_2
Xhold1639 hold1639/A VGND VGND VPWR VPWR hold1639/X sky130_fd_sc_hd__clkbuf_2
Xg_row\[1\].g_col\[1\].pe__2423_ g_row\[1\].g_col\[1\].pe__2424_/A g_row\[1\].g_col\[1\].pe__2424_/B
+ VGND VGND VPWR VPWR g_row\[1\].g_col\[1\].pe__2425_/A sky130_fd_sc_hd__nor2_2
Xg_row\[0\].g_col\[1\].pe__1880_ g_row\[0\].g_col\[1\].pe__1629_/A g_row\[0\].g_col\[1\].pe__1629_/B
+ g_row\[0\].g_col\[1\].pe__1879_/Y VGND VGND VPWR VPWR g_row\[0\].g_col\[1\].pe__1936_/B
+ sky130_fd_sc_hd__a21oi_2
XFILLER_49_191 VGND VGND VPWR VPWR sky130_fd_sc_hd__decap_3
XTAP_TAPCELL_ROW_88_1530 VGND VPWR sky130_fd_sc_hd__tapvpwrvgnd_1
Xg_row\[1\].g_col\[1\].pe__2354_ g_row\[1\].g_col\[1\].pe__2355_/A g_row\[1\].g_col\[1\].pe__2355_/B
+ VGND VGND VPWR VPWR g_row\[1\].g_col\[1\].pe__2356_/A sky130_fd_sc_hd__and2_2
XFILLER_65_673 VGND VGND VPWR VPWR sky130_fd_sc_hd__decap_3
Xg_row\[0\].g_col\[0\].pe__1795_ g_row\[0\].g_col\[0\].pe__1795_/A g_row\[0\].g_col\[0\].pe__1795_/B
+ g_row\[0\].g_col\[0\].pe__1795_/C VGND VGND VPWR VPWR g_row\[0\].g_col\[0\].pe__1811_/B
+ sky130_fd_sc_hd__and3_2
Xg_row\[1\].g_col\[0\].pe__2338_ g_row\[1\].g_col\[0\].pe__2338_/A g_row\[1\].g_col\[0\].pe__2325_/A
+ VGND VGND VPWR VPWR g_row\[1\].g_col\[0\].pe__2352_/B sky130_fd_sc_hd__or2b_2
XFILLER_52_312 VGND VGND VPWR VPWR sky130_fd_sc_hd__decap_3
XFILLER_80_621 VGND VGND VPWR VPWR sky130_fd_sc_hd__fill_2
Xg_row\[1\].g_col\[1\].pe__2285_ g_row\[1\].g_col\[1\].pe__2285_/A g_row\[1\].g_col\[1\].pe__2285_/B
+ VGND VGND VPWR VPWR g_row\[1\].g_col\[1\].pe__2310_/B sky130_fd_sc_hd__xnor2_2
Xg_row\[1\].g_col\[0\].pe_place1111 g_row\[1\].g_col\[0\].pe__1403_/C1 VGND VGND VPWR
+ VPWR g_row\[1\].g_col\[0\].pe__2670_/B1 sky130_fd_sc_hd__buf_6
Xg_row\[1\].g_col\[0\].pe__2269_ g_row\[1\].g_col\[0\].pe__2269_/A VGND VGND VPWR
+ VPWR g_row\[1\].g_col\[0\].pe__2432_/A sky130_fd_sc_hd__inv_2
Xg_row\[0\].g_col\[1\].pe__2501_ g_row\[0\].g_col\[1\].pe__2538_/A g_row\[0\].g_col\[1\].pe__2526_/A
+ g_row\[0\].g_col\[1\].pe__2501_/C g_row\[0\].g_col\[1\].pe__2533_/B VGND VGND VPWR
+ VPWR g_row\[0\].g_col\[1\].pe__2502_/D sky130_fd_sc_hd__and4_2
Xg_row\[0\].g_col\[0\].pe__2416_ g_row\[0\].g_col\[0\].pe__2450_/A1 g_row\[0\].g_col\[0\].pe__2747_/Q
+ g_row\[0\].g_col\[0\].pe__2436_/B VGND VGND VPWR VPWR g_row\[0\].g_col\[0\].pe__2434_/B
+ sky130_fd_sc_hd__a21oi_2
Xg_row\[0\].g_col\[0\].pe_hold3080 g_row\[0\].g_col\[0\].pe__2729_/Q VGND VGND VPWR
+ VPWR g_row\[0\].g_col\[0\].pe_hold3080/X sky130_fd_sc_hd__clkbuf_2
Xg_row\[0\].g_col\[1\].pe__2432_ g_row\[0\].g_col\[1\].pe__2432_/A g_row\[0\].g_col\[1\].pe__2432_/B
+ VGND VGND VPWR VPWR g_row\[0\].g_col\[1\].pe__2474_/B sky130_fd_sc_hd__xnor2_2
Xg_row\[0\].g_col\[1\].pe__2363_ g_row\[0\].g_col\[1\].pe__2632_/B g_row\[0\].g_col\[1\].pe__1558_/B
+ g_row\[0\].g_col\[1\].pe__2388_/B g_row\[0\].g_col\[1\].pe__2630_/B VGND VGND VPWR
+ VPWR g_row\[0\].g_col\[1\].pe__2364_/B sky130_fd_sc_hd__a22o_2
XFILLER_20_253 VGND VGND VPWR VPWR sky130_fd_sc_hd__decap_3
Xg_row\[0\].g_col\[0\].pe__2347_ g_row\[0\].g_col\[0\].pe__2347_/A g_row\[0\].g_col\[0\].pe__2347_/B
+ VGND VGND VPWR VPWR g_row\[0\].g_col\[0\].pe__2368_/B sky130_fd_sc_hd__xor2_2
Xg_row\[0\].g_col\[1\].pe_place960 g_row\[0\].g_col\[1\].pe__2633_/A1 VGND VGND VPWR
+ VPWR g_row\[0\].g_col\[1\].pe__2670_/A1 sky130_fd_sc_hd__buf_6
Xg_row\[0\].g_col\[0\].pe__2278_ g_row\[0\].g_col\[0\].pe__2030_/A g_row\[0\].g_col\[0\].pe__2278_/A2
+ g_row\[0\].g_col\[0\].pe__2278_/B1 g_row\[0\].g_col\[0\].pe__1970_/A VGND VGND VPWR
+ VPWR g_row\[0\].g_col\[0\].pe__2311_/A sky130_fd_sc_hd__a22o_2
Xg_row\[0\].g_col\[1\].pe__2294_ g_row\[0\].g_col\[1\].pe__2294_/A VGND VGND VPWR
+ VPWR g_row\[0\].g_col\[1\].pe__2329_/A sky130_fd_sc_hd__inv_2
Xg_row\[1\].g_col\[1\].pe_hold2838 g_row\[1\].g_col\[1\].pe__2717_/Q VGND VGND VPWR
+ VPWR g_row\[1\].g_col\[1\].pe__2663_/B sky130_fd_sc_hd__clkbuf_2
Xg_row\[1\].g_col\[1\].pe_hold2827 g_row\[1\].g_col\[1\].pe__2669_/X VGND VGND VPWR
+ VPWR g_row\[1\].g_col\[1\].pe__2670_/C1 sky130_fd_sc_hd__clkbuf_2
XFILLER_0_614 VGND VGND VPWR VPWR sky130_fd_sc_hd__fill_2
XFILLER_0_625 VGND VGND VPWR VPWR sky130_fd_sc_hd__fill_1
XFILLER_0_636 VGND VGND VPWR VPWR sky130_fd_sc_hd__decap_3
Xhold3542 hold3542/A VGND VGND VPWR VPWR hold3542/X sky130_fd_sc_hd__clkbuf_2
Xhold3531 hold3531/A VGND VGND VPWR VPWR hold3531/X sky130_fd_sc_hd__clkbuf_2
Xhold3520 hold3520/A VGND VGND VPWR VPWR hold3520/X sky130_fd_sc_hd__clkbuf_2
Xhold3586 hold3586/A VGND VGND VPWR VPWR hold3586/X sky130_fd_sc_hd__clkbuf_2
Xhold3575 hold3575/A VGND VGND VPWR VPWR hold3575/X sky130_fd_sc_hd__clkbuf_2
Xhold3564 hold3564/A VGND VGND VPWR VPWR hold3564/X sky130_fd_sc_hd__clkbuf_2
Xhold3553 a_inputs_flat[0] VGND VGND VPWR VPWR hold3553/X sky130_fd_sc_hd__clkbuf_2
XFILLER_44_813 VGND VGND VPWR VPWR sky130_fd_sc_hd__fill_2
XFILLER_43_345 VGND VGND VPWR VPWR sky130_fd_sc_hd__decap_3
XTAP_TAPCELL_ROW_26_598 VGND VPWR sky130_fd_sc_hd__tapvpwrvgnd_1
XFILLER_12_743 VGND VGND VPWR VPWR sky130_fd_sc_hd__decap_3
XFILLER_24_592 VGND VGND VPWR VPWR sky130_fd_sc_hd__fill_1
XFILLER_34_85 VGND VGND VPWR VPWR sky130_fd_sc_hd__fill_1
XFILLER_70_197 VGND VGND VPWR VPWR sky130_fd_sc_hd__fill_1
Xg_row\[0\].g_col\[1\].pe_place1132 g_row\[0\].g_col\[1\].pe__2724_/Q VGND VGND VPWR
+ VPWR g_row\[0\].g_col\[1\].pe__2045_/B sky130_fd_sc_hd__buf_6
Xg_row\[0\].g_col\[1\].pe_place1121 g_row\[0\].g_col\[1\].pe__1862_/A VGND VGND VPWR
+ VPWR g_row\[0\].g_col\[1\].pe__1816_/A sky130_fd_sc_hd__buf_6
Xg_row\[0\].g_col\[1\].pe_place1165 g_row\[0\].g_col\[1\].pe__2592_/A VGND VGND VPWR
+ VPWR g_row\[0\].g_col\[1\].pe__2595_/A sky130_fd_sc_hd__buf_6
Xg_row\[0\].g_col\[1\].pe_place1154 g_row\[0\].g_col\[1\].pe__2695_/Q VGND VGND VPWR
+ VPWR g_row\[0\].g_col\[1\].pe__2073_/B2 sky130_fd_sc_hd__buf_6
Xg_row\[0\].g_col\[1\].pe_place1143 g_row\[0\].g_col\[1\].pe__2241_/A1 VGND VGND VPWR
+ VPWR g_row\[0\].g_col\[1\].pe__1970_/A sky130_fd_sc_hd__buf_6
XFILLER_7_235 VGND VGND VPWR VPWR sky130_fd_sc_hd__fill_2
XTAP_TAPCELL_ROW_55_1028 VGND VPWR sky130_fd_sc_hd__tapvpwrvgnd_1
XTAP_TAPCELL_ROW_55_1039 VGND VPWR sky130_fd_sc_hd__tapvpwrvgnd_1
Xg_row\[1\].g_col\[0\].pe__1640_ g_row\[1\].g_col\[0\].pe__1640_/A g_row\[1\].g_col\[0\].pe__1640_/B
+ VGND VGND VPWR VPWR g_row\[1\].g_col\[0\].pe__1701_/A sky130_fd_sc_hd__xnor2_2
XFILLER_79_721 VGND VGND VPWR VPWR sky130_fd_sc_hd__decap_3
Xg_row\[1\].g_col\[0\].pe__1571_ g_row\[1\].g_col\[0\].pe__1571_/A g_row\[1\].g_col\[0\].pe__1571_/B
+ VGND VGND VPWR VPWR g_row\[1\].g_col\[0\].pe__1583_/A sky130_fd_sc_hd__xor2_2
XFILLER_78_253 VGND VGND VPWR VPWR sky130_fd_sc_hd__decap_3
Xg_row\[1\].g_col\[0\].pe_hold1826 g_row\[1\].g_col\[0\].pe__2528_/X VGND VGND VPWR
+ VPWR g_row\[1\].g_col\[0\].pe__2529_/B sky130_fd_sc_hd__clkbuf_2
XFILLER_38_139 VGND VGND VPWR VPWR sky130_fd_sc_hd__fill_1
Xg_row\[1\].g_col\[0\].pe_hold1859 g_row\[1\].g_col\[0\].pe__2613_/X VGND VGND VPWR
+ VPWR g_row\[1\].g_col\[0\].pe__2695_/D sky130_fd_sc_hd__clkbuf_2
XFILLER_19_364 VGND VGND VPWR VPWR sky130_fd_sc_hd__fill_1
XFILLER_47_673 VGND VGND VPWR VPWR sky130_fd_sc_hd__fill_1
XFILLER_35_835 VGND VGND VPWR VPWR sky130_fd_sc_hd__fill_1
Xg_row\[0\].g_col\[0\].pe__1580_ g_row\[0\].g_col\[0\].pe__1580_/A g_row\[0\].g_col\[0\].pe__1580_/B
+ VGND VGND VPWR VPWR g_row\[0\].g_col\[0\].pe__1580_/X sky130_fd_sc_hd__and2_2
Xg_row\[1\].g_col\[0\].pe__2123_ g_row\[1\].g_col\[0\].pe__2165_/A g_row\[1\].g_col\[0\].pe__2123_/B
+ g_row\[1\].g_col\[0\].pe__2123_/C VGND VGND VPWR VPWR g_row\[1\].g_col\[0\].pe__2128_/B
+ sky130_fd_sc_hd__nand3_2
XFILLER_22_507 VGND VGND VPWR VPWR sky130_fd_sc_hd__decap_3
XFILLER_62_676 VGND VGND VPWR VPWR sky130_fd_sc_hd__decap_3
Xg_row\[1\].g_col\[1\].pe__2070_ g_row\[1\].g_col\[1\].pe__1961_/A g_row\[1\].g_col\[1\].pe__1961_/B
+ g_row\[1\].g_col\[1\].pe__2024_/B g_row\[1\].g_col\[1\].pe__2023_/B g_row\[1\].g_col\[1\].pe__2023_/A
+ VGND VGND VPWR VPWR g_row\[1\].g_col\[1\].pe__2107_/A sky130_fd_sc_hd__a32o_2
Xg_row\[1\].g_col\[0\].pe__2054_ g_row\[1\].g_col\[0\].pe__2054_/A g_row\[1\].g_col\[0\].pe__2054_/B
+ VGND VGND VPWR VPWR g_row\[1\].g_col\[0\].pe__2068_/A sky130_fd_sc_hd__nand2_2
XFILLER_22_529 VGND VGND VPWR VPWR sky130_fd_sc_hd__decap_3
XFILLER_62_698 VGND VGND VPWR VPWR sky130_fd_sc_hd__fill_2
XTAP_TAPCELL_ROW_45_885 VGND VPWR sky130_fd_sc_hd__tapvpwrvgnd_1
XTAP_TAPCELL_ROW_83_1460 VGND VPWR sky130_fd_sc_hd__tapvpwrvgnd_1
Xg_row\[0\].g_col\[0\].pe__2201_ g_row\[0\].g_col\[0\].pe__2155_/B g_row\[0\].g_col\[0\].pe__2300_/A
+ g_row\[0\].g_col\[0\].pe__2299_/A VGND VGND VPWR VPWR g_row\[0\].g_col\[0\].pe__2233_/A
+ sky130_fd_sc_hd__a21o_2
XFILLER_30_551 VGND VGND VPWR VPWR sky130_fd_sc_hd__decap_3
Xg_row\[0\].g_col\[0\].pe__2132_ g_row\[0\].g_col\[0\].pe__2132_/A g_row\[0\].g_col\[0\].pe__2132_/B
+ VGND VGND VPWR VPWR g_row\[0\].g_col\[0\].pe__2222_/A sky130_fd_sc_hd__xnor2_2
Xg_row\[0\].g_col\[0\].pe__2063_ g_row\[0\].g_col\[0\].pe__2157_/A g_row\[0\].g_col\[0\].pe__2061_/Y
+ g_row\[0\].g_col\[0\].pe__2062_/X g_row\[0\].g_col\[0\].pe__2063_/B1 g_row\[0\].g_col\[0\].pe__1950_/A
+ VGND VGND VPWR VPWR g_row\[0\].g_col\[0\].pe__2063_/Y sky130_fd_sc_hd__a32oi_2
Xg_row\[1\].g_col\[1\].pe__1923_ g_row\[1\].g_col\[1\].pe__1424_/A g_row\[1\].g_col\[1\].pe__1424_/B
+ g_row\[1\].g_col\[1\].pe__1922_/Y VGND VGND VPWR VPWR g_row\[1\].g_col\[1\].pe__1924_/C
+ sky130_fd_sc_hd__a21oi_2
Xg_row\[1\].g_col\[0\].pe__1907_ g_row\[1\].g_col\[0\].pe__1907_/A g_row\[1\].g_col\[0\].pe__1907_/B
+ VGND VGND VPWR VPWR g_row\[1\].g_col\[0\].pe__1908_/B sky130_fd_sc_hd__xor2_2
Xg_row\[1\].g_col\[1\].pe__1854_ g_row\[1\].g_col\[1\].pe__2019_/B2 g_row\[1\].g_col\[1\].pe__1504_/Y
+ g_row\[1\].g_col\[1\].pe__1541_/X g_row\[1\].g_col\[1\].pe__1957_/B2 VGND VGND VPWR
+ VPWR g_row\[1\].g_col\[1\].pe__1855_/B sky130_fd_sc_hd__a22o_2
Xg_row\[1\].g_col\[0\].pe__1838_ g_row\[1\].g_col\[0\].pe__1838_/A place1233/X VGND
+ VGND VPWR VPWR g_row\[1\].g_col\[0\].pe__1838_/X sky130_fd_sc_hd__or2_2
Xg_row\[1\].g_col\[1\].pe__1785_ g_row\[1\].g_col\[1\].pe__1785_/A g_row\[1\].g_col\[1\].pe__1785_/B
+ VGND VGND VPWR VPWR g_row\[1\].g_col\[1\].pe__1796_/B sky130_fd_sc_hd__xor2_2
Xg_row\[1\].g_col\[0\].pe__1769_ g_row\[1\].g_col\[0\].pe__1781_/A g_row\[1\].g_col\[0\].pe__1781_/B
+ VGND VGND VPWR VPWR g_row\[1\].g_col\[0\].pe__1793_/C sky130_fd_sc_hd__nand2_2
Xg_row\[0\].g_col\[0\].pe__1916_ g_row\[0\].g_col\[0\].pe__1916_/A g_row\[0\].g_col\[0\].pe__1916_/B
+ VGND VGND VPWR VPWR g_row\[0\].g_col\[0\].pe__1931_/A sky130_fd_sc_hd__xor2_2
Xg_row\[0\].g_col\[1\].pe__1932_ g_row\[0\].g_col\[1\].pe__1877_/B g_row\[0\].g_col\[1\].pe__1932_/B
+ VGND VGND VPWR VPWR g_row\[0\].g_col\[1\].pe__1932_/X sky130_fd_sc_hd__and2b_2
XFILLER_85_746 VGND VGND VPWR VPWR sky130_fd_sc_hd__fill_2
XFILLER_85_757 VGND VGND VPWR VPWR sky130_fd_sc_hd__decap_3
Xhold1436 hold3177/X VGND VGND VPWR VPWR hold3178/A sky130_fd_sc_hd__clkbuf_2
Xhold1447 hold3152/X VGND VGND VPWR VPWR hold3153/A sky130_fd_sc_hd__clkbuf_2
Xhold1458 hold2472/X VGND VGND VPWR VPWR hold2473/A sky130_fd_sc_hd__clkbuf_2
Xg_row\[1\].g_col\[1\].pe__2406_ g_row\[1\].g_col\[1\].pe__2403_/A place1233/X place1249/X
+ VGND VGND VPWR VPWR g_row\[1\].g_col\[1\].pe__2406_/Y sky130_fd_sc_hd__o21ai_2
Xg_row\[0\].g_col\[1\].pe__1863_ g_row\[0\].g_col\[1\].pe__2177_/A1 g_row\[0\].g_col\[1\].pe__1457_/X
+ g_row\[0\].g_col\[1\].pe__1863_/B1 g_row\[0\].g_col\[1\].pe__2697_/Q VGND VGND VPWR
+ VPWR g_row\[0\].g_col\[1\].pe__1864_/B sky130_fd_sc_hd__a22o_2
Xg_row\[0\].g_col\[0\].pe__1847_ g_row\[0\].g_col\[0\].pe__1847_/A g_row\[0\].g_col\[0\].pe__1847_/B
+ VGND VGND VPWR VPWR g_row\[0\].g_col\[0\].pe__1888_/B sky130_fd_sc_hd__nor2_2
Xhold1469 hold3247/X VGND VGND VPWR VPWR hold3248/A sky130_fd_sc_hd__clkbuf_2
Xg_row\[0\].g_col\[0\].pe__1778_ g_row\[0\].g_col\[0\].pe__1778_/A g_row\[0\].g_col\[0\].pe__1816_/C
+ VGND VGND VPWR VPWR g_row\[0\].g_col\[0\].pe__1813_/B sky130_fd_sc_hd__xnor2_2
Xg_row\[1\].g_col\[1\].pe__2337_ g_row\[1\].g_col\[1\].pe__2337_/A g_row\[1\].g_col\[1\].pe__2337_/B
+ g_row\[1\].g_col\[1\].pe__2337_/C VGND VGND VPWR VPWR g_row\[1\].g_col\[1\].pe__2352_/A
+ sky130_fd_sc_hd__or3_2
Xg_row\[0\].g_col\[1\].pe__1794_ g_row\[0\].g_col\[1\].pe__1794_/A g_row\[0\].g_col\[1\].pe__1794_/B
+ VGND VGND VPWR VPWR g_row\[0\].g_col\[1\].pe__1795_/C sky130_fd_sc_hd__or2_4
Xg_row\[1\].g_col\[1\].pe__2268_ g_row\[1\].g_col\[1\].pe__2396_/A g_row\[1\].g_col\[1\].pe__2268_/B
+ VGND VGND VPWR VPWR g_row\[1\].g_col\[1\].pe__2748_/D sky130_fd_sc_hd__nor2_2
XFILLER_41_838 VGND VGND VPWR VPWR sky130_fd_sc_hd__fill_2
Xg_row\[1\].g_col\[1\].pe__2199_ g_row\[1\].g_col\[1\].pe__2396_/A g_row\[1\].g_col\[1\].pe__2199_/B
+ VGND VGND VPWR VPWR g_row\[1\].g_col\[1\].pe__2746_/D sky130_fd_sc_hd__nor2_2
Xg_row\[0\].g_col\[1\].pe__2415_ g_row\[0\].g_col\[1\].pe__2421_/A1 g_row\[0\].g_col\[1\].pe__2746_/Q
+ g_row\[0\].g_col\[1\].pe__2439_/B VGND VGND VPWR VPWR g_row\[0\].g_col\[1\].pe__2436_/B
+ sky130_fd_sc_hd__a21o_2
XTAP_TAPCELL_ROW_23_557 VGND VPWR sky130_fd_sc_hd__tapvpwrvgnd_1
Xinput1302 hold3544/X VGND VGND VPWR VPWR hold3545/A sky130_fd_sc_hd__buf_2
Xinput1346 hold3483/X VGND VGND VPWR VPWR hold3484/A sky130_fd_sc_hd__buf_2
Xinput1335 hold3252/X VGND VGND VPWR VPWR hold3253/A sky130_fd_sc_hd__buf_2
Xinput1324 hold3287/X VGND VGND VPWR VPWR hold3288/A sky130_fd_sc_hd__buf_2
Xinput1313 hold3413/X VGND VGND VPWR VPWR hold3414/A sky130_fd_sc_hd__buf_2
Xg_row\[0\].g_col\[1\].pe__2346_ g_row\[0\].g_col\[1\].pe__2346_/A g_row\[0\].g_col\[1\].pe__2346_/B
+ VGND VGND VPWR VPWR g_row\[0\].g_col\[1\].pe__2347_/B sky130_fd_sc_hd__nand2_2
XFILLER_4_205 VGND VGND VPWR VPWR sky130_fd_sc_hd__fill_1
Xg_row\[0\].g_col\[1\].pe__2277_ g_row\[0\].g_col\[1\].pe__2277_/A g_row\[0\].g_col\[1\].pe__2277_/B
+ VGND VGND VPWR VPWR g_row\[0\].g_col\[1\].pe__2285_/A sky130_fd_sc_hd__and2_2
Xg_row\[1\].g_col\[1\].pe_hold1945 g_row\[1\].g_col\[1\].pe__2624_/X VGND VGND VPWR
+ VPWR g_row\[1\].g_col\[1\].pe__2700_/D sky130_fd_sc_hd__clkbuf_2
Xhold3350 hold3350/A VGND VGND VPWR VPWR hold3350/X sky130_fd_sc_hd__clkbuf_2
Xhold3361 b_inputs_flat[1] VGND VGND VPWR VPWR hold3361/X sky130_fd_sc_hd__clkbuf_2
Xg_row\[1\].g_col\[1\].pe_hold1967 g_row\[1\].g_col\[1\].pe__2616_/X VGND VGND VPWR
+ VPWR g_row\[1\].g_col\[1\].pe__2617_/C1 sky130_fd_sc_hd__clkbuf_2
Xg_row\[1\].g_col\[1\].pe_hold1956 g_row\[1\].g_col\[1\].pe_hold3021/X VGND VGND VPWR
+ VPWR g_row\[1\].g_col\[1\].pe_hold3022/A sky130_fd_sc_hd__clkbuf_2
Xhold3372 hold3372/A VGND VGND VPWR VPWR hold3372/X sky130_fd_sc_hd__clkbuf_2
Xhold3383 hold3383/A VGND VGND VPWR VPWR hold3383/X sky130_fd_sc_hd__clkbuf_2
Xhold3394 hold3394/A VGND VGND VPWR VPWR hold3394/X sky130_fd_sc_hd__clkbuf_2
Xhold2660 hold3417/X VGND VGND VPWR VPWR hold3418/A sky130_fd_sc_hd__clkbuf_2
Xhold2671 hold2671/A VGND VGND VPWR VPWR _293_/D sky130_fd_sc_hd__clkbuf_2
Xhold2682 _181_/Y VGND VGND VPWR VPWR hold2682/X sky130_fd_sc_hd__clkbuf_2
XFILLER_29_673 VGND VGND VPWR VPWR sky130_fd_sc_hd__decap_3
XTAP_TAPCELL_ROW_3_260 VGND VPWR sky130_fd_sc_hd__tapvpwrvgnd_1
Xhold2693 hold3486/X VGND VGND VPWR VPWR _219_/B_N sky130_fd_sc_hd__clkbuf_2
XFILLER_17_835 VGND VGND VPWR VPWR sky130_fd_sc_hd__fill_1
XFILLER_44_643 VGND VGND VPWR VPWR sky130_fd_sc_hd__fill_1
XFILLER_45_62 VGND VGND VPWR VPWR sky130_fd_sc_hd__decap_3
XTAP_TAPCELL_ROW_42_833 VGND VPWR sky130_fd_sc_hd__tapvpwrvgnd_1
XTAP_TAPCELL_ROW_42_844 VGND VPWR sky130_fd_sc_hd__tapvpwrvgnd_1
XTAP_TAPCELL_ROW_65_1190 VGND VPWR sky130_fd_sc_hd__tapvpwrvgnd_1
XFILLER_12_584 VGND VGND VPWR VPWR sky130_fd_sc_hd__decap_3
XFILLER_12_595 VGND VGND VPWR VPWR sky130_fd_sc_hd__fill_1
XANTENNA_5 a_inputs_flat[14] VGND VGND VPWR VPWR sky130_fd_sc_hd__diode_2
Xg_row\[1\].g_col\[0\].pe__2741_ clkbuf_leaf_59_clk/X g_row\[1\].g_col\[0\].pe__2741_/D
+ VGND VGND VPWR VPWR g_row\[1\].g_col\[0\].pe__2741_/Q sky130_fd_sc_hd__dfxtp_2
XFILLER_6_89 VGND VGND VPWR VPWR sky130_fd_sc_hd__fill_2
Xg_row\[1\].g_col\[0\].pe__2672_ hold1884/X hold2069/A hold2082/A g_row\[1\].g_col\[0\].pe__2672_/D
+ VGND VGND VPWR VPWR g_row\[1\].g_col\[0\].pe__2672_/X sky130_fd_sc_hd__or4_2
XFILLER_4_772 VGND VGND VPWR VPWR sky130_fd_sc_hd__fill_1
Xg_row\[1\].g_col\[0\].pe__1623_ place1084/X g_row\[1\].g_col\[0\].pe__1982_/B g_row\[1\].g_col\[0\].pe__1424_/Y
+ place1085/X VGND VGND VPWR VPWR g_row\[1\].g_col\[0\].pe__1624_/B sky130_fd_sc_hd__a22o_2
Xg_row\[1\].g_col\[1\].pe__1570_ g_row\[1\].g_col\[1\].pe__1676_/A g_row\[1\].g_col\[1\].pe__1570_/B
+ VGND VGND VPWR VPWR g_row\[1\].g_col\[1\].pe__1571_/B sky130_fd_sc_hd__xnor2_2
Xg_row\[1\].g_col\[0\].pe_hold3047 g_row\[1\].g_col\[0\].pe_hold3047/A VGND VGND VPWR
+ VPWR g_row\[1\].g_col\[0\].pe__1399_/A1 sky130_fd_sc_hd__clkbuf_2
Xg_row\[1\].g_col\[0\].pe_hold3036 hold1889/X VGND VGND VPWR VPWR g_row\[1\].g_col\[0\].pe__2664_/A2
+ sky130_fd_sc_hd__clkbuf_2
Xg_row\[1\].g_col\[0\].pe_hold3025 g_row\[1\].g_col\[0\].pe__2658_/X VGND VGND VPWR
+ VPWR g_row\[1\].g_col\[0\].pe_hold3025/X sky130_fd_sc_hd__clkbuf_2
Xg_row\[1\].g_col\[0\].pe__1554_ g_row\[1\].g_col\[0\].pe__1554_/A g_row\[1\].g_col\[0\].pe__1554_/B
+ VGND VGND VPWR VPWR g_row\[1\].g_col\[0\].pe__1562_/A sky130_fd_sc_hd__and2_2
XFILLER_66_245 VGND VGND VPWR VPWR sky130_fd_sc_hd__decap_3
XFILLER_67_768 VGND VGND VPWR VPWR sky130_fd_sc_hd__decap_3
Xg_row\[0\].g_col\[0\].pe__2750_ _277_/CLK g_row\[0\].g_col\[0\].pe__2750_/D VGND
+ VGND VPWR VPWR ANTENNA_42/DIODE sky130_fd_sc_hd__dfxtp_2
Xg_row\[1\].g_col\[0\].pe__1485_ place1087/X g_row\[1\].g_col\[0\].pe__1729_/A2 g_row\[1\].g_col\[0\].pe__1729_/A3
+ g_row\[1\].g_col\[0\].pe__1729_/B1 place1085/X VGND VGND VPWR VPWR g_row\[1\].g_col\[0\].pe__1486_/B
+ sky130_fd_sc_hd__a32o_2
XTAP_TAPCELL_ROW_1_219 VGND VPWR sky130_fd_sc_hd__tapvpwrvgnd_1
Xg_row\[0\].g_col\[0\].pe__1701_ g_row\[0\].g_col\[0\].pe__1701_/A g_row\[0\].g_col\[0\].pe__1701_/B
+ VGND VGND VPWR VPWR g_row\[0\].g_col\[0\].pe__1827_/B sky130_fd_sc_hd__xnor2_2
Xg_row\[0\].g_col\[0\].pe__2681_ g_row\[0\].g_col\[0\].pe__2681_/A1 g_row\[0\].g_col\[0\].pe__2680_/B
+ g_row\[0\].g_col\[0\].pe__2680_/Y g_row\[0\].g_col\[0\].pe__2685_/C1 VGND VGND VPWR
+ VPWR g_row\[0\].g_col\[0\].pe__2681_/X sky130_fd_sc_hd__o211a_2
XFILLER_19_172 VGND VGND VPWR VPWR sky130_fd_sc_hd__decap_3
Xg_row\[0\].g_col\[0\].pe__1632_ g_row\[0\].g_col\[0\].pe__1883_/A g_row\[0\].g_col\[0\].pe__1883_/B
+ VGND VGND VPWR VPWR g_row\[0\].g_col\[0\].pe__1633_/B sky130_fd_sc_hd__xnor2_2
Xg_row\[1\].g_col\[0\].pe_hold1689 g_row\[1\].g_col\[0\].pe__2748_/Q VGND VGND VPWR
+ VPWR g_row\[1\].g_col\[0\].pe__2266_/A sky130_fd_sc_hd__clkbuf_2
Xg_row\[1\].g_col\[1\].pe__2122_ g_row\[1\].g_col\[1\].pe__1461_/A g_row\[1\].g_col\[1\].pe__1461_/B
+ g_row\[1\].g_col\[1\].pe__1922_/Y VGND VGND VPWR VPWR g_row\[1\].g_col\[1\].pe__2123_/C
+ sky130_fd_sc_hd__a21o_2
XFILLER_50_624 VGND VGND VPWR VPWR sky130_fd_sc_hd__decap_3
XTAP_TAPCELL_ROW_81_1419 VGND VPWR sky130_fd_sc_hd__tapvpwrvgnd_1
Xg_row\[0\].g_col\[0\].pe__1563_ g_row\[0\].g_col\[0\].pe__1846_/A g_row\[0\].g_col\[0\].pe__1563_/B
+ VGND VGND VPWR VPWR g_row\[0\].g_col\[0\].pe__1587_/A sky130_fd_sc_hd__or2_2
Xg_row\[1\].g_col\[0\].pe__2106_ g_row\[1\].g_col\[0\].pe__2106_/A g_row\[1\].g_col\[0\].pe__2105_/X
+ VGND VGND VPWR VPWR g_row\[1\].g_col\[0\].pe__2107_/B sky130_fd_sc_hd__nor2b_4
XFILLER_34_197 VGND VGND VPWR VPWR sky130_fd_sc_hd__decap_3
Xg_row\[0\].g_col\[0\].pe__1494_ place1213/X g_row\[0\].g_col\[0\].pe__1715_/B g_row\[0\].g_col\[0\].pe__1863_/B1
+ g_row\[0\].g_col\[0\].pe__1957_/B2 VGND VGND VPWR VPWR g_row\[0\].g_col\[0\].pe__1495_/B
+ sky130_fd_sc_hd__a22o_2
Xg_row\[1\].g_col\[1\].pe__2053_ g_row\[1\].g_col\[1\].pe__2052_/B g_row\[1\].g_col\[1\].pe__2052_/C
+ g_row\[1\].g_col\[1\].pe__2052_/A VGND VGND VPWR VPWR g_row\[1\].g_col\[1\].pe__2054_/B
+ sky130_fd_sc_hd__o21ai_2
Xg_row\[1\].g_col\[0\].pe__2037_ g_row\[1\].g_col\[0\].pe__2209_/A g_row\[1\].g_col\[0\].pe__2037_/B
+ VGND VGND VPWR VPWR g_row\[1\].g_col\[0\].pe__2038_/C sky130_fd_sc_hd__xnor2_2
XTAP_TAPCELL_ROW_20_505 VGND VPWR sky130_fd_sc_hd__tapvpwrvgnd_1
Xg_row\[0\].g_col\[1\].pe__2200_ g_row\[0\].g_col\[1\].pe__2200_/A g_row\[0\].g_col\[1\].pe__2200_/B
+ VGND VGND VPWR VPWR g_row\[0\].g_col\[1\].pe__2299_/A sky130_fd_sc_hd__or2_4
XTAP_TAPCELL_ROW_20_516 VGND VPWR sky130_fd_sc_hd__tapvpwrvgnd_1
Xg_row\[0\].g_col\[0\].pe__2115_ g_row\[0\].g_col\[0\].pe__2335_/A g_row\[0\].g_col\[0\].pe__2115_/B
+ VGND VGND VPWR VPWR g_row\[0\].g_col\[0\].pe__2744_/D sky130_fd_sc_hd__nor2_2
Xg_row\[0\].g_col\[1\].pe__2131_ g_row\[0\].g_col\[1\].pe__2209_/A g_row\[0\].g_col\[1\].pe__2131_/B
+ VGND VGND VPWR VPWR g_row\[0\].g_col\[1\].pe__2132_/B sky130_fd_sc_hd__xnor2_2
Xplace1210 place1210/A VGND VGND VPWR VPWR place1210/X sky130_fd_sc_hd__buf_6
Xg_row\[0\].g_col\[1\].pe__2062_ g_row\[0\].g_col\[1\].pe__2062_/A g_row\[0\].g_col\[1\].pe__2150_/C
+ g_row\[0\].g_col\[1\].pe__2062_/C VGND VGND VPWR VPWR g_row\[0\].g_col\[1\].pe__2062_/X
+ sky130_fd_sc_hd__or3_2
Xg_row\[0\].g_col\[0\].pe__2046_ g_row\[0\].g_col\[0\].pe__2094_/B g_row\[0\].g_col\[0\].pe__1988_/B
+ g_row\[0\].g_col\[0\].pe__1988_/C g_row\[0\].g_col\[0\].pe__2045_/X VGND VGND VPWR
+ VPWR g_row\[0\].g_col\[0\].pe__2047_/B sky130_fd_sc_hd__a31o_2
Xplace1221 place1222/X VGND VGND VPWR VPWR place1221/X sky130_fd_sc_hd__buf_6
Xg_row\[1\].g_col\[1\].pe__1906_ g_row\[1\].g_col\[1\].pe__1964_/A g_row\[1\].g_col\[1\].pe__1906_/B
+ VGND VGND VPWR VPWR g_row\[1\].g_col\[1\].pe__1907_/B sky130_fd_sc_hd__and2_2
Xplace1265 _235_/A VGND VGND VPWR VPWR _237_/A sky130_fd_sc_hd__buf_6
Xplace1276 hold1641/X VGND VGND VPWR VPWR _205_/A sky130_fd_sc_hd__buf_6
XFILLER_89_348 VGND VGND VPWR VPWR sky130_fd_sc_hd__fill_1
XFILLER_58_724 VGND VGND VPWR VPWR sky130_fd_sc_hd__decap_3
Xg_row\[1\].g_col\[1\].pe__1768_ g_row\[1\].g_col\[1\].pe__2728_/Q g_row\[1\].g_col\[1\].pe__1768_/B
+ VGND VGND VPWR VPWR g_row\[1\].g_col\[1\].pe__1781_/B sky130_fd_sc_hd__xnor2_2
XFILLER_58_757 VGND VGND VPWR VPWR sky130_fd_sc_hd__decap_3
Xg_row\[1\].g_col\[1\].pe__1699_ g_row\[1\].g_col\[1\].pe__1698_/A g_row\[1\].g_col\[1\].pe__1699_/B
+ VGND VGND VPWR VPWR g_row\[1\].g_col\[1\].pe__1699_/X sky130_fd_sc_hd__and2b_2
XFILLER_73_716 VGND VGND VPWR VPWR sky130_fd_sc_hd__fill_1
XFILLER_85_587 VGND VGND VPWR VPWR sky130_fd_sc_hd__decap_3
Xg_row\[1\].g_col\[0\].pe_hold2880 g_row\[1\].g_col\[0\].pe__2721_/Q VGND VGND VPWR
+ VPWR g_row\[1\].g_col\[0\].pe_hold2880/X sky130_fd_sc_hd__clkbuf_2
Xg_row\[0\].g_col\[1\].pe__1915_ g_row\[0\].g_col\[1\].pe__2209_/A g_row\[0\].g_col\[1\].pe__1915_/B
+ VGND VGND VPWR VPWR g_row\[0\].g_col\[1\].pe__1916_/B sky130_fd_sc_hd__xnor2_2
XFILLER_38_470 VGND VGND VPWR VPWR sky130_fd_sc_hd__fill_1
XTAP_TAPCELL_ROW_28_627 VGND VPWR sky130_fd_sc_hd__tapvpwrvgnd_1
Xg_row\[0\].g_col\[1\].pe__1846_ g_row\[0\].g_col\[1\].pe__1846_/A VGND VGND VPWR
+ VPWR g_row\[0\].g_col\[1\].pe__1847_/A sky130_fd_sc_hd__inv_2
Xg_row\[0\].g_col\[1\].pe__1777_ g_row\[0\].g_col\[1\].pe__1777_/A g_row\[0\].g_col\[1\].pe__1777_/B
+ VGND VGND VPWR VPWR g_row\[0\].g_col\[1\].pe__1816_/C sky130_fd_sc_hd__xor2_2
XFILLER_25_175 VGND VGND VPWR VPWR sky130_fd_sc_hd__fill_1
XFILLER_81_782 VGND VGND VPWR VPWR sky130_fd_sc_hd__fill_2
XFILLER_25_197 VGND VGND VPWR VPWR sky130_fd_sc_hd__decap_3
XFILLER_15_98 VGND VGND VPWR VPWR sky130_fd_sc_hd__fill_1
XFILLER_5_503 VGND VGND VPWR VPWR sky130_fd_sc_hd__fill_1
Xg_row\[0\].g_col\[1\].pe__2329_ g_row\[0\].g_col\[1\].pe__2329_/A g_row\[0\].g_col\[1\].pe__2329_/B
+ VGND VGND VPWR VPWR g_row\[0\].g_col\[1\].pe__2329_/Y sky130_fd_sc_hd__xnor2_2
XTAP_TAPCELL_ROW_8_330 VGND VPWR sky130_fd_sc_hd__tapvpwrvgnd_1
Xg_row\[1\].g_col\[1\].pe_hold1742 g_row\[1\].g_col\[1\].pe__2591_/X VGND VGND VPWR
+ VPWR g_row\[1\].g_col\[1\].pe__2592_/B sky130_fd_sc_hd__clkbuf_2
XFILLER_49_746 VGND VGND VPWR VPWR sky130_fd_sc_hd__fill_1
Xhold3180 hold3180/A VGND VGND VPWR VPWR hold3180/X sky130_fd_sc_hd__clkbuf_2
Xhold3191 hold3191/A VGND VGND VPWR VPWR hold3191/X sky130_fd_sc_hd__clkbuf_2
XFILLER_48_256 VGND VGND VPWR VPWR sky130_fd_sc_hd__decap_3
XTAP_TAPCELL_ROW_47_914 VGND VPWR sky130_fd_sc_hd__tapvpwrvgnd_1
Xhold2490 _255_/Y VGND VGND VPWR VPWR hold2490/X sky130_fd_sc_hd__clkbuf_2
XFILLER_16_120 VGND VGND VPWR VPWR sky130_fd_sc_hd__fill_1
XFILLER_16_164 VGND VGND VPWR VPWR sky130_fd_sc_hd__decap_3
XFILLER_17_698 VGND VGND VPWR VPWR sky130_fd_sc_hd__decap_3
XFILLER_72_782 VGND VGND VPWR VPWR sky130_fd_sc_hd__decap_3
Xg_row\[0\].g_col\[0\].pe_hold2912 g_row\[0\].g_col\[0\].pe__2608_/X VGND VGND VPWR
+ VPWR g_row\[0\].g_col\[0\].pe_hold2912/X sky130_fd_sc_hd__clkbuf_2
XFILLER_16_197 VGND VGND VPWR VPWR sky130_fd_sc_hd__fill_2
XFILLER_71_281 VGND VGND VPWR VPWR sky130_fd_sc_hd__fill_1
XTAP_TAPCELL_ROW_63_1149 VGND VPWR sky130_fd_sc_hd__tapvpwrvgnd_1
Xg_row\[0\].g_col\[0\].pe_hold2923 _291_/Q VGND VGND VPWR VPWR g_row\[0\].g_col\[0\].pe_hold2923/X
+ sky130_fd_sc_hd__clkbuf_2
Xg_row\[0\].g_col\[0\].pe_hold2934 _286_/Q VGND VGND VPWR VPWR g_row\[0\].g_col\[0\].pe_hold2934/X
+ sky130_fd_sc_hd__clkbuf_2
Xg_row\[0\].g_col\[0\].pe_hold2945 g_row\[0\].g_col\[0\].pe_hold2945/A VGND VGND VPWR
+ VPWR g_row\[0\].g_col\[0\].pe__2721_/D sky130_fd_sc_hd__clkbuf_2
XFILLER_31_145 VGND VGND VPWR VPWR sky130_fd_sc_hd__fill_2
XFILLER_72_82 VGND VGND VPWR VPWR sky130_fd_sc_hd__fill_2
Xg_row\[0\].g_col\[0\].pe_hold2956 g_row\[0\].g_col\[0\].pe__1395_/X VGND VGND VPWR
+ VPWR g_row\[0\].g_col\[0\].pe_hold2956/X sky130_fd_sc_hd__clkbuf_2
XTAP_TAPCELL_ROW_78_1381 VGND VPWR sky130_fd_sc_hd__tapvpwrvgnd_1
Xg_row\[1\].g_col\[1\].pe__2740_ clkbuf_leaf_72_clk/X g_row\[1\].g_col\[1\].pe__2740_/D
+ VGND VGND VPWR VPWR g_row\[1\].g_col\[1\].pe__2740_/Q sky130_fd_sc_hd__dfxtp_2
Xg_row\[1\].g_col\[0\].pe__2724_ clkbuf_leaf_43_clk/X g_row\[1\].g_col\[0\].pe__2724_/D
+ VGND VGND VPWR VPWR g_row\[1\].g_col\[0\].pe__2724_/Q sky130_fd_sc_hd__dfxtp_2
Xg_row\[1\].g_col\[1\].pe__2671_ hold2099/A hold3114/A hold3115/A hold2090/A VGND
+ VGND VPWR VPWR g_row\[1\].g_col\[1\].pe__2672_/D sky130_fd_sc_hd__or4_2
Xg_row\[1\].g_col\[1\].pe__1622_ g_row\[1\].g_col\[1\].pe__1622_/A g_row\[1\].g_col\[1\].pe__1875_/C
+ VGND VGND VPWR VPWR g_row\[1\].g_col\[1\].pe__1625_/A sky130_fd_sc_hd__xnor2_2
Xg_row\[1\].g_col\[0\].pe__2655_ g_row\[1\].g_col\[0\].pe__2676_/A g_row\[1\].g_col\[0\].pe__2655_/B
+ VGND VGND VPWR VPWR g_row\[1\].g_col\[0\].pe__2655_/X sky130_fd_sc_hd__or2_2
XTAP_TAPCELL_ROW_91_1570 VGND VPWR sky130_fd_sc_hd__tapvpwrvgnd_1
XTAP_TAPCELL_ROW_91_1581 VGND VPWR sky130_fd_sc_hd__tapvpwrvgnd_1
Xg_row\[1\].g_col\[0\].pe__2586_ g_row\[1\].g_col\[0\].pe__2590_/A g_row\[1\].g_col\[0\].pe__2586_/B
+ g_row\[1\].g_col\[0\].pe__2586_/C VGND VGND VPWR VPWR g_row\[1\].g_col\[0\].pe__2586_/X
+ sky130_fd_sc_hd__or3_2
Xg_row\[1\].g_col\[0\].pe__1606_ g_row\[1\].g_col\[0\].pe__1606_/A g_row\[1\].g_col\[0\].pe__1848_/B
+ VGND VGND VPWR VPWR g_row\[1\].g_col\[0\].pe__1849_/B sky130_fd_sc_hd__xnor2_2
Xg_row\[1\].g_col\[1\].pe__1553_ g_row\[1\].g_col\[1\].pe__2736_/Q g_row\[1\].g_col\[1\].pe__1535_/B
+ g_row\[1\].g_col\[1\].pe__1546_/B g_row\[1\].g_col\[1\].pe__1552_/X VGND VGND VPWR
+ VPWR g_row\[1\].g_col\[1\].pe__1591_/A sky130_fd_sc_hd__a31oi_2
Xg_row\[1\].g_col\[0\].pe__1537_ g_row\[1\].g_col\[0\].pe__1499_/A g_row\[1\].g_col\[0\].pe__1499_/B
+ g_row\[1\].g_col\[0\].pe__1536_/X VGND VGND VPWR VPWR g_row\[1\].g_col\[0\].pe__1545_/A
+ sky130_fd_sc_hd__a21oi_2
Xg_row\[0\].g_col\[0\].pe__2733_ clkbuf_leaf_39_clk/X g_row\[0\].g_col\[0\].pe__2733_/D
+ VGND VGND VPWR VPWR g_row\[0\].g_col\[0\].pe__2733_/Q sky130_fd_sc_hd__dfxtp_2
Xg_row\[1\].g_col\[1\].pe__1484_ g_row\[1\].g_col\[1\].pe__1728_/A g_row\[1\].g_col\[1\].pe__1484_/B
+ VGND VGND VPWR VPWR g_row\[1\].g_col\[1\].pe__1514_/A sky130_fd_sc_hd__xnor2_2
Xg_row\[0\].g_col\[1\].pe__1700_ g_row\[0\].g_col\[1\].pe__1823_/A g_row\[0\].g_col\[1\].pe__1823_/B
+ g_row\[0\].g_col\[1\].pe__1699_/X VGND VGND VPWR VPWR g_row\[0\].g_col\[1\].pe__1827_/A
+ sky130_fd_sc_hd__a21oi_2
Xg_row\[0\].g_col\[1\].pe__2680_ g_row\[0\].g_col\[1\].pe__2680_/A g_row\[0\].g_col\[1\].pe__2680_/B
+ VGND VGND VPWR VPWR g_row\[0\].g_col\[1\].pe__2680_/Y sky130_fd_sc_hd__nand2_2
XFILLER_54_248 VGND VGND VPWR VPWR sky130_fd_sc_hd__decap_3
XFILLER_54_259 VGND VGND VPWR VPWR sky130_fd_sc_hd__decap_3
XFILLER_82_568 VGND VGND VPWR VPWR sky130_fd_sc_hd__decap_3
Xg_row\[0\].g_col\[0\].pe__2664_ g_row\[0\].g_col\[0\].pe__2670_/A1 g_row\[0\].g_col\[0\].pe__2664_/A2
+ g_row\[0\].g_col\[0\].pe__2555_/A g_row\[0\].g_col\[0\].pe__2663_/X VGND VGND VPWR
+ VPWR g_row\[0\].g_col\[0\].pe__2664_/X sky130_fd_sc_hd__o211a_2
Xg_row\[0\].g_col\[1\].pe__1631_ g_row\[0\].g_col\[1\].pe__1583_/A g_row\[0\].g_col\[1\].pe__1583_/B
+ g_row\[0\].g_col\[1\].pe__1630_/X VGND VGND VPWR VPWR g_row\[0\].g_col\[1\].pe__1883_/B
+ sky130_fd_sc_hd__a21oi_2
Xg_row\[1\].g_col\[0\].pe__1399_ g_row\[1\].g_col\[0\].pe__1399_/A1 g_row\[1\].g_col\[0\].pe__2679_/A2
+ g_row\[1\].g_col\[0\].pe__1398_/X g_row\[1\].g_col\[0\].pe__1403_/C1 VGND VGND VPWR
+ VPWR g_row\[1\].g_col\[0\].pe__1399_/X sky130_fd_sc_hd__o211a_2
XFILLER_23_613 VGND VGND VPWR VPWR sky130_fd_sc_hd__decap_3
Xg_row\[0\].g_col\[0\].pe__1615_ g_row\[0\].g_col\[0\].pe__1615_/A g_row\[0\].g_col\[0\].pe__1615_/B
+ VGND VGND VPWR VPWR g_row\[0\].g_col\[0\].pe__1629_/A sky130_fd_sc_hd__xor2_2
Xg_row\[0\].g_col\[0\].pe__2595_ g_row\[0\].g_col\[0\].pe__2595_/A g_row\[0\].g_col\[0\].pe__2595_/B
+ VGND VGND VPWR VPWR g_row\[0\].g_col\[0\].pe__2771_/D sky130_fd_sc_hd__and2_2
XFILLER_23_646 VGND VGND VPWR VPWR sky130_fd_sc_hd__decap_3
XFILLER_50_421 VGND VGND VPWR VPWR sky130_fd_sc_hd__decap_3
Xg_row\[0\].g_col\[0\].pe__1546_ g_row\[0\].g_col\[0\].pe__1546_/A g_row\[0\].g_col\[0\].pe__1546_/B
+ VGND VGND VPWR VPWR g_row\[0\].g_col\[0\].pe__1547_/B sky130_fd_sc_hd__xnor2_2
Xg_row\[0\].g_col\[1\].pe__1562_ g_row\[0\].g_col\[1\].pe__1562_/A g_row\[0\].g_col\[1\].pe__1562_/B
+ g_row\[0\].g_col\[1\].pe__1562_/C VGND VGND VPWR VPWR g_row\[0\].g_col\[1\].pe__1563_/B
+ sky130_fd_sc_hd__nor3_2
Xg_row\[1\].g_col\[1\].pe__2105_ g_row\[1\].g_col\[1\].pe__2104_/A g_row\[1\].g_col\[1\].pe__2104_/B
+ g_row\[1\].g_col\[1\].pe__2104_/C VGND VGND VPWR VPWR g_row\[1\].g_col\[1\].pe__2105_/X
+ sky130_fd_sc_hd__a21o_2
XFILLER_22_167 VGND VGND VPWR VPWR sky130_fd_sc_hd__decap_3
Xg_row\[0\].g_col\[1\].pe__1493_ g_row\[0\].g_col\[1\].pe__1862_/A g_row\[0\].g_col\[1\].pe__1493_/B
+ VGND VGND VPWR VPWR g_row\[0\].g_col\[1\].pe__1536_/A sky130_fd_sc_hd__xor2_2
Xg_row\[1\].g_col\[1\].pe__2036_ g_row\[1\].g_col\[1\].pe__2241_/B2 g_row\[1\].g_col\[1\].pe__1471_/X
+ g_row\[1\].g_col\[1\].pe__2247_/B1 g_row\[1\].g_col\[1\].pe__2036_/B2 VGND VGND
+ VPWR VPWR g_row\[1\].g_col\[1\].pe__2037_/B sky130_fd_sc_hd__a22o_2
Xg_row\[0\].g_col\[0\].pe__1477_ g_row\[0\].g_col\[0\].pe__1676_/A g_row\[0\].g_col\[0\].pe__1477_/B
+ VGND VGND VPWR VPWR g_row\[0\].g_col\[0\].pe__1478_/B sky130_fd_sc_hd__xnor2_2
Xg_row\[0\].g_col\[1\].pe__2114_ g_row\[0\].g_col\[1\].pe__2406_/B1 g_row\[0\].g_col\[1\].pe__2114_/A2
+ g_row\[0\].g_col\[1\].pe__2112_/Y g_row\[0\].g_col\[1\].pe__2113_/X VGND VGND VPWR
+ VPWR g_row\[0\].g_col\[1\].pe__2114_/X sky130_fd_sc_hd__o22a_2
Xg_row\[0\].g_col\[0\].pe__2029_ g_row\[0\].g_col\[0\].pe__2028_/B g_row\[0\].g_col\[0\].pe__2028_/C
+ g_row\[0\].g_col\[0\].pe__2167_/A VGND VGND VPWR VPWR g_row\[0\].g_col\[0\].pe__2034_/B
+ sky130_fd_sc_hd__a21bo_2
Xg_row\[0\].g_col\[1\].pe__2045_ g_row\[0\].g_col\[1\].pe__2045_/A g_row\[0\].g_col\[1\].pe__2045_/B
+ VGND VGND VPWR VPWR g_row\[0\].g_col\[1\].pe__2045_/X sky130_fd_sc_hd__and2_2
Xplace1084 hold1938/A VGND VGND VPWR VPWR place1084/X sky130_fd_sc_hd__buf_6
XFILLER_73_502 VGND VGND VPWR VPWR sky130_fd_sc_hd__fill_2
XFILLER_46_738 VGND VGND VPWR VPWR sky130_fd_sc_hd__fill_1
XFILLER_61_708 VGND VGND VPWR VPWR sky130_fd_sc_hd__fill_2
XFILLER_73_557 VGND VGND VPWR VPWR sky130_fd_sc_hd__decap_3
Xg_row\[0\].g_col\[1\].pe__1829_ g_row\[0\].g_col\[1\].pe__1821_/X g_row\[0\].g_col\[1\].pe__1822_/X
+ g_row\[0\].g_col\[1\].pe__1826_/Y g_row\[0\].g_col\[1\].pe__1827_/Y g_row\[0\].g_col\[1\].pe__1828_/Y
+ VGND VGND VPWR VPWR g_row\[0\].g_col\[1\].pe__1829_/Y sky130_fd_sc_hd__o311ai_2
XFILLER_14_657 VGND VGND VPWR VPWR sky130_fd_sc_hd__fill_1
XFILLER_53_281 VGND VGND VPWR VPWR sky130_fd_sc_hd__decap_3
XFILLER_9_149 VGND VGND VPWR VPWR sky130_fd_sc_hd__decap_3
XTAP_TAPCELL_ROW_52_983 VGND VPWR sky130_fd_sc_hd__tapvpwrvgnd_1
XTAP_TAPCELL_ROW_52_994 VGND VPWR sky130_fd_sc_hd__tapvpwrvgnd_1
X_293_ _294_/CLK _293_/D VGND VGND VPWR VPWR _293_/Q sky130_fd_sc_hd__dfxtp_2
XFILLER_10_841 VGND VGND VPWR VPWR sky130_fd_sc_hd__fill_1
XFILLER_6_801 VGND VGND VPWR VPWR sky130_fd_sc_hd__decap_3
XTAP_TAPCELL_ROW_11_368 VGND VPWR sky130_fd_sc_hd__tapvpwrvgnd_1
XTAP_TAPCELL_ROW_11_379 VGND VPWR sky130_fd_sc_hd__tapvpwrvgnd_1
XPHY_EDGE_ROW_39_Left_133 VGND VGND VPWR VPWR sky130_fd_sc_hd__decap_3
Xg_row\[1\].g_col\[1\].pe_hold2262 g_row\[1\].g_col\[1\].pe_hold3120/X VGND VGND VPWR
+ VPWR g_row\[1\].g_col\[1\].pe__2641_/B sky130_fd_sc_hd__clkbuf_2
Xg_row\[1\].g_col\[1\].pe_hold2251 g_row\[1\].g_col\[1\].pe__2709_/Q VGND VGND VPWR
+ VPWR g_row\[1\].g_col\[1\].pe__2647_/B sky130_fd_sc_hd__clkbuf_2
Xg_row\[1\].g_col\[0\].pe__2440_ g_row\[1\].g_col\[0\].pe__2763_/Q g_row\[1\].g_col\[0\].pe__2439_/Y
+ VGND VGND VPWR VPWR g_row\[1\].g_col\[0\].pe__2495_/A sky130_fd_sc_hd__or2b_2
XFILLER_49_532 VGND VGND VPWR VPWR sky130_fd_sc_hd__fill_2
XFILLER_77_841 VGND VGND VPWR VPWR sky130_fd_sc_hd__fill_1
XFILLER_76_351 VGND VGND VPWR VPWR sky130_fd_sc_hd__fill_2
Xg_row\[1\].g_col\[0\].pe__2371_ g_row\[1\].g_col\[0\].pe__2347_/A g_row\[1\].g_col\[0\].pe__2346_/B
+ g_row\[1\].g_col\[0\].pe__2346_/A VGND VGND VPWR VPWR g_row\[1\].g_col\[0\].pe__2386_/A
+ sky130_fd_sc_hd__a21boi_2
XFILLER_64_513 VGND VGND VPWR VPWR sky130_fd_sc_hd__decap_3
XPHY_EDGE_ROW_48_Left_142 VGND VGND VPWR VPWR sky130_fd_sc_hd__decap_3
XFILLER_64_579 VGND VGND VPWR VPWR sky130_fd_sc_hd__decap_3
XFILLER_32_421 VGND VGND VPWR VPWR sky130_fd_sc_hd__fill_2
Xg_row\[0\].g_col\[0\].pe__1400_ g_row\[0\].g_col\[0\].pe__2672_/A g_row\[0\].g_col\[0\].pe__1402_/B
+ VGND VGND VPWR VPWR g_row\[0\].g_col\[0\].pe__1400_/X sky130_fd_sc_hd__or2_2
Xg_row\[0\].g_col\[0\].pe__2380_ g_row\[0\].g_col\[0\].pe__2376_/X g_row\[0\].g_col\[0\].pe__2378_/X
+ g_row\[0\].g_col\[0\].pe__2379_/Y g_row\[0\].g_col\[0\].pe__2380_/B1 g_row\[0\].g_col\[0\].pe__1950_/A
+ VGND VGND VPWR VPWR g_row\[0\].g_col\[0\].pe__2380_/X sky130_fd_sc_hd__a32o_2
XFILLER_32_454 VGND VGND VPWR VPWR sky130_fd_sc_hd__fill_2
XFILLER_20_627 VGND VGND VPWR VPWR sky130_fd_sc_hd__fill_2
XFILLER_32_498 VGND VGND VPWR VPWR sky130_fd_sc_hd__decap_3
XTAP_TAPCELL_ROW_30_655 VGND VPWR sky130_fd_sc_hd__tapvpwrvgnd_1
XPHY_EDGE_ROW_57_Left_151 VGND VGND VPWR VPWR sky130_fd_sc_hd__decap_3
XTAP_TAPCELL_ROW_30_666 VGND VPWR sky130_fd_sc_hd__tapvpwrvgnd_1
XFILLER_8_182 VGND VGND VPWR VPWR sky130_fd_sc_hd__fill_1
XTAP_TAPCELL_ROW_93_1610 VGND VPWR sky130_fd_sc_hd__tapvpwrvgnd_1
XTAP_TAPCELL_ROW_93_1621 VGND VPWR sky130_fd_sc_hd__tapvpwrvgnd_1
Xg_row\[1\].g_col\[1\].pe__2723_ clkload14/A g_row\[1\].g_col\[1\].pe__2723_/D VGND
+ VGND VPWR VPWR g_row\[1\].g_col\[1\].pe__2723_/Q sky130_fd_sc_hd__dfxtp_2
Xg_row\[1\].g_col\[0\].pe__2707_ clkbuf_leaf_36_clk/X g_row\[1\].g_col\[0\].pe__2707_/D
+ VGND VGND VPWR VPWR g_row\[1\].g_col\[0\].pe__2707_/Q sky130_fd_sc_hd__dfxtp_2
XFILLER_86_104 VGND VGND VPWR VPWR sky130_fd_sc_hd__fill_1
XFILLER_87_627 VGND VGND VPWR VPWR sky130_fd_sc_hd__decap_3
Xg_row\[1\].g_col\[1\].pe__2654_ g_row\[1\].g_col\[1\].pe__2670_/A1 hold2176/X g_row\[1\].g_col\[1\].pe__2687_/C1
+ g_row\[1\].g_col\[1\].pe__2654_/C1 VGND VGND VPWR VPWR g_row\[1\].g_col\[1\].pe__2654_/X
+ sky130_fd_sc_hd__o211a_2
Xg_row\[1\].g_col\[0\].pe__2638_ g_row\[1\].g_col\[0\].pe__2635_/X g_row\[1\].g_col\[0\].pe__2636_/X
+ g_row\[1\].g_col\[0\].pe__2637_/X g_row\[1\].g_col\[0\].pe__2638_/B1 VGND VGND VPWR
+ VPWR g_row\[1\].g_col\[0\].pe__2638_/X sky130_fd_sc_hd__o31a_2
XFILLER_87_649 VGND VGND VPWR VPWR sky130_fd_sc_hd__fill_2
Xg_row\[1\].g_col\[1\].pe__2585_ g_row\[1\].g_col\[1\].pe__2585_/A g_row\[1\].g_col\[1\].pe__2585_/B
+ VGND VGND VPWR VPWR g_row\[1\].g_col\[1\].pe__2586_/C sky130_fd_sc_hd__and2_2
Xg_row\[1\].g_col\[1\].pe__1605_ g_row\[1\].g_col\[1\].pe__1860_/A g_row\[1\].g_col\[1\].pe__1605_/B
+ VGND VGND VPWR VPWR g_row\[1\].g_col\[1\].pe__1848_/B sky130_fd_sc_hd__and2_2
XPHY_EDGE_ROW_66_Left_160 VGND VGND VPWR VPWR sky130_fd_sc_hd__decap_3
Xg_row\[1\].g_col\[1\].pe__1536_ g_row\[1\].g_col\[1\].pe__1536_/A g_row\[1\].g_col\[1\].pe__1536_/B
+ VGND VGND VPWR VPWR g_row\[1\].g_col\[1\].pe__1536_/X sky130_fd_sc_hd__and2_2
Xg_row\[1\].g_col\[0\].pe__2569_ g_row\[1\].g_col\[0\].pe__2595_/A g_row\[1\].g_col\[0\].pe__2569_/B
+ VGND VGND VPWR VPWR g_row\[1\].g_col\[0\].pe__2765_/D sky130_fd_sc_hd__and2_2
Xg_row\[0\].g_col\[1\].pe_hold3006 g_row\[0\].g_col\[1\].pe_hold3006/A VGND VGND VPWR
+ VPWR g_row\[0\].g_col\[1\].pe__1403_/A1 sky130_fd_sc_hd__clkbuf_2
Xg_row\[0\].g_col\[1\].pe_hold2327 g_row\[0\].g_col\[1\].pe__2158_/X VGND VGND VPWR
+ VPWR g_row\[0\].g_col\[1\].pe__2159_/B sky130_fd_sc_hd__clkbuf_2
Xg_row\[0\].g_col\[1\].pe__2732_ clkbuf_leaf_94_clk/X g_row\[0\].g_col\[1\].pe__2732_/D
+ VGND VGND VPWR VPWR g_row\[0\].g_col\[1\].pe__2732_/Q sky130_fd_sc_hd__dfxtp_2
XFILLER_55_557 VGND VGND VPWR VPWR sky130_fd_sc_hd__decap_3
Xg_row\[0\].g_col\[0\].pe__2716_ _319_/CLK g_row\[0\].g_col\[0\].pe__2716_/D VGND
+ VGND VPWR VPWR hold3008/A sky130_fd_sc_hd__dfxtp_2
Xg_row\[0\].g_col\[1\].pe_hold2349 g_row\[0\].g_col\[1\].pe__2693_/Q VGND VGND VPWR
+ VPWR g_row\[0\].g_col\[1\].pe__2607_/B sky130_fd_sc_hd__clkbuf_2
Xg_row\[0\].g_col\[1\].pe_hold2338 g_row\[0\].g_col\[1\].pe__2640_/X VGND VGND VPWR
+ VPWR g_row\[0\].g_col\[1\].pe__2705_/D sky130_fd_sc_hd__clkbuf_2
XFILLER_82_365 VGND VGND VPWR VPWR sky130_fd_sc_hd__fill_1
XFILLER_82_376 VGND VGND VPWR VPWR sky130_fd_sc_hd__fill_2
XFILLER_82_387 VGND VGND VPWR VPWR sky130_fd_sc_hd__fill_1
XTAP_TAPCELL_ROW_38_777 VGND VPWR sky130_fd_sc_hd__tapvpwrvgnd_1
Xg_row\[0\].g_col\[0\].pe__2647_ place1263/X hold2043/X VGND VGND VPWR VPWR g_row\[0\].g_col\[0\].pe__2647_/X
+ sky130_fd_sc_hd__or2_2
Xg_row\[1\].g_col\[1\].pe__1398_ hold1976/X g_row\[1\].g_col\[1\].pe__1398_/B VGND
+ VGND VPWR VPWR g_row\[1\].g_col\[1\].pe__1398_/X sky130_fd_sc_hd__or2_2
Xg_row\[0\].g_col\[1\].pe__2663_ g_row\[0\].g_col\[1\].pe__2663_/A hold2084/X VGND
+ VGND VPWR VPWR g_row\[0\].g_col\[1\].pe__2663_/X sky130_fd_sc_hd__or2_2
XFILLER_35_281 VGND VGND VPWR VPWR sky130_fd_sc_hd__decap_3
Xg_row\[0\].g_col\[1\].pe__1614_ g_row\[0\].g_col\[1\].pe__2348_/A g_row\[0\].g_col\[1\].pe__1614_/B
+ VGND VGND VPWR VPWR g_row\[0\].g_col\[1\].pe__1615_/B sky130_fd_sc_hd__xnor2_2
Xg_row\[0\].g_col\[1\].pe__2594_ g_row\[0\].g_col\[1\].pe__2403_/A g_row\[0\].g_col\[1\].pe__2157_/A
+ g_row\[0\].g_col\[1\].pe__2516_/X g_row\[0\].g_col\[1\].pe__2406_/Y g_row\[0\].g_col\[1\].pe__1348_/A
+ VGND VGND VPWR VPWR g_row\[0\].g_col\[1\].pe__2594_/X sky130_fd_sc_hd__a32o_2
XFILLER_51_763 VGND VGND VPWR VPWR sky130_fd_sc_hd__fill_1
Xg_row\[0\].g_col\[1\].pe__1545_ g_row\[0\].g_col\[1\].pe__1545_/A g_row\[0\].g_col\[1\].pe__1552_/B
+ VGND VGND VPWR VPWR g_row\[0\].g_col\[1\].pe__1546_/B sky130_fd_sc_hd__xnor2_2
XFILLER_51_785 VGND VGND VPWR VPWR sky130_fd_sc_hd__fill_2
Xg_row\[0\].g_col\[0\].pe__1529_ g_row\[0\].g_col\[0\].pe__1554_/A g_row\[0\].g_col\[0\].pe__1554_/B
+ VGND VGND VPWR VPWR g_row\[0\].g_col\[0\].pe__1555_/A sky130_fd_sc_hd__xor2_2
Xg_row\[0\].g_col\[1\].pe__1476_ g_row\[0\].g_col\[1\].pe__2603_/B g_row\[0\].g_col\[1\].pe__1657_/B
+ g_row\[0\].g_col\[1\].pe__2247_/B1 g_row\[0\].g_col\[1\].pe__2599_/B VGND VGND VPWR
+ VPWR g_row\[0\].g_col\[1\].pe__1477_/B sky130_fd_sc_hd__a22o_2
Xg_row\[1\].g_col\[1\].pe__2019_ g_row\[1\].g_col\[1\].pe__2073_/B2 g_row\[1\].g_col\[1\].pe__2177_/A2
+ g_row\[1\].g_col\[1\].pe__2177_/B1 g_row\[1\].g_col\[1\].pe__2019_/B2 VGND VGND
+ VPWR VPWR g_row\[1\].g_col\[1\].pe__2071_/A sky130_fd_sc_hd__a22o_2
XFILLER_12_33 VGND VGND VPWR VPWR sky130_fd_sc_hd__fill_2
XFILLER_3_826 VGND VGND VPWR VPWR sky130_fd_sc_hd__fill_1
Xg_row\[0\].g_col\[1\].pe__2028_ g_row\[0\].g_col\[1\].pe__1459_/C g_row\[0\].g_col\[1\].pe__2028_/B
+ g_row\[0\].g_col\[1\].pe__2028_/C VGND VGND VPWR VPWR g_row\[0\].g_col\[1\].pe__2034_/A
+ sky130_fd_sc_hd__nand3b_2
XFILLER_59_841 VGND VGND VPWR VPWR sky130_fd_sc_hd__fill_1
XFILLER_46_513 VGND VGND VPWR VPWR sky130_fd_sc_hd__decap_3
Xg_row\[0\].g_col\[0\].pe_hold2005 g_row\[0\].g_col\[0\].pe_hold2963/X VGND VGND VPWR
+ VPWR g_row\[0\].g_col\[0\].pe__1394_/A sky130_fd_sc_hd__clkbuf_2
Xg_row\[0\].g_col\[0\].pe_hold2016 g_row\[0\].g_col\[0\].pe_hold2944/X VGND VGND VPWR
+ VPWR g_row\[0\].g_col\[0\].pe_hold2945/A sky130_fd_sc_hd__clkbuf_2
XTAP_TAPCELL_ROW_16_449 VGND VPWR sky130_fd_sc_hd__tapvpwrvgnd_1
Xg_row\[0\].g_col\[0\].pe_hold2027 g_row\[0\].g_col\[0\].pe__2633_/X VGND VGND VPWR
+ VPWR g_row\[0\].g_col\[0\].pe__2704_/D sky130_fd_sc_hd__clkbuf_2
XTAP_TAPCELL_ROW_60_1108 VGND VPWR sky130_fd_sc_hd__tapvpwrvgnd_1
X_276_ _276_/CLK _276_/D VGND VGND VPWR VPWR _276_/Q sky130_fd_sc_hd__dfxtp_2
Xg_row\[1\].g_col\[0\].pe__1940_ g_row\[1\].g_col\[0\].pe__1941_/A g_row\[1\].g_col\[0\].pe__1941_/B
+ g_row\[1\].g_col\[0\].pe__1941_/C VGND VGND VPWR VPWR g_row\[1\].g_col\[0\].pe__2005_/A
+ sky130_fd_sc_hd__a21oi_2
Xg_row\[1\].g_col\[0\].pe__1871_ g_row\[1\].g_col\[0\].pe__2682_/A g_row\[1\].g_col\[0\].pe__1928_/B
+ VGND VGND VPWR VPWR g_row\[1\].g_col\[0\].pe__1874_/A sky130_fd_sc_hd__xor2_2
XFILLER_5_152 VGND VGND VPWR VPWR sky130_fd_sc_hd__decap_3
XFILLER_6_664 VGND VGND VPWR VPWR sky130_fd_sc_hd__fill_2
XTAP_TAPCELL_ROW_75_1340 VGND VPWR sky130_fd_sc_hd__tapvpwrvgnd_1
Xg_row\[1\].g_col\[1\].pe_hold2092 g_row\[1\].g_col\[1\].pe__2719_/Q VGND VGND VPWR
+ VPWR g_row\[1\].g_col\[1\].pe__2667_/B sky130_fd_sc_hd__clkbuf_2
XFILLER_68_126 VGND VGND VPWR VPWR sky130_fd_sc_hd__fill_1
XFILLER_78_81 VGND VGND VPWR VPWR sky130_fd_sc_hd__decap_3
Xg_row\[0\].g_col\[0\].pe__1880_ g_row\[0\].g_col\[0\].pe__1629_/A g_row\[0\].g_col\[0\].pe__1629_/B
+ g_row\[0\].g_col\[0\].pe__1879_/Y VGND VGND VPWR VPWR g_row\[0\].g_col\[0\].pe__1936_/B
+ sky130_fd_sc_hd__a21oi_2
Xg_row\[1\].g_col\[0\].pe__2423_ g_row\[1\].g_col\[0\].pe__2424_/A g_row\[1\].g_col\[0\].pe__2424_/B
+ VGND VGND VPWR VPWR g_row\[1\].g_col\[0\].pe__2425_/A sky130_fd_sc_hd__nor2_2
XFILLER_49_384 VGND VGND VPWR VPWR sky130_fd_sc_hd__decap_3
XFILLER_83_107 VGND VGND VPWR VPWR sky130_fd_sc_hd__fill_1
XFILLER_83_118 VGND VGND VPWR VPWR sky130_fd_sc_hd__fill_2
Xg_row\[1\].g_col\[1\].pe__2370_ g_row\[1\].g_col\[1\].pe__2387_/A g_row\[1\].g_col\[1\].pe__2370_/B
+ VGND VGND VPWR VPWR g_row\[1\].g_col\[1\].pe__2372_/A sky130_fd_sc_hd__and2_2
Xg_row\[1\].g_col\[0\].pe__2354_ g_row\[1\].g_col\[0\].pe__2355_/A g_row\[1\].g_col\[0\].pe__2355_/B
+ VGND VGND VPWR VPWR g_row\[1\].g_col\[0\].pe__2356_/A sky130_fd_sc_hd__and2_2
XFILLER_52_527 VGND VGND VPWR VPWR sky130_fd_sc_hd__decap_3
XFILLER_64_365 VGND VGND VPWR VPWR sky130_fd_sc_hd__decap_3
Xg_row\[0\].g_col\[0\].pe__2501_ g_row\[0\].g_col\[0\].pe__2538_/A g_row\[0\].g_col\[0\].pe__2526_/A
+ g_row\[0\].g_col\[0\].pe__2501_/C g_row\[0\].g_col\[0\].pe__2533_/B VGND VGND VPWR
+ VPWR g_row\[0\].g_col\[0\].pe__2502_/D sky130_fd_sc_hd__and4_2
Xg_row\[1\].g_col\[0\].pe__2285_ g_row\[1\].g_col\[0\].pe__2285_/A g_row\[1\].g_col\[0\].pe__2285_/B
+ VGND VGND VPWR VPWR g_row\[1\].g_col\[0\].pe__2310_/B sky130_fd_sc_hd__xnor2_2
XFILLER_17_281 VGND VGND VPWR VPWR sky130_fd_sc_hd__fill_1
XTAP_TAPCELL_ROW_35_736 VGND VPWR sky130_fd_sc_hd__tapvpwrvgnd_1
Xg_row\[0\].g_col\[0\].pe__2432_ ANTENNA_179/DIODE g_row\[0\].g_col\[0\].pe__2432_/B
+ VGND VGND VPWR VPWR g_row\[0\].g_col\[0\].pe__2474_/B sky130_fd_sc_hd__xnor2_2
XFILLER_32_251 VGND VGND VPWR VPWR sky130_fd_sc_hd__fill_1
Xg_row\[0\].g_col\[0\].pe__2363_ g_row\[0\].g_col\[0\].pe__2388_/A g_row\[0\].g_col\[0\].pe__2363_/A2
+ g_row\[0\].g_col\[0\].pe__2388_/B g_row\[0\].g_col\[0\].pe__2121_/A VGND VGND VPWR
+ VPWR g_row\[0\].g_col\[0\].pe__2364_/B sky130_fd_sc_hd__a22o_2
Xg_row\[0\].g_col\[0\].pe__2294_ g_row\[0\].g_col\[0\].pe__2294_/A VGND VGND VPWR
+ VPWR g_row\[0\].g_col\[0\].pe__2329_/A sky130_fd_sc_hd__inv_2
Xg_row\[0\].g_col\[0\].pe_hold1882 g_row\[0\].g_col\[0\].pe__2336_/Y VGND VGND VPWR
+ VPWR g_row\[0\].g_col\[0\].pe__2360_/A2 sky130_fd_sc_hd__clkbuf_2
XPHY_EDGE_ROW_12_Right_12 VGND VGND VPWR VPWR sky130_fd_sc_hd__decap_3
Xg_row\[1\].g_col\[1\].pe__2706_ clkbuf_leaf_92_clk/X g_row\[1\].g_col\[1\].pe__2706_/D
+ VGND VGND VPWR VPWR g_row\[1\].g_col\[1\].pe__2706_/Q sky130_fd_sc_hd__dfxtp_2
Xg_row\[1\].g_col\[1\].pe__2637_ place1096/X place1098/X place1092/X place1093/X VGND
+ VGND VPWR VPWR g_row\[1\].g_col\[1\].pe__2637_/X sky130_fd_sc_hd__or4_2
XFILLER_28_502 VGND VGND VPWR VPWR sky130_fd_sc_hd__fill_1
Xg_row\[1\].g_col\[1\].pe__2568_ g_row\[1\].g_col\[1\].pe__2568_/A1 g_row\[1\].g_col\[1\].pe__2568_/A2
+ g_row\[1\].g_col\[1\].pe__2568_/B1 g_row\[1\].g_col\[1\].pe__2567_/X VGND VGND VPWR
+ VPWR g_row\[1\].g_col\[1\].pe__2568_/X sky130_fd_sc_hd__a22o_2
Xclkbuf_leaf_94_clk clkload1/A VGND VGND VPWR VPWR clkbuf_leaf_94_clk/X sky130_fd_sc_hd__clkbuf_16
Xg_row\[1\].g_col\[1\].pe__2499_ g_row\[1\].g_col\[1\].pe__2499_/A g_row\[1\].g_col\[1\].pe__2499_/B
+ VGND VGND VPWR VPWR g_row\[1\].g_col\[1\].pe__2501_/C sky130_fd_sc_hd__nor2_2
Xg_row\[1\].g_col\[1\].pe__1519_ g_row\[1\].g_col\[1\].pe__1730_/A g_row\[1\].g_col\[1\].pe__1519_/B
+ VGND VGND VPWR VPWR g_row\[1\].g_col\[1\].pe__1580_/B sky130_fd_sc_hd__xor2_2
Xg_row\[0\].g_col\[1\].pe_hold2135 ANTENNA_117/DIODE VGND VGND VPWR VPWR g_row\[0\].g_col\[1\].pe__2674_/B
+ sky130_fd_sc_hd__clkbuf_2
XPHY_EDGE_ROW_21_Right_21 VGND VGND VPWR VPWR sky130_fd_sc_hd__decap_3
Xg_row\[0\].g_col\[1\].pe_hold2168 g_row\[0\].g_col\[1\].pe__2673_/C VGND VGND VPWR
+ VPWR g_row\[0\].g_col\[1\].pe__2648_/A2 sky130_fd_sc_hd__clkbuf_2
Xg_row\[0\].g_col\[1\].pe_hold2157 _338_/Q VGND VGND VPWR VPWR g_row\[0\].g_col\[1\].pe__1400_/A
+ sky130_fd_sc_hd__clkbuf_2
Xg_row\[0\].g_col\[1\].pe_hold2146 _330_/Q VGND VGND VPWR VPWR g_row\[0\].g_col\[1\].pe_hold2146/X
+ sky130_fd_sc_hd__clkbuf_2
Xg_row\[0\].g_col\[1\].pe__2715_ _339_/CLK g_row\[0\].g_col\[1\].pe__2715_/D VGND
+ VGND VPWR VPWR hold2099/A sky130_fd_sc_hd__dfxtp_2
XFILLER_55_387 VGND VGND VPWR VPWR sky130_fd_sc_hd__decap_3
Xg_row\[0\].g_col\[1\].pe__2646_ g_row\[0\].g_col\[1\].pe__2666_/A1 g_row\[0\].g_col\[1\].pe__2685_/A1
+ g_row\[0\].g_col\[1\].pe__2677_/B1 g_row\[0\].g_col\[1\].pe__2645_/X VGND VGND VPWR
+ VPWR g_row\[0\].g_col\[1\].pe__2646_/X sky130_fd_sc_hd__o211a_2
XFILLER_11_413 VGND VGND VPWR VPWR sky130_fd_sc_hd__decap_3
XFILLER_11_424 VGND VGND VPWR VPWR sky130_fd_sc_hd__fill_2
XTAP_TAPCELL_ROW_13_408 VGND VPWR sky130_fd_sc_hd__tapvpwrvgnd_1
Xg_row\[0\].g_col\[1\].pe__2577_ g_row\[0\].g_col\[1\].pe__2595_/A g_row\[0\].g_col\[1\].pe__2577_/B
+ VGND VGND VPWR VPWR g_row\[0\].g_col\[1\].pe__2767_/D sky130_fd_sc_hd__and2_2
XFILLER_11_435 VGND VGND VPWR VPWR sky130_fd_sc_hd__decap_3
XFILLER_23_32 VGND VGND VPWR VPWR sky130_fd_sc_hd__fill_1
Xg_row\[0\].g_col\[1\].pe__1528_ g_row\[0\].g_col\[1\].pe__1673_/A g_row\[0\].g_col\[1\].pe__1528_/B
+ VGND VGND VPWR VPWR g_row\[0\].g_col\[1\].pe__1554_/B sky130_fd_sc_hd__xnor2_2
Xg_row\[0\].g_col\[1\].pe__1459_ g_row\[0\].g_col\[1\].pe__2732_/Q g_row\[0\].g_col\[1\].pe__2731_/Q
+ g_row\[0\].g_col\[1\].pe__1459_/C VGND VGND VPWR VPWR g_row\[0\].g_col\[1\].pe__1461_/A
+ sky130_fd_sc_hd__nand3b_2
XPHY_EDGE_ROW_30_Right_30 VGND VGND VPWR VPWR sky130_fd_sc_hd__decap_3
Xg_row\[0\].g_col\[0\].pe_place864 g_row\[0\].g_col\[0\].pe__1616_/A2 VGND VGND VPWR
+ VPWR g_row\[0\].g_col\[0\].pe__1761_/B2 sky130_fd_sc_hd__buf_6
XFILLER_3_656 VGND VGND VPWR VPWR sky130_fd_sc_hd__decap_3
XTAP_TAPCELL_ROW_57_1070 VGND VPWR sky130_fd_sc_hd__tapvpwrvgnd_1
XFILLER_59_671 VGND VGND VPWR VPWR sky130_fd_sc_hd__fill_1
XFILLER_19_546 VGND VGND VPWR VPWR sky130_fd_sc_hd__decap_3
XFILLER_59_693 VGND VGND VPWR VPWR sky130_fd_sc_hd__decap_3
XFILLER_74_641 VGND VGND VPWR VPWR sky130_fd_sc_hd__decap_3
Xclkbuf_leaf_85_clk clkbuf_4_8_0_clk/X VGND VGND VPWR VPWR clkbuf_leaf_85_clk/X sky130_fd_sc_hd__clkbuf_16
XFILLER_34_516 VGND VGND VPWR VPWR sky130_fd_sc_hd__decap_3
XFILLER_73_140 VGND VGND VPWR VPWR sky130_fd_sc_hd__fill_1
Xg_row\[1\].g_col\[0\].pe__2070_ g_row\[1\].g_col\[0\].pe__1961_/A g_row\[1\].g_col\[0\].pe__1961_/B
+ g_row\[1\].g_col\[0\].pe__2024_/B g_row\[1\].g_col\[0\].pe__2023_/B g_row\[1\].g_col\[0\].pe__2023_/A
+ VGND VGND VPWR VPWR g_row\[1\].g_col\[0\].pe__2107_/A sky130_fd_sc_hd__a32o_2
XFILLER_15_741 VGND VGND VPWR VPWR sky130_fd_sc_hd__fill_1
XFILLER_14_273 VGND VGND VPWR VPWR sky130_fd_sc_hd__fill_1
XFILLER_15_785 VGND VGND VPWR VPWR sky130_fd_sc_hd__decap_3
X_328_ _333_/CLK _328_/D VGND VGND VPWR VPWR _328_/Q sky130_fd_sc_hd__dfxtp_2
X_259_ _267_/A _259_/B_N VGND VGND VPWR VPWR _259_/Y sky130_fd_sc_hd__nor2b_4
Xg_row\[1\].g_col\[0\].pe__1923_ g_row\[1\].g_col\[0\].pe__1424_/A g_row\[1\].g_col\[0\].pe__1424_/B
+ g_row\[1\].g_col\[0\].pe__1922_/Y VGND VGND VPWR VPWR g_row\[1\].g_col\[0\].pe__1924_/C
+ sky130_fd_sc_hd__a21oi_2
Xg_row\[1\].g_col\[1\].pe__1870_ g_row\[1\].g_col\[1\].pe__2686_/A g_row\[1\].g_col\[1\].pe__1870_/B
+ VGND VGND VPWR VPWR g_row\[1\].g_col\[1\].pe__1928_/B sky130_fd_sc_hd__xor2_2
Xg_row\[1\].g_col\[0\].pe__1854_ place1098/A g_row\[1\].g_col\[0\].pe__1504_/Y g_row\[1\].g_col\[0\].pe__2074_/B1
+ place1100/X VGND VGND VPWR VPWR g_row\[1\].g_col\[0\].pe__1855_/B sky130_fd_sc_hd__a22o_2
Xg_row\[1\].g_col\[0\].pe__1785_ g_row\[1\].g_col\[0\].pe__1785_/A g_row\[1\].g_col\[0\].pe__1785_/B
+ VGND VGND VPWR VPWR g_row\[1\].g_col\[0\].pe__1796_/B sky130_fd_sc_hd__xor2_2
XFILLER_69_446 VGND VGND VPWR VPWR sky130_fd_sc_hd__fill_2
Xg_row\[0\].g_col\[0\].pe__1932_ g_row\[0\].g_col\[0\].pe__1877_/B g_row\[0\].g_col\[0\].pe__1932_/B
+ VGND VGND VPWR VPWR g_row\[0\].g_col\[0\].pe__1932_/X sky130_fd_sc_hd__and2b_2
Xhold1607 hold3513/X VGND VGND VPWR VPWR hold3514/A sky130_fd_sc_hd__clkbuf_2
Xg_row\[0\].g_col\[0\].pe__1863_ g_row\[0\].g_col\[0\].pe__2215_/B2 g_row\[0\].g_col\[0\].pe__2163_/B
+ g_row\[0\].g_col\[0\].pe__1863_/B1 place1208/X VGND VGND VPWR VPWR g_row\[0\].g_col\[0\].pe__1864_/B
+ sky130_fd_sc_hd__a22o_2
Xhold1618 hold3566/X VGND VGND VPWR VPWR hold3567/A sky130_fd_sc_hd__clkbuf_2
Xhold1629 hold2814/X VGND VGND VPWR VPWR hold2815/A sky130_fd_sc_hd__clkbuf_2
Xg_row\[1\].g_col\[1\].pe__2422_ g_row\[1\].g_col\[1\].pe__2422_/A g_row\[1\].g_col\[1\].pe__2484_/A
+ VGND VGND VPWR VPWR g_row\[1\].g_col\[1\].pe__2424_/B sky130_fd_sc_hd__xnor2_2
Xg_row\[1\].g_col\[0\].pe__2406_ g_row\[1\].g_col\[0\].pe__2403_/A place1233/X place1262/X
+ VGND VGND VPWR VPWR g_row\[1\].g_col\[0\].pe__2406_/Y sky130_fd_sc_hd__o21ai_2
XTAP_TAPCELL_ROW_88_1531 VGND VPWR sky130_fd_sc_hd__tapvpwrvgnd_1
Xclkbuf_leaf_76_clk clkbuf_4_10_0_clk/X VGND VGND VPWR VPWR clkbuf_leaf_76_clk/X sky130_fd_sc_hd__clkbuf_16
Xg_row\[1\].g_col\[1\].pe__2353_ g_row\[1\].g_col\[1\].pe__2375_/A g_row\[1\].g_col\[1\].pe__2353_/B
+ VGND VGND VPWR VPWR g_row\[1\].g_col\[1\].pe__2355_/B sky130_fd_sc_hd__nor2_2
XFILLER_25_505 VGND VGND VPWR VPWR sky130_fd_sc_hd__fill_1
Xg_row\[0\].g_col\[0\].pe__1794_ g_row\[0\].g_col\[0\].pe__1794_/A g_row\[0\].g_col\[0\].pe__1794_/B
+ VGND VGND VPWR VPWR g_row\[0\].g_col\[0\].pe__1795_/C sky130_fd_sc_hd__or2_4
Xg_row\[1\].g_col\[0\].pe__2337_ g_row\[1\].g_col\[0\].pe__2337_/A g_row\[1\].g_col\[0\].pe__2337_/B
+ g_row\[1\].g_col\[0\].pe__2337_/C VGND VGND VPWR VPWR g_row\[1\].g_col\[0\].pe__2352_/A
+ sky130_fd_sc_hd__or3_2
XFILLER_25_538 VGND VGND VPWR VPWR sky130_fd_sc_hd__fill_1
XFILLER_64_162 VGND VGND VPWR VPWR sky130_fd_sc_hd__fill_2
Xg_row\[1\].g_col\[1\].pe__2284_ g_row\[1\].g_col\[1\].pe__2284_/A g_row\[1\].g_col\[1\].pe__2284_/B
+ VGND VGND VPWR VPWR g_row\[1\].g_col\[1\].pe__2285_/B sky130_fd_sc_hd__nor2_2
Xg_row\[1\].g_col\[0\].pe_place1101 hold2198/A VGND VGND VPWR VPWR g_row\[1\].g_col\[0\].pe__2605_/B
+ sky130_fd_sc_hd__buf_6
Xg_row\[1\].g_col\[0\].pe__2268_ place1271/X g_row\[1\].g_col\[0\].pe__2268_/B VGND
+ VGND VPWR VPWR g_row\[1\].g_col\[0\].pe__2748_/D sky130_fd_sc_hd__nor2_2
Xg_row\[0\].g_col\[1\].pe__2500_ g_row\[0\].g_col\[1\].pe__2464_/X g_row\[0\].g_col\[1\].pe__2538_/B
+ VGND VGND VPWR VPWR g_row\[0\].g_col\[1\].pe__2533_/B sky130_fd_sc_hd__and2b_2
Xg_row\[1\].g_col\[0\].pe_place1112 g_row\[1\].g_col\[0\].pe__2679_/C1 VGND VGND VPWR
+ VPWR g_row\[1\].g_col\[0\].pe__1403_/C1 sky130_fd_sc_hd__buf_6
XFILLER_33_571 VGND VGND VPWR VPWR sky130_fd_sc_hd__decap_3
XFILLER_40_519 VGND VGND VPWR VPWR sky130_fd_sc_hd__decap_3
Xg_row\[0\].g_col\[0\].pe__2415_ g_row\[0\].g_col\[0\].pe__2450_/A1 ANTENNA_180/DIODE
+ g_row\[0\].g_col\[0\].pe__2439_/B VGND VGND VPWR VPWR g_row\[0\].g_col\[0\].pe__2436_/B
+ sky130_fd_sc_hd__a21o_2
Xg_row\[1\].g_col\[0\].pe__2199_ g_row\[1\].g_col\[0\].pe__2514_/A g_row\[1\].g_col\[0\].pe__2199_/B
+ VGND VGND VPWR VPWR g_row\[1\].g_col\[0\].pe__2746_/D sky130_fd_sc_hd__nor2_2
Xg_row\[0\].g_col\[1\].pe__2431_ g_row\[0\].g_col\[1\].pe__2476_/B g_row\[0\].g_col\[1\].pe__2767_/Q
+ VGND VGND VPWR VPWR g_row\[0\].g_col\[1\].pe__2579_/B sky130_fd_sc_hd__or2b_2
Xg_row\[0\].g_col\[0\].pe__2346_ g_row\[0\].g_col\[0\].pe__2346_/A g_row\[0\].g_col\[0\].pe__2346_/B
+ VGND VGND VPWR VPWR g_row\[0\].g_col\[0\].pe__2347_/B sky130_fd_sc_hd__nand2_2
Xg_row\[0\].g_col\[1\].pe_place961 g_row\[0\].g_col\[1\].pe__2668_/A1 VGND VGND VPWR
+ VPWR g_row\[0\].g_col\[1\].pe__2666_/A1 sky130_fd_sc_hd__buf_6
Xg_row\[0\].g_col\[1\].pe_place950 g_row\[0\].g_col\[1\].pe__1864_/A VGND VGND VPWR
+ VPWR g_row\[0\].g_col\[1\].pe__1673_/A sky130_fd_sc_hd__buf_6
Xg_row\[0\].g_col\[1\].pe__2293_ g_row\[0\].g_col\[1\].pe__2295_/A g_row\[0\].g_col\[1\].pe__2295_/B
+ g_row\[0\].g_col\[1\].pe__2292_/X VGND VGND VPWR VPWR g_row\[0\].g_col\[1\].pe__2294_/A
+ sky130_fd_sc_hd__o21ba_2
XFILLER_20_287 VGND VGND VPWR VPWR sky130_fd_sc_hd__decap_3
Xg_row\[0\].g_col\[0\].pe__2277_ g_row\[0\].g_col\[0\].pe__2277_/A g_row\[0\].g_col\[0\].pe__2277_/B
+ VGND VGND VPWR VPWR g_row\[0\].g_col\[0\].pe__2285_/A sky130_fd_sc_hd__and2_2
Xg_row\[1\].g_col\[1\].pe_hold2839 g_row\[1\].g_col\[1\].pe__2663_/X VGND VGND VPWR
+ VPWR g_row\[1\].g_col\[1\].pe__2664_/C1 sky130_fd_sc_hd__clkbuf_2
Xg_row\[1\].g_col\[1\].pe_hold2828 g_row\[1\].g_col\[1\].pe__2670_/X VGND VGND VPWR
+ VPWR g_row\[1\].g_col\[1\].pe_hold2828/X sky130_fd_sc_hd__clkbuf_2
Xhold3510 hold3510/A VGND VGND VPWR VPWR hold3510/X sky130_fd_sc_hd__clkbuf_2
Xg_row\[1\].g_col\[1\].pe__1999_ g_row\[1\].g_col\[1\].pe__1999_/A g_row\[1\].g_col\[1\].pe__1999_/B
+ VGND VGND VPWR VPWR g_row\[1\].g_col\[1\].pe__1999_/X sky130_fd_sc_hd__or2_2
Xhold3543 hold3543/A VGND VGND VPWR VPWR hold3543/X sky130_fd_sc_hd__clkbuf_2
Xhold3532 hold3532/A VGND VGND VPWR VPWR hold3532/X sky130_fd_sc_hd__clkbuf_2
Xhold3521 hold3521/A VGND VGND VPWR VPWR hold3521/X sky130_fd_sc_hd__clkbuf_2
XFILLER_48_608 VGND VGND VPWR VPWR sky130_fd_sc_hd__fill_1
XFILLER_88_777 VGND VGND VPWR VPWR sky130_fd_sc_hd__decap_3
Xhold3576 hold3576/A VGND VGND VPWR VPWR hold3576/X sky130_fd_sc_hd__clkbuf_2
Xhold3565 load_weights VGND VGND VPWR VPWR hold3565/X sky130_fd_sc_hd__clkbuf_2
Xhold3554 hold3554/A VGND VGND VPWR VPWR hold3554/X sky130_fd_sc_hd__clkbuf_2
XFILLER_29_811 VGND VGND VPWR VPWR sky130_fd_sc_hd__fill_2
XFILLER_47_118 VGND VGND VPWR VPWR sky130_fd_sc_hd__fill_2
Xhold3587 hold3587/A VGND VGND VPWR VPWR hold3587/X sky130_fd_sc_hd__clkbuf_2
XFILLER_18_43 VGND VGND VPWR VPWR sky130_fd_sc_hd__fill_1
XFILLER_56_641 VGND VGND VPWR VPWR sky130_fd_sc_hd__decap_3
XFILLER_75_449 VGND VGND VPWR VPWR sky130_fd_sc_hd__fill_1
Xclkbuf_leaf_67_clk clkload5/A VGND VGND VPWR VPWR clkbuf_leaf_67_clk/X sky130_fd_sc_hd__clkbuf_16
XFILLER_70_110 VGND VGND VPWR VPWR sky130_fd_sc_hd__fill_2
XFILLER_31_508 VGND VGND VPWR VPWR sky130_fd_sc_hd__fill_2
XFILLER_71_655 VGND VGND VPWR VPWR sky130_fd_sc_hd__decap_3
XFILLER_24_560 VGND VGND VPWR VPWR sky130_fd_sc_hd__fill_1
XFILLER_12_755 VGND VGND VPWR VPWR sky130_fd_sc_hd__fill_1
XFILLER_8_704 VGND VGND VPWR VPWR sky130_fd_sc_hd__decap_3
XTAP_TAPCELL_ROW_26_599 VGND VPWR sky130_fd_sc_hd__tapvpwrvgnd_1
Xg_row\[0\].g_col\[1\].pe_place1133 g_row\[0\].g_col\[1\].pe__1804_/A VGND VGND VPWR
+ VPWR g_row\[0\].g_col\[1\].pe__1704_/A1 sky130_fd_sc_hd__buf_6
Xg_row\[0\].g_col\[1\].pe_place1122 g_row\[0\].g_col\[1\].pe__2730_/Q VGND VGND VPWR
+ VPWR g_row\[0\].g_col\[1\].pe__1862_/A sky130_fd_sc_hd__buf_6
XFILLER_12_788 VGND VGND VPWR VPWR sky130_fd_sc_hd__decap_3
Xg_row\[0\].g_col\[1\].pe_place1166 g_row\[0\].g_col\[1\].pe__1836_/A VGND VGND VPWR
+ VPWR g_row\[0\].g_col\[1\].pe__2592_/A sky130_fd_sc_hd__buf_6
Xg_row\[0\].g_col\[1\].pe_place1155 g_row\[0\].g_col\[1\].pe__2019_/B2 VGND VGND VPWR
+ VPWR g_row\[0\].g_col\[1\].pe__1761_/A2 sky130_fd_sc_hd__buf_6
Xg_row\[0\].g_col\[1\].pe_place1144 g_row\[0\].g_col\[1\].pe__2700_/Q VGND VGND VPWR
+ VPWR g_row\[0\].g_col\[1\].pe__2241_/A1 sky130_fd_sc_hd__buf_6
XFILLER_79_700 VGND VGND VPWR VPWR sky130_fd_sc_hd__fill_2
XTAP_TAPCELL_ROW_55_1029 VGND VPWR sky130_fd_sc_hd__tapvpwrvgnd_1
Xg_row\[1\].g_col\[0\].pe__1570_ g_row\[1\].g_col\[0\].pe__1676_/A g_row\[1\].g_col\[0\].pe__1570_/B
+ VGND VGND VPWR VPWR g_row\[1\].g_col\[0\].pe__1571_/B sky130_fd_sc_hd__xnor2_2
XFILLER_79_777 VGND VGND VPWR VPWR sky130_fd_sc_hd__decap_3
Xg_row\[1\].g_col\[0\].pe_hold1827 g_row\[1\].g_col\[0\].pe__2761_/Q VGND VGND VPWR
+ VPWR g_row\[1\].g_col\[0\].pe__2548_/A1 sky130_fd_sc_hd__clkbuf_2
XFILLER_47_630 VGND VGND VPWR VPWR sky130_fd_sc_hd__decap_3
Xclkbuf_leaf_58_clk clkload7/A VGND VGND VPWR VPWR clkbuf_leaf_58_clk/X sky130_fd_sc_hd__clkbuf_16
Xg_row\[1\].g_col\[0\].pe_hold1838 _308_/Q VGND VGND VPWR VPWR g_row\[1\].g_col\[0\].pe__2638_/B1
+ sky130_fd_sc_hd__clkbuf_2
XFILLER_93_268 VGND VGND VPWR VPWR sky130_fd_sc_hd__fill_1
Xclkbuf_4_11_0_clk clkbuf_0_clk/X VGND VGND VPWR VPWR clkload5/A sky130_fd_sc_hd__clkbuf_16
XFILLER_35_825 VGND VGND VPWR VPWR sky130_fd_sc_hd__decap_3
XFILLER_74_482 VGND VGND VPWR VPWR sky130_fd_sc_hd__fill_2
Xg_row\[1\].g_col\[0\].pe__2122_ g_row\[1\].g_col\[0\].pe__1461_/A g_row\[1\].g_col\[0\].pe__1461_/B
+ g_row\[1\].g_col\[0\].pe__1922_/Y VGND VGND VPWR VPWR g_row\[1\].g_col\[0\].pe__2123_/C
+ sky130_fd_sc_hd__a21o_2
XFILLER_62_655 VGND VGND VPWR VPWR sky130_fd_sc_hd__decap_3
Xg_row\[1\].g_col\[0\].pe__2053_ g_row\[1\].g_col\[0\].pe__2052_/B g_row\[1\].g_col\[0\].pe__2052_/C
+ g_row\[1\].g_col\[0\].pe__2052_/A VGND VGND VPWR VPWR g_row\[1\].g_col\[0\].pe__2054_/B
+ sky130_fd_sc_hd__o21ai_2
XFILLER_34_379 VGND VGND VPWR VPWR sky130_fd_sc_hd__fill_1
XTAP_TAPCELL_ROW_45_886 VGND VPWR sky130_fd_sc_hd__tapvpwrvgnd_1
XTAP_TAPCELL_ROW_83_1450 VGND VPWR sky130_fd_sc_hd__tapvpwrvgnd_1
XTAP_TAPCELL_ROW_83_1461 VGND VPWR sky130_fd_sc_hd__tapvpwrvgnd_1
XFILLER_91_92 VGND VGND VPWR VPWR sky130_fd_sc_hd__fill_2
Xg_row\[0\].g_col\[0\].pe__2200_ g_row\[0\].g_col\[0\].pe__2200_/A g_row\[0\].g_col\[0\].pe__2200_/B
+ VGND VGND VPWR VPWR g_row\[0\].g_col\[0\].pe__2299_/A sky130_fd_sc_hd__or2_4
Xg_row\[0\].g_col\[0\].pe__2131_ g_row\[0\].g_col\[0\].pe__2171_/A g_row\[0\].g_col\[0\].pe__2131_/B
+ VGND VGND VPWR VPWR g_row\[0\].g_col\[0\].pe__2132_/B sky130_fd_sc_hd__xnor2_2
Xg_row\[0\].g_col\[0\].pe__2062_ g_row\[0\].g_col\[0\].pe__2062_/A g_row\[0\].g_col\[0\].pe__2150_/C
+ g_row\[0\].g_col\[0\].pe__2062_/C VGND VGND VPWR VPWR g_row\[0\].g_col\[0\].pe__2062_/X
+ sky130_fd_sc_hd__or3_2
Xg_row\[1\].g_col\[1\].pe__1922_ g_row\[1\].g_col\[1\].pe__2083_/A VGND VGND VPWR
+ VPWR g_row\[1\].g_col\[1\].pe__1922_/Y sky130_fd_sc_hd__inv_2
Xg_row\[1\].g_col\[0\].pe__1906_ g_row\[1\].g_col\[0\].pe__1964_/A g_row\[1\].g_col\[0\].pe__1906_/B
+ VGND VGND VPWR VPWR g_row\[1\].g_col\[0\].pe__1907_/B sky130_fd_sc_hd__and2_2
Xg_row\[1\].g_col\[1\].pe__1853_ g_row\[1\].g_col\[1\].pe__1901_/B2 g_row\[1\].g_col\[1\].pe__2177_/A2
+ g_row\[1\].g_col\[1\].pe__2177_/B1 g_row\[1\].g_col\[1\].pe__1853_/B2 VGND VGND
+ VPWR VPWR g_row\[1\].g_col\[1\].pe__1857_/A sky130_fd_sc_hd__a22o_2
Xg_row\[1\].g_col\[1\].pe__1784_ g_row\[1\].g_col\[1\].pe__2690_/Q g_row\[1\].g_col\[1\].pe__1414_/X
+ g_row\[1\].g_col\[1\].pe__1415_/Y g_row\[1\].g_col\[1\].pe__1801_/B g_row\[1\].g_col\[1\].pe__1805_/A2
+ VGND VGND VPWR VPWR g_row\[1\].g_col\[1\].pe__1785_/B sky130_fd_sc_hd__a32o_2
Xg_row\[1\].g_col\[0\].pe__1768_ g_row\[1\].g_col\[0\].pe__1789_/A g_row\[1\].g_col\[0\].pe__1768_/B
+ VGND VGND VPWR VPWR g_row\[1\].g_col\[0\].pe__1781_/B sky130_fd_sc_hd__xnor2_2
Xg_row\[0\].g_col\[0\].pe__1915_ g_row\[0\].g_col\[0\].pe__2348_/A g_row\[0\].g_col\[0\].pe__1915_/B
+ VGND VGND VPWR VPWR g_row\[0\].g_col\[0\].pe__1916_/B sky130_fd_sc_hd__xnor2_2
Xhold2149 hold2149/A VGND VGND VPWR VPWR hold2149/X sky130_fd_sc_hd__clkbuf_2
Xg_row\[1\].g_col\[0\].pe__1699_ g_row\[1\].g_col\[0\].pe__1698_/A g_row\[1\].g_col\[0\].pe__1699_/B
+ VGND VGND VPWR VPWR g_row\[1\].g_col\[0\].pe__1699_/X sky130_fd_sc_hd__and2b_2
Xg_row\[0\].g_col\[1\].pe__1931_ g_row\[0\].g_col\[1\].pe__1931_/A g_row\[0\].g_col\[1\].pe__1931_/B
+ VGND VGND VPWR VPWR g_row\[0\].g_col\[1\].pe__1999_/A sky130_fd_sc_hd__xnor2_2
XFILLER_38_641 VGND VGND VPWR VPWR sky130_fd_sc_hd__decap_3
XFILLER_57_449 VGND VGND VPWR VPWR sky130_fd_sc_hd__fill_1
Xclkbuf_leaf_49_clk clkload6/A VGND VGND VPWR VPWR clkbuf_leaf_49_clk/X sky130_fd_sc_hd__clkbuf_16
Xhold1437 hold2430/X VGND VGND VPWR VPWR hold2431/A sky130_fd_sc_hd__clkbuf_2
Xhold1448 hold3156/X VGND VGND VPWR VPWR hold3157/A sky130_fd_sc_hd__clkbuf_2
Xhold1459 hold3236/X VGND VGND VPWR VPWR hold3237/A sky130_fd_sc_hd__clkbuf_2
Xg_row\[1\].g_col\[1\].pe__2405_ _195_/A g_row\[1\].g_col\[1\].pe__2405_/B VGND VGND
+ VPWR VPWR g_row\[1\].g_col\[1\].pe__2405_/Y sky130_fd_sc_hd__nor2_2
Xg_row\[0\].g_col\[1\].pe__1862_ g_row\[0\].g_col\[1\].pe__1862_/A g_row\[0\].g_col\[1\].pe__1862_/B
+ VGND VGND VPWR VPWR g_row\[0\].g_col\[1\].pe__1899_/A sky130_fd_sc_hd__xor2_2
Xg_row\[0\].g_col\[0\].pe__1846_ g_row\[0\].g_col\[0\].pe__1846_/A VGND VGND VPWR
+ VPWR g_row\[0\].g_col\[0\].pe__1847_/A sky130_fd_sc_hd__inv_2
XFILLER_25_313 VGND VGND VPWR VPWR sky130_fd_sc_hd__fill_2
XFILLER_37_162 VGND VGND VPWR VPWR sky130_fd_sc_hd__fill_2
XFILLER_53_611 VGND VGND VPWR VPWR sky130_fd_sc_hd__decap_3
Xg_row\[0\].g_col\[0\].pe__1777_ g_row\[0\].g_col\[0\].pe__1777_/A g_row\[0\].g_col\[0\].pe__1777_/B
+ VGND VGND VPWR VPWR g_row\[0\].g_col\[0\].pe__1816_/C sky130_fd_sc_hd__xor2_2
Xg_row\[1\].g_col\[1\].pe__2336_ g_row\[1\].g_col\[1\].pe__2336_/A VGND VGND VPWR
+ VPWR g_row\[1\].g_col\[1\].pe__2336_/Y sky130_fd_sc_hd__inv_2
Xg_row\[0\].g_col\[1\].pe__1793_ g_row\[0\].g_col\[1\].pe__1793_/A g_row\[0\].g_col\[1\].pe__1793_/B
+ g_row\[0\].g_col\[1\].pe__1793_/C VGND VGND VPWR VPWR g_row\[0\].g_col\[1\].pe__1794_/B
+ sky130_fd_sc_hd__and3_2
XFILLER_53_655 VGND VGND VPWR VPWR sky130_fd_sc_hd__decap_3
Xg_row\[1\].g_col\[1\].pe__2267_ g_row\[1\].g_col\[1\].pe__2264_/X g_row\[1\].g_col\[1\].pe__2265_/Y
+ g_row\[1\].g_col\[1\].pe__2267_/B1 g_row\[1\].g_col\[1\].pe__2334_/A1 VGND VGND
+ VPWR VPWR g_row\[1\].g_col\[1\].pe__2268_/B sky130_fd_sc_hd__o2bb2a_2
XFILLER_80_474 VGND VGND VPWR VPWR sky130_fd_sc_hd__fill_2
XFILLER_33_390 VGND VGND VPWR VPWR sky130_fd_sc_hd__fill_2
Xg_row\[1\].g_col\[1\].pe__2198_ g_row\[1\].g_col\[1\].pe__2334_/A1 g_row\[1\].g_col\[1\].pe__2198_/A2
+ g_row\[1\].g_col\[1\].pe__2196_/X g_row\[1\].g_col\[1\].pe__2197_/Y VGND VGND VPWR
+ VPWR g_row\[1\].g_col\[1\].pe__2198_/X sky130_fd_sc_hd__o22a_2
Xg_row\[0\].g_col\[1\].pe__2414_ g_row\[0\].g_col\[1\].pe__2754_/Q g_row\[0\].g_col\[1\].pe__2116_/Y
+ g_row\[0\].g_col\[1\].pe__2441_/B VGND VGND VPWR VPWR g_row\[0\].g_col\[1\].pe__2439_/B
+ sky130_fd_sc_hd__o21ai_2
XTAP_TAPCELL_ROW_23_558 VGND VPWR sky130_fd_sc_hd__tapvpwrvgnd_1
Xinput1303 hold3532/X VGND VGND VPWR VPWR hold3533/A sky130_fd_sc_hd__buf_2
Xg_row\[0\].g_col\[0\].pe__2329_ g_row\[0\].g_col\[0\].pe__2329_/A g_row\[0\].g_col\[0\].pe__2329_/B
+ VGND VGND VPWR VPWR g_row\[0\].g_col\[0\].pe__2329_/Y sky130_fd_sc_hd__xnor2_2
Xinput1336 hold3343/X VGND VGND VPWR VPWR hold3344/A sky130_fd_sc_hd__buf_2
Xinput1325 hold3280/X VGND VGND VPWR VPWR hold3281/A sky130_fd_sc_hd__buf_2
Xinput1314 hold3350/X VGND VGND VPWR VPWR hold3351/A sky130_fd_sc_hd__buf_2
Xg_row\[0\].g_col\[1\].pe__2345_ g_row\[0\].g_col\[1\].pe__2368_/A g_row\[0\].g_col\[1\].pe__2345_/B
+ VGND VGND VPWR VPWR g_row\[0\].g_col\[1\].pe__2346_/B sky130_fd_sc_hd__or2_2
Xinput1347 hold3217/X VGND VGND VPWR VPWR hold3218/A sky130_fd_sc_hd__buf_2
Xg_row\[0\].g_col\[1\].pe__2276_ g_row\[0\].g_col\[1\].pe__2318_/A g_row\[0\].g_col\[1\].pe__2276_/B
+ VGND VGND VPWR VPWR g_row\[0\].g_col\[1\].pe__2286_/A sky130_fd_sc_hd__and2b_2
XFILLER_20_33 VGND VGND VPWR VPWR sky130_fd_sc_hd__fill_2
XFILLER_4_228 VGND VGND VPWR VPWR sky130_fd_sc_hd__decap_3
Xg_row\[1\].g_col\[1\].pe_hold1946 g_row\[1\].g_col\[1\].pe__2696_/Q VGND VGND VPWR
+ VPWR g_row\[1\].g_col\[1\].pe_hold1946/X sky130_fd_sc_hd__clkbuf_2
XFILLER_29_20 VGND VGND VPWR VPWR sky130_fd_sc_hd__fill_1
Xhold3340 b_inputs_flat[26] VGND VGND VPWR VPWR hold3340/X sky130_fd_sc_hd__clkbuf_2
Xhold3351 hold3351/A VGND VGND VPWR VPWR hold3351/X sky130_fd_sc_hd__clkbuf_2
Xg_row\[1\].g_col\[1\].pe_hold1968 g_row\[1\].g_col\[1\].pe__2617_/X VGND VGND VPWR
+ VPWR g_row\[1\].g_col\[1\].pe__2697_/D sky130_fd_sc_hd__clkbuf_2
Xg_row\[1\].g_col\[1\].pe_hold1957 g_row\[1\].g_col\[1\].pe__1393_/X VGND VGND VPWR
+ VPWR g_row\[1\].g_col\[1\].pe__2732_/D sky130_fd_sc_hd__clkbuf_2
XFILLER_76_714 VGND VGND VPWR VPWR sky130_fd_sc_hd__decap_3
XFILLER_88_563 VGND VGND VPWR VPWR sky130_fd_sc_hd__fill_1
Xhold3362 hold3362/A VGND VGND VPWR VPWR hold3362/X sky130_fd_sc_hd__clkbuf_2
Xhold3373 hold3373/A VGND VGND VPWR VPWR hold3373/X sky130_fd_sc_hd__clkbuf_2
Xhold3384 hold3384/A VGND VGND VPWR VPWR hold3384/X sky130_fd_sc_hd__clkbuf_2
Xhold2650 hold3372/X VGND VGND VPWR VPWR hold3373/A sky130_fd_sc_hd__clkbuf_2
Xhold2661 hold3419/X VGND VGND VPWR VPWR hold3420/A sky130_fd_sc_hd__clkbuf_2
Xhold2672 hold3459/X VGND VGND VPWR VPWR hold3460/A sky130_fd_sc_hd__clkbuf_2
Xhold2683 hold2683/A VGND VGND VPWR VPWR _296_/D sky130_fd_sc_hd__clkbuf_2
Xhold3395 hold3395/A VGND VGND VPWR VPWR hold3395/X sky130_fd_sc_hd__clkbuf_2
XFILLER_63_419 VGND VGND VPWR VPWR sky130_fd_sc_hd__fill_1
XPHY_EDGE_ROW_11_Left_105 VGND VGND VPWR VPWR sky130_fd_sc_hd__decap_3
XTAP_TAPCELL_ROW_3_250 VGND VPWR sky130_fd_sc_hd__tapvpwrvgnd_1
XTAP_TAPCELL_ROW_3_261 VGND VPWR sky130_fd_sc_hd__tapvpwrvgnd_1
Xhold2694 _219_/Y VGND VGND VPWR VPWR hold2694/X sky130_fd_sc_hd__clkbuf_2
XFILLER_28_173 VGND VGND VPWR VPWR sky130_fd_sc_hd__decap_3
XFILLER_56_471 VGND VGND VPWR VPWR sky130_fd_sc_hd__decap_3
XFILLER_43_110 VGND VGND VPWR VPWR sky130_fd_sc_hd__fill_2
XTAP_TAPCELL_ROW_42_834 VGND VPWR sky130_fd_sc_hd__tapvpwrvgnd_1
XTAP_TAPCELL_ROW_42_845 VGND VPWR sky130_fd_sc_hd__tapvpwrvgnd_1
XTAP_TAPCELL_ROW_65_1180 VGND VPWR sky130_fd_sc_hd__tapvpwrvgnd_1
XTAP_TAPCELL_ROW_65_1191 VGND VPWR sky130_fd_sc_hd__tapvpwrvgnd_1
XFILLER_61_84 VGND VGND VPWR VPWR sky130_fd_sc_hd__fill_1
XFILLER_8_589 VGND VGND VPWR VPWR sky130_fd_sc_hd__decap_3
XPHY_EDGE_ROW_20_Left_114 VGND VGND VPWR VPWR sky130_fd_sc_hd__decap_3
XANTENNA_6 a_inputs_flat[28] VGND VGND VPWR VPWR sky130_fd_sc_hd__diode_2
Xg_row\[1\].g_col\[0\].pe__2740_ clkbuf_leaf_60_clk/X g_row\[1\].g_col\[0\].pe__2740_/D
+ VGND VGND VPWR VPWR g_row\[1\].g_col\[0\].pe__2740_/Q sky130_fd_sc_hd__dfxtp_2
XFILLER_4_751 VGND VGND VPWR VPWR sky130_fd_sc_hd__decap_3
Xg_row\[1\].g_col\[0\].pe__2671_ hold3029/A hold3023/A hold3035/A hold3008/A VGND
+ VGND VPWR VPWR g_row\[1\].g_col\[0\].pe__2672_/D sky130_fd_sc_hd__or4_2
Xg_row\[1\].g_col\[0\].pe_hold3004 hold1887/X VGND VGND VPWR VPWR g_row\[1\].g_col\[0\].pe__2681_/A1
+ sky130_fd_sc_hd__clkbuf_2
Xg_row\[1\].g_col\[0\].pe__1622_ g_row\[1\].g_col\[0\].pe__1622_/A g_row\[1\].g_col\[0\].pe__1875_/C
+ VGND VGND VPWR VPWR g_row\[1\].g_col\[0\].pe__1625_/A sky130_fd_sc_hd__xnor2_2
XFILLER_79_541 VGND VGND VPWR VPWR sky130_fd_sc_hd__decap_3
Xg_row\[1\].g_col\[0\].pe_hold3048 g_row\[1\].g_col\[0\].pe__1399_/X VGND VGND VPWR
+ VPWR g_row\[1\].g_col\[0\].pe_hold3048/X sky130_fd_sc_hd__clkbuf_2
Xg_row\[1\].g_col\[0\].pe_hold3037 g_row\[1\].g_col\[0\].pe__2664_/X VGND VGND VPWR
+ VPWR g_row\[1\].g_col\[0\].pe_hold3037/X sky130_fd_sc_hd__clkbuf_2
Xg_row\[1\].g_col\[0\].pe__1553_ g_row\[1\].g_col\[0\].pe__2736_/Q g_row\[1\].g_col\[0\].pe__1535_/B
+ g_row\[1\].g_col\[0\].pe__1546_/B g_row\[1\].g_col\[0\].pe__1552_/X VGND VGND VPWR
+ VPWR g_row\[1\].g_col\[0\].pe__1591_/A sky130_fd_sc_hd__a31oi_2
XFILLER_39_449 VGND VGND VPWR VPWR sky130_fd_sc_hd__fill_2
Xg_row\[0\].g_col\[0\].pe__1700_ g_row\[0\].g_col\[0\].pe__1823_/A g_row\[0\].g_col\[0\].pe__1823_/B
+ g_row\[0\].g_col\[0\].pe__1699_/X VGND VGND VPWR VPWR g_row\[0\].g_col\[0\].pe__1827_/A
+ sky130_fd_sc_hd__a21oi_2
Xg_row\[1\].g_col\[0\].pe__1484_ g_row\[1\].g_col\[0\].pe__1642_/A g_row\[1\].g_col\[0\].pe__1484_/B
+ VGND VGND VPWR VPWR g_row\[1\].g_col\[0\].pe__1514_/A sky130_fd_sc_hd__xnor2_2
XFILLER_54_408 VGND VGND VPWR VPWR sky130_fd_sc_hd__fill_2
Xg_row\[0\].g_col\[0\].pe__2680_ g_row\[0\].g_col\[0\].pe__2680_/A g_row\[0\].g_col\[0\].pe__2680_/B
+ VGND VGND VPWR VPWR g_row\[0\].g_col\[0\].pe__2680_/Y sky130_fd_sc_hd__nand2_2
XFILLER_35_600 VGND VGND VPWR VPWR sky130_fd_sc_hd__fill_1
Xg_row\[0\].g_col\[0\].pe__1631_ g_row\[0\].g_col\[0\].pe__1583_/A g_row\[0\].g_col\[0\].pe__1583_/B
+ g_row\[0\].g_col\[0\].pe__1630_/X VGND VGND VPWR VPWR g_row\[0\].g_col\[0\].pe__1883_/B
+ sky130_fd_sc_hd__a21oi_2
XFILLER_62_430 VGND VGND VPWR VPWR sky130_fd_sc_hd__fill_2
XFILLER_74_290 VGND VGND VPWR VPWR sky130_fd_sc_hd__fill_1
Xg_row\[0\].g_col\[0\].pe__1562_ g_row\[0\].g_col\[0\].pe__1562_/A g_row\[0\].g_col\[0\].pe__1562_/B
+ g_row\[0\].g_col\[0\].pe__1562_/C VGND VGND VPWR VPWR g_row\[0\].g_col\[0\].pe__1563_/B
+ sky130_fd_sc_hd__nor3_2
Xg_row\[1\].g_col\[1\].pe__2121_ g_row\[1\].g_col\[1\].pe__2121_/A g_row\[1\].g_col\[1\].pe__2163_/B
+ VGND VGND VPWR VPWR g_row\[1\].g_col\[1\].pe__2123_/B sky130_fd_sc_hd__nand2_2
Xg_row\[1\].g_col\[0\].pe__2105_ g_row\[1\].g_col\[0\].pe__2104_/A g_row\[1\].g_col\[0\].pe__2104_/B
+ g_row\[1\].g_col\[0\].pe__2104_/C VGND VGND VPWR VPWR g_row\[1\].g_col\[0\].pe__2105_/X
+ sky130_fd_sc_hd__a21o_2
XFILLER_50_614 VGND VGND VPWR VPWR sky130_fd_sc_hd__fill_2
Xg_row\[1\].g_col\[1\].pe__2052_ g_row\[1\].g_col\[1\].pe__2052_/A g_row\[1\].g_col\[1\].pe__2052_/B
+ g_row\[1\].g_col\[1\].pe__2052_/C VGND VGND VPWR VPWR g_row\[1\].g_col\[1\].pe__2054_/A
+ sky130_fd_sc_hd__or3_4
Xg_row\[0\].g_col\[0\].pe__1493_ g_row\[0\].g_col\[0\].pe__1816_/A g_row\[0\].g_col\[0\].pe__1493_/B
+ VGND VGND VPWR VPWR g_row\[0\].g_col\[0\].pe__1536_/A sky130_fd_sc_hd__xor2_2
Xg_row\[1\].g_col\[0\].pe__2036_ g_row\[1\].g_col\[0\].pe__2241_/B2 g_row\[1\].g_col\[0\].pe__1471_/X
+ g_row\[1\].g_col\[0\].pe__2036_/B1 place1090/X VGND VGND VPWR VPWR g_row\[1\].g_col\[0\].pe__2037_/B
+ sky130_fd_sc_hd__a22o_2
XTAP_TAPCELL_ROW_20_506 VGND VPWR sky130_fd_sc_hd__tapvpwrvgnd_1
XTAP_TAPCELL_ROW_20_517 VGND VPWR sky130_fd_sc_hd__tapvpwrvgnd_1
XPHY_EDGE_ROW_6_Right_6 VGND VGND VPWR VPWR sky130_fd_sc_hd__decap_3
Xg_row\[0\].g_col\[0\].pe__2114_ g_row\[0\].g_col\[0\].pe__2395_/A1 g_row\[0\].g_col\[0\].pe__2114_/A2
+ g_row\[0\].g_col\[0\].pe__2112_/Y g_row\[0\].g_col\[0\].pe__2113_/X VGND VGND VPWR
+ VPWR g_row\[0\].g_col\[0\].pe__2114_/X sky130_fd_sc_hd__o22a_2
Xg_row\[0\].g_col\[1\].pe__2130_ g_row\[0\].g_col\[1\].pe__2030_/A g_row\[0\].g_col\[1\].pe__1471_/X
+ g_row\[0\].g_col\[1\].pe__1474_/Y g_row\[0\].g_col\[1\].pe__2241_/A1 VGND VGND VPWR
+ VPWR g_row\[0\].g_col\[1\].pe__2131_/B sky130_fd_sc_hd__a22o_2
Xg_row\[0\].g_col\[1\].pe__2061_ g_row\[0\].g_col\[1\].pe__2062_/A g_row\[0\].g_col\[1\].pe__2062_/C
+ g_row\[0\].g_col\[1\].pe__2150_/C VGND VGND VPWR VPWR g_row\[0\].g_col\[1\].pe__2061_/Y
+ sky130_fd_sc_hd__o21ai_2
Xg_row\[0\].g_col\[0\].pe__2045_ g_row\[0\].g_col\[0\].pe__2045_/A g_row\[0\].g_col\[0\].pe__2045_/B
+ VGND VGND VPWR VPWR g_row\[0\].g_col\[0\].pe__2045_/X sky130_fd_sc_hd__and2_2
Xplace1222 place1223/X VGND VGND VPWR VPWR place1222/X sky130_fd_sc_hd__buf_6
Xplace1233 _275_/Q VGND VGND VPWR VPWR place1233/X sky130_fd_sc_hd__buf_6
Xg_row\[1\].g_col\[1\].pe__1905_ g_row\[1\].g_col\[1\].pe__1905_/A g_row\[1\].g_col\[1\].pe__1905_/B
+ VGND VGND VPWR VPWR g_row\[1\].g_col\[1\].pe__1906_/B sky130_fd_sc_hd__or2_2
Xplace1266 _219_/A VGND VGND VPWR VPWR _235_/A sky130_fd_sc_hd__buf_6
Xplace1277 hold1640/X VGND VGND VPWR VPWR hold1641/A sky130_fd_sc_hd__buf_6
Xg_row\[1\].g_col\[1\].pe__1836_ g_row\[1\].g_col\[1\].pe__2595_/A g_row\[1\].g_col\[1\].pe__1836_/B
+ VGND VGND VPWR VPWR g_row\[1\].g_col\[1\].pe__1836_/X sky130_fd_sc_hd__and2_2
XFILLER_57_202 VGND VGND VPWR VPWR sky130_fd_sc_hd__fill_2
Xg_row\[1\].g_col\[1\].pe__1767_ g_row\[1\].g_col\[1\].pe__2690_/Q g_row\[1\].g_col\[1\].pe__1982_/B
+ VGND VGND VPWR VPWR g_row\[1\].g_col\[1\].pe__1768_/B sky130_fd_sc_hd__nand2_2
XFILLER_66_29 VGND VGND VPWR VPWR sky130_fd_sc_hd__fill_1
Xg_row\[1\].g_col\[1\].pe__1698_ g_row\[1\].g_col\[1\].pe__1698_/A g_row\[1\].g_col\[1\].pe__1699_/B
+ VGND VGND VPWR VPWR g_row\[1\].g_col\[1\].pe__1823_/B sky130_fd_sc_hd__xnor2_2
Xg_row\[0\].g_col\[1\].pe__1914_ g_row\[0\].g_col\[1\].pe__2616_/B g_row\[0\].g_col\[1\].pe__1471_/X
+ g_row\[0\].g_col\[1\].pe__1474_/Y g_row\[0\].g_col\[1\].pe__2138_/B2 VGND VGND VPWR
+ VPWR g_row\[0\].g_col\[1\].pe__1915_/B sky130_fd_sc_hd__a22o_2
XFILLER_45_408 VGND VGND VPWR VPWR sky130_fd_sc_hd__fill_2
Xg_row\[1\].g_col\[0\].pe_hold2892 _305_/Q VGND VGND VPWR VPWR g_row\[1\].g_col\[0\].pe_hold2892/X
+ sky130_fd_sc_hd__clkbuf_2
Xg_row\[1\].g_col\[0\].pe_hold2881 g_row\[1\].g_col\[0\].pe_hold2881/A VGND VGND VPWR
+ VPWR g_row\[1\].g_col\[0\].pe__2677_/A1 sky130_fd_sc_hd__clkbuf_2
XTAP_TAPCELL_ROW_28_628 VGND VPWR sky130_fd_sc_hd__tapvpwrvgnd_1
Xg_row\[0\].g_col\[0\].pe__1829_ g_row\[0\].g_col\[0\].pe__1821_/X g_row\[0\].g_col\[0\].pe__1822_/X
+ g_row\[0\].g_col\[0\].pe__1826_/Y g_row\[0\].g_col\[0\].pe__1827_/Y g_row\[0\].g_col\[0\].pe__1828_/Y
+ VGND VGND VPWR VPWR g_row\[0\].g_col\[0\].pe__1829_/Y sky130_fd_sc_hd__o311ai_2
Xg_row\[0\].g_col\[1\].pe__1845_ g_row\[0\].g_col\[1\].pe__1636_/B g_row\[0\].g_col\[1\].pe__1845_/B
+ VGND VGND VPWR VPWR g_row\[0\].g_col\[1\].pe__1888_/A sky130_fd_sc_hd__and2b_2
Xg_row\[1\].g_col\[1\].pe__2319_ g_row\[1\].g_col\[1\].pe__2319_/A g_row\[1\].g_col\[1\].pe__2319_/B
+ VGND VGND VPWR VPWR g_row\[1\].g_col\[1\].pe__2348_/B sky130_fd_sc_hd__xor2_2
Xg_row\[0\].g_col\[1\].pe__1776_ g_row\[0\].g_col\[1\].pe__1776_/A g_row\[0\].g_col\[1\].pe__1776_/B
+ VGND VGND VPWR VPWR g_row\[0\].g_col\[1\].pe__1777_/B sky130_fd_sc_hd__xor2_2
XFILLER_14_817 VGND VGND VPWR VPWR sky130_fd_sc_hd__fill_1
XFILLER_25_154 VGND VGND VPWR VPWR sky130_fd_sc_hd__decap_3
XFILLER_26_699 VGND VGND VPWR VPWR sky130_fd_sc_hd__fill_1
XFILLER_53_452 VGND VGND VPWR VPWR sky130_fd_sc_hd__decap_3
Xg_row\[1\].g_col\[1\].pe_hold3101 g_row\[1\].g_col\[1\].pe__2733_/Q VGND VGND VPWR
+ VPWR g_row\[1\].g_col\[1\].pe_hold3101/X sky130_fd_sc_hd__clkbuf_2
Xg_row\[0\].g_col\[1\].pe__2328_ g_row\[0\].g_col\[1\].pe__2355_/A g_row\[0\].g_col\[1\].pe__2328_/B
+ VGND VGND VPWR VPWR g_row\[0\].g_col\[1\].pe__2329_/B sky130_fd_sc_hd__or2_2
XFILLER_5_559 VGND VGND VPWR VPWR sky130_fd_sc_hd__fill_1
Xg_row\[0\].g_col\[1\].pe__2259_ g_row\[0\].g_col\[1\].pe__2226_/A g_row\[0\].g_col\[1\].pe__2226_/B
+ g_row\[0\].g_col\[1\].pe__2258_/X VGND VGND VPWR VPWR g_row\[0\].g_col\[1\].pe__2330_/B
+ sky130_fd_sc_hd__a21oi_2
Xg_row\[1\].g_col\[1\].pe_hold1710 g_row\[1\].g_col\[1\].pe__2749_/Q VGND VGND VPWR
+ VPWR g_row\[1\].g_col\[1\].pe__2269_/A sky130_fd_sc_hd__clkbuf_2
XTAP_TAPCELL_ROW_8_331 VGND VPWR sky130_fd_sc_hd__tapvpwrvgnd_1
Xg_row\[1\].g_col\[1\].pe_hold1743 g_row\[1\].g_col\[1\].pe__2592_/X VGND VGND VPWR
+ VPWR g_row\[1\].g_col\[1\].pe__2770_/D sky130_fd_sc_hd__clkbuf_2
XFILLER_0_253 VGND VGND VPWR VPWR sky130_fd_sc_hd__fill_1
Xg_row\[1\].g_col\[1\].pe_hold1776 g_row\[1\].g_col\[1\].pe_hold3091/X VGND VGND VPWR
+ VPWR g_row\[1\].g_col\[1\].pe__1397_/A1 sky130_fd_sc_hd__clkbuf_2
XFILLER_76_533 VGND VGND VPWR VPWR sky130_fd_sc_hd__fill_2
Xhold3170 hold3170/A VGND VGND VPWR VPWR hold3170/X sky130_fd_sc_hd__clkbuf_2
Xhold3181 hold3181/A VGND VGND VPWR VPWR hold3181/X sky130_fd_sc_hd__clkbuf_2
Xhold3192 hold3192/A VGND VGND VPWR VPWR hold3192/X sky130_fd_sc_hd__clkbuf_2
XFILLER_64_717 VGND VGND VPWR VPWR sky130_fd_sc_hd__decap_3
XFILLER_76_577 VGND VGND VPWR VPWR sky130_fd_sc_hd__decap_3
Xhold2480 hold3228/X VGND VGND VPWR VPWR hold3229/A sky130_fd_sc_hd__clkbuf_2
Xhold2491 hold2491/A VGND VGND VPWR VPWR _333_/D sky130_fd_sc_hd__clkbuf_2
XTAP_TAPCELL_ROW_47_915 VGND VPWR sky130_fd_sc_hd__tapvpwrvgnd_1
XFILLER_56_290 VGND VGND VPWR VPWR sky130_fd_sc_hd__decap_3
XTAP_TAPCELL_ROW_67_1220 VGND VPWR sky130_fd_sc_hd__tapvpwrvgnd_1
Xg_row\[0\].g_col\[0\].pe_hold2924 g_row\[0\].g_col\[0\].pe__2635_/C VGND VGND VPWR
+ VPWR g_row\[0\].g_col\[0\].pe__2633_/A2 sky130_fd_sc_hd__clkbuf_2
Xg_row\[0\].g_col\[0\].pe_hold2935 ANTENNA_107/DIODE VGND VGND VPWR VPWR g_row\[0\].g_col\[0\].pe__2622_/A2
+ sky130_fd_sc_hd__clkbuf_2
XPHY_EDGE_ROW_59_Right_59 VGND VGND VPWR VPWR sky130_fd_sc_hd__decap_3
Xg_row\[1\].g_col\[0\].pe__2723_ clkbuf_leaf_43_clk/X g_row\[1\].g_col\[0\].pe__2723_/D
+ VGND VGND VPWR VPWR g_row\[1\].g_col\[0\].pe__2723_/Q sky130_fd_sc_hd__dfxtp_2
XTAP_TAPCELL_ROW_78_1382 VGND VPWR sky130_fd_sc_hd__tapvpwrvgnd_1
Xg_row\[1\].g_col\[1\].pe__2670_ g_row\[1\].g_col\[1\].pe__2670_/A1 hold2088/X g_row\[1\].g_col\[1\].pe__2670_/B1
+ g_row\[1\].g_col\[1\].pe__2670_/C1 VGND VGND VPWR VPWR g_row\[1\].g_col\[1\].pe__2670_/X
+ sky130_fd_sc_hd__o211a_2
XFILLER_87_809 VGND VGND VPWR VPWR sky130_fd_sc_hd__fill_1
Xg_row\[1\].g_col\[1\].pe__1621_ g_row\[1\].g_col\[1\].pe__2686_/A g_row\[1\].g_col\[1\].pe__1621_/B
+ VGND VGND VPWR VPWR g_row\[1\].g_col\[1\].pe__1875_/C sky130_fd_sc_hd__xor2_2
Xg_row\[1\].g_col\[0\].pe__2654_ g_row\[1\].g_col\[0\].pe__1838_/A hold1905/X g_row\[1\].g_col\[0\].pe__2677_/B1
+ g_row\[1\].g_col\[0\].pe__2654_/C1 VGND VGND VPWR VPWR g_row\[1\].g_col\[0\].pe__2654_/X
+ sky130_fd_sc_hd__o211a_2
XTAP_TAPCELL_ROW_91_1571 VGND VPWR sky130_fd_sc_hd__tapvpwrvgnd_1
XTAP_TAPCELL_ROW_91_1582 VGND VPWR sky130_fd_sc_hd__tapvpwrvgnd_1
Xg_row\[1\].g_col\[0\].pe_hold2111 g_row\[1\].g_col\[0\].pe_hold3107/X VGND VGND VPWR
+ VPWR g_row\[1\].g_col\[0\].pe__2063_/B1 sky130_fd_sc_hd__clkbuf_2
Xg_row\[1\].g_col\[0\].pe__2585_ g_row\[1\].g_col\[0\].pe__2585_/A g_row\[1\].g_col\[0\].pe__2585_/B
+ VGND VGND VPWR VPWR g_row\[1\].g_col\[0\].pe__2586_/C sky130_fd_sc_hd__and2_2
Xg_row\[1\].g_col\[0\].pe__1605_ g_row\[1\].g_col\[0\].pe__1860_/A g_row\[1\].g_col\[0\].pe__1605_/B
+ VGND VGND VPWR VPWR g_row\[1\].g_col\[0\].pe__1848_/B sky130_fd_sc_hd__and2_2
XFILLER_39_213 VGND VGND VPWR VPWR sky130_fd_sc_hd__fill_1
XFILLER_79_393 VGND VGND VPWR VPWR sky130_fd_sc_hd__fill_2
XPHY_EDGE_ROW_68_Right_68 VGND VGND VPWR VPWR sky130_fd_sc_hd__decap_3
Xg_row\[1\].g_col\[1\].pe__1552_ g_row\[1\].g_col\[1\].pe__1545_/A g_row\[1\].g_col\[1\].pe__1552_/B
+ VGND VGND VPWR VPWR g_row\[1\].g_col\[1\].pe__1552_/X sky130_fd_sc_hd__and2b_2
Xg_row\[1\].g_col\[0\].pe__1536_ g_row\[1\].g_col\[0\].pe__1536_/A g_row\[1\].g_col\[0\].pe__1536_/B
+ VGND VGND VPWR VPWR g_row\[1\].g_col\[0\].pe__1536_/X sky130_fd_sc_hd__and2_2
Xg_row\[0\].g_col\[0\].pe__2732_ clkbuf_leaf_39_clk/X g_row\[0\].g_col\[0\].pe__2732_/D
+ VGND VGND VPWR VPWR g_row\[0\].g_col\[0\].pe__2732_/Q sky130_fd_sc_hd__dfxtp_2
Xg_row\[1\].g_col\[1\].pe__1483_ g_row\[1\].g_col\[1\].pe__1727_/A1 g_row\[1\].g_col\[1\].pe__2702_/Q
+ g_row\[1\].g_col\[1\].pe__2625_/B g_row\[1\].g_col\[1\].pe__1727_/B2 VGND VGND VPWR
+ VPWR g_row\[1\].g_col\[1\].pe__1484_/B sky130_fd_sc_hd__a22o_2
XFILLER_82_525 VGND VGND VPWR VPWR sky130_fd_sc_hd__decap_3
XFILLER_82_536 VGND VGND VPWR VPWR sky130_fd_sc_hd__decap_3
Xg_row\[0\].g_col\[0\].pe__2663_ g_row\[0\].g_col\[0\].pe__2669_/A hold1889/X VGND
+ VGND VPWR VPWR g_row\[0\].g_col\[0\].pe__2663_/X sky130_fd_sc_hd__or2_2
Xg_row\[0\].g_col\[0\].pe__1614_ g_row\[0\].g_col\[0\].pe__1676_/A g_row\[0\].g_col\[0\].pe__1614_/B
+ VGND VGND VPWR VPWR g_row\[0\].g_col\[0\].pe__1615_/B sky130_fd_sc_hd__xnor2_2
Xg_row\[0\].g_col\[1\].pe__1630_ g_row\[0\].g_col\[1\].pe__1582_/B g_row\[0\].g_col\[1\].pe__1630_/B
+ VGND VGND VPWR VPWR g_row\[0\].g_col\[1\].pe__1630_/X sky130_fd_sc_hd__and2b_2
Xg_row\[1\].g_col\[0\].pe__1398_ hold2069/X g_row\[1\].g_col\[0\].pe__1402_/B VGND
+ VGND VPWR VPWR g_row\[1\].g_col\[0\].pe__1398_/X sky130_fd_sc_hd__or2_2
Xg_row\[0\].g_col\[0\].pe__2594_ g_row\[0\].g_col\[0\].pe__2594_/A1 g_row\[0\].g_col\[0\].pe__2157_/A
+ g_row\[0\].g_col\[0\].pe__2516_/X g_row\[0\].g_col\[0\].pe__2406_/Y g_row\[0\].g_col\[0\].pe__1348_/A
+ VGND VGND VPWR VPWR g_row\[0\].g_col\[0\].pe__2594_/X sky130_fd_sc_hd__a32o_2
XFILLER_35_496 VGND VGND VPWR VPWR sky130_fd_sc_hd__decap_3
Xg_row\[0\].g_col\[0\].pe__1545_ g_row\[0\].g_col\[0\].pe__1545_/A g_row\[0\].g_col\[0\].pe__1552_/B
+ VGND VGND VPWR VPWR g_row\[0\].g_col\[0\].pe__1546_/B sky130_fd_sc_hd__xnor2_2
Xg_row\[0\].g_col\[1\].pe__1561_ g_row\[0\].g_col\[1\].pe__1562_/A g_row\[0\].g_col\[1\].pe__1562_/B
+ g_row\[0\].g_col\[1\].pe__1562_/C VGND VGND VPWR VPWR g_row\[0\].g_col\[1\].pe__1846_/A
+ sky130_fd_sc_hd__o21a_2
Xg_row\[1\].g_col\[1\].pe__2104_ g_row\[1\].g_col\[1\].pe__2104_/A g_row\[1\].g_col\[1\].pe__2104_/B
+ g_row\[1\].g_col\[1\].pe__2104_/C VGND VGND VPWR VPWR g_row\[1\].g_col\[1\].pe__2106_/A
+ sky130_fd_sc_hd__and3_4
XPHY_EDGE_ROW_77_Right_77 VGND VGND VPWR VPWR sky130_fd_sc_hd__decap_3
Xg_row\[0\].g_col\[0\].pe__1476_ g_row\[0\].g_col\[0\].pe__1672_/A1 g_row\[0\].g_col\[0\].pe__1657_/B
+ g_row\[0\].g_col\[0\].pe__2247_/B1 place1223/X VGND VGND VPWR VPWR g_row\[0\].g_col\[0\].pe__1477_/B
+ sky130_fd_sc_hd__a22o_2
Xg_row\[0\].g_col\[1\].pe__1492_ g_row\[0\].g_col\[1\].pe__1727_/A2 g_row\[0\].g_col\[1\].pe__1748_/B
+ g_row\[0\].g_col\[1\].pe__1738_/B1 g_row\[0\].g_col\[1\].pe__1749_/A2 VGND VGND
+ VPWR VPWR g_row\[0\].g_col\[1\].pe__1493_/B sky130_fd_sc_hd__a22o_2
Xg_row\[1\].g_col\[1\].pe__2035_ g_row\[1\].g_col\[1\].pe__2034_/A g_row\[1\].g_col\[1\].pe__2034_/B
+ g_row\[1\].g_col\[1\].pe__2034_/C g_row\[1\].g_col\[1\].pe__2034_/D VGND VGND VPWR
+ VPWR g_row\[1\].g_col\[1\].pe__2038_/B sky130_fd_sc_hd__a22o_2
Xg_row\[1\].g_col\[0\].pe__2019_ g_row\[1\].g_col\[0\].pe__2612_/B g_row\[1\].g_col\[0\].pe__1558_/B
+ g_row\[1\].g_col\[0\].pe__2177_/B1 place1098/A VGND VGND VPWR VPWR g_row\[1\].g_col\[0\].pe__2071_/A
+ sky130_fd_sc_hd__a22o_2
XFILLER_50_499 VGND VGND VPWR VPWR sky130_fd_sc_hd__decap_3
XFILLER_30_190 VGND VGND VPWR VPWR sky130_fd_sc_hd__decap_3
Xg_row\[0\].g_col\[1\].pe__2113_ g_row\[0\].g_col\[1\].pe__2066_/Y g_row\[0\].g_col\[1\].pe__2061_/Y
+ g_row\[0\].g_col\[1\].pe__2111_/X g_row\[0\].g_col\[1\].pe__2404_/B2 VGND VGND VPWR
+ VPWR g_row\[0\].g_col\[1\].pe__2113_/X sky130_fd_sc_hd__a31o_2
Xg_row\[0\].g_col\[0\].pe__2028_ g_row\[0\].g_col\[0\].pe__2167_/A g_row\[0\].g_col\[0\].pe__2028_/B
+ g_row\[0\].g_col\[0\].pe__2028_/C VGND VGND VPWR VPWR g_row\[0\].g_col\[0\].pe__2034_/A
+ sky130_fd_sc_hd__nand3b_2
Xg_row\[0\].g_col\[1\].pe__2044_ g_row\[0\].g_col\[1\].pe__2094_/C g_row\[0\].g_col\[1\].pe__2044_/B
+ VGND VGND VPWR VPWR g_row\[0\].g_col\[1\].pe__2047_/A sky130_fd_sc_hd__and2_2
Xplace1085 place1086/X VGND VGND VPWR VPWR place1085/X sky130_fd_sc_hd__buf_6
XPHY_EDGE_ROW_86_Right_86 VGND VGND VPWR VPWR sky130_fd_sc_hd__decap_3
Xplace1096 hold1950/X VGND VGND VPWR VPWR place1096/X sky130_fd_sc_hd__buf_6
Xg_row\[1\].g_col\[1\].pe__1819_ g_row\[1\].g_col\[1\].pe__1819_/A g_row\[1\].g_col\[1\].pe__1819_/B
+ VGND VGND VPWR VPWR g_row\[1\].g_col\[1\].pe__1820_/A sky130_fd_sc_hd__and2_2
XFILLER_85_385 VGND VGND VPWR VPWR sky130_fd_sc_hd__fill_2
XFILLER_45_249 VGND VGND VPWR VPWR sky130_fd_sc_hd__fill_1
Xg_row\[0\].g_col\[1\].pe__1828_ g_row\[0\].g_col\[1\].pe__1828_/A g_row\[0\].g_col\[1\].pe__1828_/B
+ VGND VGND VPWR VPWR g_row\[0\].g_col\[1\].pe__1828_/Y sky130_fd_sc_hd__nand2_2
XFILLER_14_614 VGND VGND VPWR VPWR sky130_fd_sc_hd__decap_3
XFILLER_13_124 VGND VGND VPWR VPWR sky130_fd_sc_hd__decap_3
XFILLER_41_411 VGND VGND VPWR VPWR sky130_fd_sc_hd__fill_1
XFILLER_53_293 VGND VGND VPWR VPWR sky130_fd_sc_hd__fill_1
Xg_row\[0\].g_col\[1\].pe__1759_ g_row\[0\].g_col\[1\].pe__1774_/A g_row\[0\].g_col\[1\].pe__1774_/B
+ VGND VGND VPWR VPWR g_row\[0\].g_col\[1\].pe__1760_/B sky130_fd_sc_hd__xor2_2
XTAP_TAPCELL_ROW_52_984 VGND VPWR sky130_fd_sc_hd__tapvpwrvgnd_1
XTAP_TAPCELL_ROW_52_995 VGND VPWR sky130_fd_sc_hd__tapvpwrvgnd_1
X_292_ _292_/CLK _292_/D VGND VGND VPWR VPWR _292_/Q sky130_fd_sc_hd__dfxtp_2
XFILLER_21_190 VGND VGND VPWR VPWR sky130_fd_sc_hd__decap_3
XFILLER_6_813 VGND VGND VPWR VPWR sky130_fd_sc_hd__fill_1
XTAP_TAPCELL_ROW_11_369 VGND VPWR sky130_fd_sc_hd__tapvpwrvgnd_1
Xg_row\[1\].g_col\[1\].pe_hold2263 g_row\[1\].g_col\[1\].pe__2641_/X VGND VGND VPWR
+ VPWR g_row\[1\].g_col\[1\].pe__2642_/C1 sky130_fd_sc_hd__clkbuf_2
Xg_row\[1\].g_col\[1\].pe_hold2252 g_row\[1\].g_col\[1\].pe__2647_/X VGND VGND VPWR
+ VPWR g_row\[1\].g_col\[1\].pe__2648_/C1 sky130_fd_sc_hd__clkbuf_2
XFILLER_67_50 VGND VGND VPWR VPWR sky130_fd_sc_hd__fill_2
Xg_row\[1\].g_col\[0\].pe__2370_ g_row\[1\].g_col\[0\].pe__2387_/A g_row\[1\].g_col\[0\].pe__2370_/B
+ VGND VGND VPWR VPWR g_row\[1\].g_col\[0\].pe__2372_/A sky130_fd_sc_hd__and2_2
XFILLER_76_363 VGND VGND VPWR VPWR sky130_fd_sc_hd__fill_1
XFILLER_64_536 VGND VGND VPWR VPWR sky130_fd_sc_hd__decap_3
XFILLER_32_444 VGND VGND VPWR VPWR sky130_fd_sc_hd__decap_3
XFILLER_44_293 VGND VGND VPWR VPWR sky130_fd_sc_hd__fill_1
XFILLER_60_753 VGND VGND VPWR VPWR sky130_fd_sc_hd__decap_3
XFILLER_60_764 VGND VGND VPWR VPWR sky130_fd_sc_hd__decap_3
XFILLER_13_691 VGND VGND VPWR VPWR sky130_fd_sc_hd__decap_3
XTAP_TAPCELL_ROW_30_656 VGND VPWR sky130_fd_sc_hd__tapvpwrvgnd_1
XFILLER_73_3 VGND VGND VPWR VPWR sky130_fd_sc_hd__fill_1
XFILLER_9_673 VGND VGND VPWR VPWR sky130_fd_sc_hd__decap_3
XFILLER_9_695 VGND VGND VPWR VPWR sky130_fd_sc_hd__decap_3
XTAP_TAPCELL_ROW_30_667 VGND VPWR sky130_fd_sc_hd__tapvpwrvgnd_1
XTAP_TAPCELL_ROW_93_1600 VGND VPWR sky130_fd_sc_hd__tapvpwrvgnd_1
XTAP_TAPCELL_ROW_93_1611 VGND VPWR sky130_fd_sc_hd__tapvpwrvgnd_1
XTAP_TAPCELL_ROW_93_1622 VGND VPWR sky130_fd_sc_hd__tapvpwrvgnd_1
Xg_row\[0\].g_col\[0\].pe_place1190 g_row\[0\].g_col\[0\].pe__2724_/Q VGND VGND VPWR
+ VPWR g_row\[0\].g_col\[0\].pe__2045_/B sky130_fd_sc_hd__buf_6
Xg_row\[1\].g_col\[1\].pe__2722_ clkbuf_leaf_85_clk/X g_row\[1\].g_col\[1\].pe__2722_/D
+ VGND VGND VPWR VPWR g_row\[1\].g_col\[1\].pe__2722_/Q sky130_fd_sc_hd__dfxtp_2
Xg_row\[1\].g_col\[0\].pe__2706_ _306_/CLK g_row\[1\].g_col\[0\].pe__2706_/D VGND
+ VGND VPWR VPWR g_row\[1\].g_col\[0\].pe__2706_/Q sky130_fd_sc_hd__dfxtp_2
XFILLER_59_319 VGND VGND VPWR VPWR sky130_fd_sc_hd__fill_1
XFILLER_87_606 VGND VGND VPWR VPWR sky130_fd_sc_hd__decap_3
XFILLER_87_617 VGND VGND VPWR VPWR sky130_fd_sc_hd__fill_2
Xg_row\[1\].g_col\[1\].pe__2653_ g_row\[1\].g_col\[1\].pe__2669_/A g_row\[1\].g_col\[1\].pe__2653_/B
+ VGND VGND VPWR VPWR g_row\[1\].g_col\[1\].pe__2653_/X sky130_fd_sc_hd__or2_2
Xg_row\[1\].g_col\[0\].pe__2637_ _298_/Q g_row\[1\].g_col\[0\].pe__2637_/B _300_/Q
+ _299_/Q VGND VGND VPWR VPWR g_row\[1\].g_col\[0\].pe__2637_/X sky130_fd_sc_hd__or4_2
Xg_row\[1\].g_col\[1\].pe__2584_ g_row\[1\].g_col\[1\].pe__2585_/A g_row\[1\].g_col\[1\].pe__2585_/B
+ VGND VGND VPWR VPWR g_row\[1\].g_col\[1\].pe__2586_/B sky130_fd_sc_hd__nor2_2
Xg_row\[1\].g_col\[1\].pe__1604_ g_row\[1\].g_col\[1\].pe__1604_/A g_row\[1\].g_col\[1\].pe__1604_/B
+ VGND VGND VPWR VPWR g_row\[1\].g_col\[1\].pe__1605_/B sky130_fd_sc_hd__or2_2
Xg_row\[1\].g_col\[1\].pe__1535_ g_row\[1\].g_col\[1\].pe__2736_/Q g_row\[1\].g_col\[1\].pe__1535_/B
+ VGND VGND VPWR VPWR g_row\[1\].g_col\[1\].pe__1546_/A sky130_fd_sc_hd__nand2_2
Xg_row\[1\].g_col\[0\].pe__2568_ g_row\[1\].g_col\[0\].pe__2568_/A1 g_row\[1\].g_col\[0\].pe__2591_/A2
+ g_row\[1\].g_col\[0\].pe__2591_/B1 g_row\[1\].g_col\[0\].pe__2567_/X VGND VGND VPWR
+ VPWR g_row\[1\].g_col\[0\].pe__2568_/X sky130_fd_sc_hd__a22o_2
XFILLER_28_739 VGND VGND VPWR VPWR sky130_fd_sc_hd__fill_1
Xg_row\[1\].g_col\[0\].pe__2499_ g_row\[1\].g_col\[0\].pe__2499_/A g_row\[1\].g_col\[0\].pe__2499_/B
+ VGND VGND VPWR VPWR g_row\[1\].g_col\[0\].pe__2501_/C sky130_fd_sc_hd__nor2_2
Xg_row\[1\].g_col\[0\].pe__1519_ g_row\[1\].g_col\[0\].pe__1730_/A g_row\[1\].g_col\[0\].pe__1519_/B
+ VGND VGND VPWR VPWR g_row\[1\].g_col\[0\].pe__1580_/B sky130_fd_sc_hd__xor2_2
Xg_row\[0\].g_col\[1\].pe__2731_ clkbuf_leaf_90_clk/X g_row\[0\].g_col\[1\].pe__2731_/D
+ VGND VGND VPWR VPWR g_row\[0\].g_col\[1\].pe__2731_/Q sky130_fd_sc_hd__dfxtp_2
Xg_row\[0\].g_col\[0\].pe__2715_ clkbuf_leaf_35_clk/X g_row\[0\].g_col\[0\].pe__2715_/D
+ VGND VGND VPWR VPWR hold3029/A sky130_fd_sc_hd__dfxtp_2
Xg_row\[1\].g_col\[1\].pe__1466_ g_row\[1\].g_col\[1\].pe__2368_/A VGND VGND VPWR
+ VPWR g_row\[1\].g_col\[1\].pe__2348_/A sky130_fd_sc_hd__inv_2
Xg_row\[0\].g_col\[1\].pe_hold2328 g_row\[0\].g_col\[1\].pe__2775_/A VGND VGND VPWR
+ VPWR g_row\[0\].g_col\[1\].pe__2513_/A1 sky130_fd_sc_hd__clkbuf_2
XTAP_TAPCELL_ROW_38_778 VGND VPWR sky130_fd_sc_hd__tapvpwrvgnd_1
Xg_row\[0\].g_col\[0\].pe__2646_ g_row\[0\].g_col\[0\].pe__2656_/A1 g_row\[0\].g_col\[0\].pe__2646_/A2
+ g_row\[0\].g_col\[0\].pe__2687_/C1 g_row\[0\].g_col\[0\].pe__2645_/X VGND VGND VPWR
+ VPWR g_row\[0\].g_col\[0\].pe__2708_/D sky130_fd_sc_hd__o211a_2
Xg_row\[1\].g_col\[1\].pe__1397_ g_row\[1\].g_col\[1\].pe__1397_/A1 g_row\[1\].g_col\[1\].pe__1403_/A2
+ g_row\[1\].g_col\[1\].pe__1396_/X g_row\[1\].g_col\[1\].pe__2640_/C1 VGND VGND VPWR
+ VPWR g_row\[1\].g_col\[1\].pe__1397_/X sky130_fd_sc_hd__o211a_2
Xg_row\[0\].g_col\[1\].pe__2662_ g_row\[0\].g_col\[1\].pe__2670_/A1 g_row\[0\].g_col\[1\].pe__2662_/A2
+ g_row\[0\].g_col\[1\].pe__2670_/B1 g_row\[0\].g_col\[1\].pe__2661_/X VGND VGND VPWR
+ VPWR g_row\[0\].g_col\[1\].pe__2662_/X sky130_fd_sc_hd__o211a_2
XFILLER_63_580 VGND VGND VPWR VPWR sky130_fd_sc_hd__fill_1
XFILLER_70_539 VGND VGND VPWR VPWR sky130_fd_sc_hd__decap_3
Xg_row\[0\].g_col\[0\].pe__2577_ g_row\[0\].g_col\[0\].pe__2592_/A g_row\[0\].g_col\[0\].pe__2577_/B
+ VGND VGND VPWR VPWR g_row\[0\].g_col\[0\].pe__2767_/D sky130_fd_sc_hd__and2_2
Xg_row\[0\].g_col\[1\].pe__1613_ g_row\[0\].g_col\[1\].pe__2073_/B2 g_row\[0\].g_col\[1\].pe__1657_/B
+ g_row\[0\].g_col\[1\].pe__2247_/B1 g_row\[0\].g_col\[1\].pe__2019_/B2 VGND VGND
+ VPWR VPWR g_row\[0\].g_col\[1\].pe__1614_/B sky130_fd_sc_hd__a22o_2
XFILLER_50_241 VGND VGND VPWR VPWR sky130_fd_sc_hd__decap_3
XTAP_TAPCELL_ROW_18_480 VGND VPWR sky130_fd_sc_hd__tapvpwrvgnd_1
Xg_row\[0\].g_col\[0\].pe__1528_ g_row\[0\].g_col\[0\].pe__1864_/A g_row\[0\].g_col\[0\].pe__1528_/B
+ VGND VGND VPWR VPWR g_row\[0\].g_col\[0\].pe__1554_/B sky130_fd_sc_hd__xnor2_2
Xg_row\[0\].g_col\[1\].pe__1544_ g_row\[0\].g_col\[1\].pe__1557_/A g_row\[0\].g_col\[1\].pe__1544_/B
+ VGND VGND VPWR VPWR g_row\[0\].g_col\[1\].pe__1552_/B sky130_fd_sc_hd__xnor2_2
XFILLER_50_263 VGND VGND VPWR VPWR sky130_fd_sc_hd__decap_3
XFILLER_10_127 VGND VGND VPWR VPWR sky130_fd_sc_hd__fill_1
Xg_row\[0\].g_col\[0\].pe__1459_ g_row\[0\].g_col\[0\].pe__2732_/Q g_row\[0\].g_col\[0\].pe__2731_/Q
+ g_row\[0\].g_col\[0\].pe__1460_/B VGND VGND VPWR VPWR g_row\[0\].g_col\[0\].pe__1461_/A
+ sky130_fd_sc_hd__nand3b_2
Xg_row\[1\].g_col\[1\].pe__2018_ g_row\[1\].g_col\[1\].pe__1978_/B g_row\[1\].g_col\[1\].pe__1978_/C
+ g_row\[1\].g_col\[1\].pe__1978_/A VGND VGND VPWR VPWR g_row\[1\].g_col\[1\].pe__2023_/A
+ sky130_fd_sc_hd__o21bai_2
Xg_row\[0\].g_col\[1\].pe__2027_ g_row\[0\].g_col\[1\].pe__1449_/A g_row\[0\].g_col\[1\].pe__1449_/B
+ g_row\[0\].g_col\[1\].pe__1922_/Y VGND VGND VPWR VPWR g_row\[0\].g_col\[1\].pe__2028_/C
+ sky130_fd_sc_hd__a21o_2
XFILLER_78_628 VGND VGND VPWR VPWR sky130_fd_sc_hd__decap_3
XFILLER_58_363 VGND VGND VPWR VPWR sky130_fd_sc_hd__fill_1
XFILLER_74_834 VGND VGND VPWR VPWR sky130_fd_sc_hd__fill_2
XFILLER_46_536 VGND VGND VPWR VPWR sky130_fd_sc_hd__fill_1
XFILLER_46_558 VGND VGND VPWR VPWR sky130_fd_sc_hd__fill_1
XFILLER_61_539 VGND VGND VPWR VPWR sky130_fd_sc_hd__decap_3
Xg_row\[0\].g_col\[0\].pe_hold2006 g_row\[0\].g_col\[0\].pe__1394_/X VGND VGND VPWR
+ VPWR g_row\[0\].g_col\[0\].pe__1395_/B1 sky130_fd_sc_hd__clkbuf_2
Xg_row\[0\].g_col\[0\].pe_hold2017 g_row\[0\].g_col\[0\].pe_hold3041/X VGND VGND VPWR
+ VPWR g_row\[0\].g_col\[0\].pe__1389_/A sky130_fd_sc_hd__clkbuf_2
XFILLER_14_477 VGND VGND VPWR VPWR sky130_fd_sc_hd__fill_2
XFILLER_14_499 VGND VGND VPWR VPWR sky130_fd_sc_hd__fill_2
XFILLER_41_263 VGND VGND VPWR VPWR sky130_fd_sc_hd__fill_1
XTAP_TAPCELL_ROW_60_1109 VGND VPWR sky130_fd_sc_hd__tapvpwrvgnd_1
X_275_ _278_/CLK _275_/D VGND VGND VPWR VPWR _275_/Q sky130_fd_sc_hd__dfxtp_2
XFILLER_10_672 VGND VGND VPWR VPWR sky130_fd_sc_hd__decap_3
XFILLER_6_643 VGND VGND VPWR VPWR sky130_fd_sc_hd__fill_1
Xg_row\[1\].g_col\[0\].pe__1870_ g_row\[1\].g_col\[0\].pe__1870_/A g_row\[1\].g_col\[0\].pe__1870_/B
+ VGND VGND VPWR VPWR g_row\[1\].g_col\[0\].pe__1928_/B sky130_fd_sc_hd__xor2_2
XFILLER_6_698 VGND VGND VPWR VPWR sky130_fd_sc_hd__fill_2
XTAP_TAPCELL_ROW_75_1330 VGND VPWR sky130_fd_sc_hd__tapvpwrvgnd_1
XTAP_TAPCELL_ROW_75_1341 VGND VPWR sky130_fd_sc_hd__tapvpwrvgnd_1
Xg_row\[1\].g_col\[1\].pe_hold2093 g_row\[1\].g_col\[1\].pe__2667_/X VGND VGND VPWR
+ VPWR g_row\[1\].g_col\[1\].pe__2668_/C1 sky130_fd_sc_hd__clkbuf_2
Xg_row\[1\].g_col\[0\].pe__2422_ g_row\[1\].g_col\[0\].pe__2422_/A g_row\[1\].g_col\[0\].pe__2484_/A
+ VGND VGND VPWR VPWR g_row\[1\].g_col\[0\].pe__2424_/B sky130_fd_sc_hd__xnor2_2
XFILLER_68_149 VGND VGND VPWR VPWR sky130_fd_sc_hd__decap_3
Xg_row\[1\].g_col\[0\].pe__2353_ g_row\[1\].g_col\[0\].pe__2375_/A g_row\[1\].g_col\[0\].pe__2353_/B
+ VGND VGND VPWR VPWR g_row\[1\].g_col\[0\].pe__2355_/B sky130_fd_sc_hd__nor2_2
XFILLER_49_396 VGND VGND VPWR VPWR sky130_fd_sc_hd__decap_3
Xg_row\[1\].g_col\[0\].pe__2284_ g_row\[1\].g_col\[0\].pe__2284_/A g_row\[1\].g_col\[0\].pe__2284_/B
+ VGND VGND VPWR VPWR g_row\[1\].g_col\[0\].pe__2285_/B sky130_fd_sc_hd__nor2_2
XFILLER_80_804 VGND VGND VPWR VPWR sky130_fd_sc_hd__fill_2
XFILLER_91_141 VGND VGND VPWR VPWR sky130_fd_sc_hd__fill_2
Xg_row\[0\].g_col\[0\].pe__2500_ g_row\[0\].g_col\[0\].pe__2464_/X g_row\[0\].g_col\[0\].pe__2538_/B
+ VGND VGND VPWR VPWR g_row\[0\].g_col\[0\].pe__2533_/B sky130_fd_sc_hd__and2b_2
XTAP_TAPCELL_ROW_35_737 VGND VPWR sky130_fd_sc_hd__tapvpwrvgnd_1
Xg_row\[0\].g_col\[0\].pe__2431_ g_row\[0\].g_col\[0\].pe__2476_/B g_row\[0\].g_col\[0\].pe__2767_/Q
+ VGND VGND VPWR VPWR g_row\[0\].g_col\[0\].pe__2579_/B sky130_fd_sc_hd__or2b_2
Xg_row\[0\].g_col\[0\].pe__2293_ g_row\[0\].g_col\[0\].pe__2295_/A g_row\[0\].g_col\[0\].pe__2295_/B
+ g_row\[0\].g_col\[0\].pe__2292_/X VGND VGND VPWR VPWR g_row\[0\].g_col\[0\].pe__2294_/A
+ sky130_fd_sc_hd__o21ba_2
Xg_row\[0\].g_col\[0\].pe_hold1883 g_row\[0\].g_col\[0\].pe__2360_/X VGND VGND VPWR
+ VPWR g_row\[0\].g_col\[0\].pe__2361_/B sky130_fd_sc_hd__clkbuf_2
Xg_row\[1\].g_col\[0\].pe__1999_ g_row\[1\].g_col\[0\].pe__1999_/A g_row\[1\].g_col\[0\].pe__1999_/B
+ VGND VGND VPWR VPWR g_row\[1\].g_col\[0\].pe__1999_/X sky130_fd_sc_hd__or2_2
Xg_row\[1\].g_col\[1\].pe__2705_ clkload17/A g_row\[1\].g_col\[1\].pe__2705_/D VGND
+ VGND VPWR VPWR g_row\[1\].g_col\[1\].pe__2774_/A sky130_fd_sc_hd__dfxtp_2
Xg_row\[1\].g_col\[1\].pe__2636_ place1104/X place1106/X place1099/X place1102/X VGND
+ VGND VPWR VPWR g_row\[1\].g_col\[1\].pe__2636_/X sky130_fd_sc_hd__or4_2
Xg_row\[1\].g_col\[1\].pe__2567_ g_row\[1\].g_col\[1\].pe__2567_/A g_row\[1\].g_col\[1\].pe__2590_/A
+ VGND VGND VPWR VPWR g_row\[1\].g_col\[1\].pe__2567_/X sky130_fd_sc_hd__or2_2
XFILLER_74_29 VGND VGND VPWR VPWR sky130_fd_sc_hd__fill_2
Xg_row\[1\].g_col\[1\].pe__2498_ g_row\[1\].g_col\[1\].pe__2519_/A g_row\[1\].g_col\[1\].pe__2519_/B
+ VGND VGND VPWR VPWR g_row\[1\].g_col\[1\].pe__2499_/B sky130_fd_sc_hd__or2_2
Xg_row\[1\].g_col\[1\].pe__1518_ g_row\[1\].g_col\[1\].pe__1970_/A g_row\[1\].g_col\[1\].pe__1729_/A2
+ g_row\[1\].g_col\[1\].pe__1729_/A3 g_row\[1\].g_col\[1\].pe__1729_/B1 g_row\[1\].g_col\[1\].pe__2625_/B
+ VGND VGND VPWR VPWR g_row\[1\].g_col\[1\].pe__1519_/B sky130_fd_sc_hd__a32o_2
XFILLER_70_303 VGND VGND VPWR VPWR sky130_fd_sc_hd__fill_1
XFILLER_82_141 VGND VGND VPWR VPWR sky130_fd_sc_hd__fill_2
Xg_row\[1\].g_col\[1\].pe__1449_ g_row\[1\].g_col\[1\].pe__1449_/A g_row\[1\].g_col\[1\].pe__1449_/B
+ VGND VGND VPWR VPWR g_row\[1\].g_col\[1\].pe__1449_/Y sky130_fd_sc_hd__nand2_2
Xg_row\[0\].g_col\[1\].pe_hold2169 g_row\[0\].g_col\[1\].pe__2648_/X VGND VGND VPWR
+ VPWR g_row\[0\].g_col\[1\].pe__2709_/D sky130_fd_sc_hd__clkbuf_2
Xg_row\[0\].g_col\[1\].pe_hold2158 g_row\[0\].g_col\[1\].pe__2668_/X VGND VGND VPWR
+ VPWR g_row\[0\].g_col\[1\].pe__2719_/D sky130_fd_sc_hd__clkbuf_2
Xg_row\[0\].g_col\[1\].pe_hold2147 g_row\[0\].g_col\[1\].pe__2674_/A VGND VGND VPWR
+ VPWR g_row\[0\].g_col\[1\].pe__2652_/A2 sky130_fd_sc_hd__clkbuf_2
Xg_row\[0\].g_col\[1\].pe_hold2136 g_row\[0\].g_col\[1\].pe_hold2969/X VGND VGND VPWR
+ VPWR g_row\[0\].g_col\[1\].pe__2710_/D sky130_fd_sc_hd__clkbuf_2
Xg_row\[0\].g_col\[1\].pe__2714_ _333_/CLK g_row\[0\].g_col\[1\].pe__2714_/D VGND
+ VGND VPWR VPWR hold3114/A sky130_fd_sc_hd__dfxtp_2
XFILLER_36_580 VGND VGND VPWR VPWR sky130_fd_sc_hd__decap_3
XFILLER_71_837 VGND VGND VPWR VPWR sky130_fd_sc_hd__decap_3
Xg_row\[0\].g_col\[1\].pe__2645_ g_row\[0\].g_col\[1\].pe__2661_/A hold2119/X VGND
+ VGND VPWR VPWR g_row\[0\].g_col\[1\].pe__2645_/X sky130_fd_sc_hd__or2_2
XFILLER_23_263 VGND VGND VPWR VPWR sky130_fd_sc_hd__fill_1
XTAP_TAPCELL_ROW_13_409 VGND VPWR sky130_fd_sc_hd__tapvpwrvgnd_1
Xg_row\[0\].g_col\[1\].pe__2576_ g_row\[0\].g_col\[1\].pe__2576_/A1 g_row\[0\].g_col\[1\].pe__2587_/A2
+ g_row\[0\].g_col\[1\].pe__2517_/Y g_row\[0\].g_col\[1\].pe__2575_/X VGND VGND VPWR
+ VPWR g_row\[0\].g_col\[1\].pe__2576_/X sky130_fd_sc_hd__a22o_2
XFILLER_11_447 VGND VGND VPWR VPWR sky130_fd_sc_hd__fill_1
Xg_row\[0\].g_col\[1\].pe__1527_ g_row\[0\].g_col\[1\].pe__2073_/B2 g_row\[0\].g_col\[1\].pe__1457_/X
+ g_row\[0\].g_col\[1\].pe__1863_/B1 g_row\[0\].g_col\[1\].pe__2019_/B2 VGND VGND
+ VPWR VPWR g_row\[0\].g_col\[1\].pe__1528_/B sky130_fd_sc_hd__a22o_2
XFILLER_3_602 VGND VGND VPWR VPWR sky130_fd_sc_hd__decap_3
Xg_row\[0\].g_col\[1\].pe__1389_ g_row\[0\].g_col\[1\].pe__1389_/A g_row\[0\].g_col\[1\].pe__1389_/B
+ VGND VGND VPWR VPWR g_row\[0\].g_col\[1\].pe__1389_/X sky130_fd_sc_hd__or2_2
XFILLER_3_624 VGND VGND VPWR VPWR sky130_fd_sc_hd__decap_3
Xg_row\[0\].g_col\[0\].pe_place865 g_row\[0\].g_col\[0\].pe__2010_/A VGND VGND VPWR
+ VPWR g_row\[0\].g_col\[0\].pe__2394_/B1 sky130_fd_sc_hd__buf_6
XFILLER_3_679 VGND VGND VPWR VPWR sky130_fd_sc_hd__fill_2
XTAP_TAPCELL_ROW_57_1060 VGND VPWR sky130_fd_sc_hd__tapvpwrvgnd_1
XTAP_TAPCELL_ROW_57_1071 VGND VPWR sky130_fd_sc_hd__tapvpwrvgnd_1
XTAP_TAPCELL_ROW_70_1260 VGND VPWR sky130_fd_sc_hd__tapvpwrvgnd_1
XFILLER_48_96 VGND VGND VPWR VPWR sky130_fd_sc_hd__fill_2
XFILLER_74_631 VGND VGND VPWR VPWR sky130_fd_sc_hd__fill_2
XFILLER_19_558 VGND VGND VPWR VPWR sky130_fd_sc_hd__fill_2
XFILLER_46_344 VGND VGND VPWR VPWR sky130_fd_sc_hd__fill_1
XFILLER_27_580 VGND VGND VPWR VPWR sky130_fd_sc_hd__fill_1
XFILLER_74_686 VGND VGND VPWR VPWR sky130_fd_sc_hd__decap_3
XFILLER_73_196 VGND VGND VPWR VPWR sky130_fd_sc_hd__decap_3
XPHY_EDGE_ROW_85_Left_179 VGND VGND VPWR VPWR sky130_fd_sc_hd__decap_3
XFILLER_30_701 VGND VGND VPWR VPWR sky130_fd_sc_hd__fill_1
X_327_ _327_/CLK _327_/D VGND VGND VPWR VPWR _327_/Q sky130_fd_sc_hd__dfxtp_2
Xg_row\[1\].g_col\[0\].pe__1922_ place1082/X VGND VGND VPWR VPWR g_row\[1\].g_col\[0\].pe__1922_/Y
+ sky130_fd_sc_hd__inv_2
XFILLER_6_451 VGND VGND VPWR VPWR sky130_fd_sc_hd__fill_2
X_189_ _189_/A _189_/B_N VGND VGND VPWR VPWR _189_/Y sky130_fd_sc_hd__nor2b_4
Xg_row\[1\].g_col\[0\].pe__1853_ g_row\[1\].g_col\[0\].pe__2605_/B g_row\[1\].g_col\[0\].pe__1901_/A2
+ g_row\[1\].g_col\[0\].pe__2177_/B1 g_row\[1\].g_col\[0\].pe__2603_/B VGND VGND VPWR
+ VPWR g_row\[1\].g_col\[0\].pe__1857_/A sky130_fd_sc_hd__a22o_2
XFILLER_89_81 VGND VGND VPWR VPWR sky130_fd_sc_hd__decap_3
Xg_row\[1\].g_col\[0\].pe__1784_ place1106/A g_row\[1\].g_col\[0\].pe__1414_/X g_row\[1\].g_col\[0\].pe__1415_/Y
+ g_row\[1\].g_col\[0\].pe__1801_/B place1104/X VGND VGND VPWR VPWR g_row\[1\].g_col\[0\].pe__1785_/B
+ sky130_fd_sc_hd__a32o_2
Xg_row\[0\].g_col\[0\].pe__1931_ g_row\[0\].g_col\[0\].pe__1931_/A g_row\[0\].g_col\[0\].pe__1931_/B
+ VGND VGND VPWR VPWR g_row\[0\].g_col\[0\].pe__1999_/A sky130_fd_sc_hd__xnor2_2
Xhold1608 hold2754/X VGND VGND VPWR VPWR hold2755/A sky130_fd_sc_hd__clkbuf_2
Xg_row\[0\].g_col\[0\].pe__1862_ g_row\[0\].g_col\[0\].pe__1910_/A g_row\[0\].g_col\[0\].pe__1862_/B
+ VGND VGND VPWR VPWR g_row\[0\].g_col\[0\].pe__1899_/A sky130_fd_sc_hd__xor2_2
Xhold1619 hold3570/X VGND VGND VPWR VPWR hold2789/A sky130_fd_sc_hd__clkbuf_2
Xg_row\[1\].g_col\[1\].pe__2421_ g_row\[1\].g_col\[1\].pe__2450_/A1 g_row\[1\].g_col\[1\].pe__2752_/Q
+ g_row\[1\].g_col\[1\].pe__2426_/B VGND VGND VPWR VPWR g_row\[1\].g_col\[1\].pe__2484_/A
+ sky130_fd_sc_hd__a21o_2
Xg_row\[1\].g_col\[0\].pe__2405_ place1268/X g_row\[1\].g_col\[0\].pe__2405_/B VGND
+ VGND VPWR VPWR g_row\[1\].g_col\[0\].pe__2755_/D sky130_fd_sc_hd__nor2_2
XFILLER_49_160 VGND VGND VPWR VPWR sky130_fd_sc_hd__fill_1
XFILLER_65_620 VGND VGND VPWR VPWR sky130_fd_sc_hd__fill_1
XTAP_TAPCELL_ROW_88_1532 VGND VPWR sky130_fd_sc_hd__tapvpwrvgnd_1
Xg_row\[0\].g_col\[0\].pe__1793_ g_row\[0\].g_col\[0\].pe__1793_/A g_row\[0\].g_col\[0\].pe__1793_/B
+ g_row\[0\].g_col\[0\].pe__1793_/C VGND VGND VPWR VPWR g_row\[0\].g_col\[0\].pe__1794_/B
+ sky130_fd_sc_hd__and3_2
Xg_row\[1\].g_col\[1\].pe__2352_ g_row\[1\].g_col\[1\].pe__2352_/A g_row\[1\].g_col\[1\].pe__2352_/B
+ g_row\[1\].g_col\[1\].pe__2352_/C VGND VGND VPWR VPWR g_row\[1\].g_col\[1\].pe__2353_/B
+ sky130_fd_sc_hd__and3_2
Xg_row\[1\].g_col\[0\].pe__2336_ g_row\[1\].g_col\[0\].pe__2336_/A VGND VGND VPWR
+ VPWR g_row\[1\].g_col\[0\].pe__2336_/Y sky130_fd_sc_hd__inv_2
XFILLER_37_399 VGND VGND VPWR VPWR sky130_fd_sc_hd__fill_1
Xg_row\[1\].g_col\[1\].pe__2283_ g_row\[1\].g_col\[1\].pe__2283_/A g_row\[1\].g_col\[1\].pe__2283_/B
+ VGND VGND VPWR VPWR g_row\[1\].g_col\[1\].pe__2284_/B sky130_fd_sc_hd__and2_2
Xg_row\[1\].g_col\[0\].pe__2267_ g_row\[1\].g_col\[0\].pe__2264_/X g_row\[1\].g_col\[0\].pe__2265_/Y
+ g_row\[1\].g_col\[0\].pe__2267_/B1 g_row\[1\].g_col\[0\].pe__2404_/A1 VGND VGND
+ VPWR VPWR g_row\[1\].g_col\[0\].pe__2268_/B sky130_fd_sc_hd__o2bb2a_2
XFILLER_52_336 VGND VGND VPWR VPWR sky130_fd_sc_hd__fill_1
Xg_row\[1\].g_col\[0\].pe_place1113 g_row\[1\].g_col\[0\].pe__2592_/A VGND VGND VPWR
+ VPWR g_row\[1\].g_col\[0\].pe__2679_/C1 sky130_fd_sc_hd__buf_6
Xg_row\[1\].g_col\[0\].pe__2198_ g_row\[1\].g_col\[0\].pe__2404_/A1 g_row\[1\].g_col\[0\].pe__2198_/A2
+ g_row\[1\].g_col\[0\].pe__2196_/X g_row\[1\].g_col\[0\].pe__2197_/Y VGND VGND VPWR
+ VPWR g_row\[1\].g_col\[0\].pe__2198_/X sky130_fd_sc_hd__o22a_2
Xg_row\[0\].g_col\[1\].pe__2430_ g_row\[0\].g_col\[1\].pe__2430_/A g_row\[0\].g_col\[1\].pe__2430_/B
+ VGND VGND VPWR VPWR g_row\[0\].g_col\[1\].pe__2476_/B sky130_fd_sc_hd__xnor2_2
XFILLER_33_561 VGND VGND VPWR VPWR sky130_fd_sc_hd__fill_2
Xg_row\[0\].g_col\[0\].pe__2414_ g_row\[0\].g_col\[0\].pe__2754_/Q ANTENNA_144/DIODE
+ g_row\[0\].g_col\[0\].pe__2441_/B VGND VGND VPWR VPWR g_row\[0\].g_col\[0\].pe__2439_/B
+ sky130_fd_sc_hd__o21ai_2
XFILLER_21_734 VGND VGND VPWR VPWR sky130_fd_sc_hd__fill_1
Xg_row\[0\].g_col\[0\].pe__2345_ g_row\[0\].g_col\[0\].pe__2345_/A g_row\[0\].g_col\[0\].pe__2345_/B
+ VGND VGND VPWR VPWR g_row\[0\].g_col\[0\].pe__2346_/B sky130_fd_sc_hd__or2_2
Xg_row\[0\].g_col\[1\].pe_place940 g_row\[0\].g_col\[1\].pe__2591_/A2 VGND VGND VPWR
+ VPWR g_row\[0\].g_col\[1\].pe__2587_/A2 sky130_fd_sc_hd__buf_6
Xg_row\[0\].g_col\[1\].pe__2361_ g_row\[0\].g_col\[1\].pe__2405_/A g_row\[0\].g_col\[1\].pe__2361_/B
+ VGND VGND VPWR VPWR g_row\[0\].g_col\[1\].pe__2751_/D sky130_fd_sc_hd__nor2_2
XFILLER_21_789 VGND VGND VPWR VPWR sky130_fd_sc_hd__fill_2
Xg_row\[0\].g_col\[1\].pe_place962 g_row\[0\].g_col\[1\].pe__2633_/A1 VGND VGND VPWR
+ VPWR g_row\[0\].g_col\[1\].pe__2668_/A1 sky130_fd_sc_hd__buf_6
Xg_row\[0\].g_col\[1\].pe_place951 g_row\[0\].g_col\[1\].pe__2165_/A VGND VGND VPWR
+ VPWR g_row\[0\].g_col\[1\].pe__1864_/A sky130_fd_sc_hd__buf_6
Xg_row\[0\].g_col\[1\].pe__2292_ g_row\[0\].g_col\[1\].pe__2292_/A g_row\[0\].g_col\[1\].pe__2327_/B
+ VGND VGND VPWR VPWR g_row\[0\].g_col\[1\].pe__2292_/X sky130_fd_sc_hd__or2_2
Xg_row\[0\].g_col\[0\].pe__2276_ g_row\[0\].g_col\[0\].pe__2318_/A g_row\[0\].g_col\[0\].pe__2276_/B
+ VGND VGND VPWR VPWR g_row\[0\].g_col\[0\].pe__2286_/A sky130_fd_sc_hd__and2b_2
Xg_row\[1\].g_col\[1\].pe_hold2829 g_row\[1\].g_col\[1\].pe_hold2829/A VGND VGND VPWR
+ VPWR g_row\[1\].g_col\[1\].pe__2720_/D sky130_fd_sc_hd__clkbuf_2
Xhold3500 hold3500/A VGND VGND VPWR VPWR hold3500/X sky130_fd_sc_hd__clkbuf_2
Xg_row\[1\].g_col\[1\].pe__1998_ g_row\[1\].g_col\[1\].pe__1999_/A g_row\[1\].g_col\[1\].pe__1999_/B
+ VGND VGND VPWR VPWR g_row\[1\].g_col\[1\].pe__1998_/X sky130_fd_sc_hd__and2_2
Xhold3533 hold3533/A VGND VGND VPWR VPWR hold3533/X sky130_fd_sc_hd__clkbuf_2
Xhold3522 a_inputs_flat[27] VGND VGND VPWR VPWR hold3522/X sky130_fd_sc_hd__clkbuf_2
Xhold3511 hold3511/A VGND VGND VPWR VPWR hold3511/X sky130_fd_sc_hd__clkbuf_2
Xhold2810 hold3571/X VGND VGND VPWR VPWR hold3572/A sky130_fd_sc_hd__clkbuf_2
Xhold3577 a_inputs_flat[28] VGND VGND VPWR VPWR hold3577/X sky130_fd_sc_hd__clkbuf_2
Xhold3566 hold3566/A VGND VGND VPWR VPWR hold3566/X sky130_fd_sc_hd__clkbuf_2
Xhold3555 hold3555/A VGND VGND VPWR VPWR hold3555/X sky130_fd_sc_hd__clkbuf_2
Xhold3544 hold3544/A VGND VGND VPWR VPWR hold3544/X sky130_fd_sc_hd__clkbuf_2
Xhold3588 hold3588/A VGND VGND VPWR VPWR hold3588/X sky130_fd_sc_hd__clkbuf_2
Xg_row\[1\].g_col\[1\].pe__2619_ g_row\[1\].g_col\[1\].pe__2626_/A1 place1089/X g_row\[1\].g_col\[1\].pe__2626_/B1
+ g_row\[1\].g_col\[1\].pe__2619_/C1 VGND VGND VPWR VPWR g_row\[1\].g_col\[1\].pe__2698_/D
+ sky130_fd_sc_hd__o211a_2
XFILLER_16_539 VGND VGND VPWR VPWR sky130_fd_sc_hd__fill_2
XFILLER_70_122 VGND VGND VPWR VPWR sky130_fd_sc_hd__fill_1
XFILLER_12_701 VGND VGND VPWR VPWR sky130_fd_sc_hd__decap_3
XFILLER_24_572 VGND VGND VPWR VPWR sky130_fd_sc_hd__fill_2
Xg_row\[0\].g_col\[1\].pe__2628_ g_row\[0\].g_col\[1\].pe__2633_/A1 g_row\[0\].g_col\[1\].pe__2628_/A2
+ g_row\[0\].g_col\[1\].pe__2381_/A g_row\[0\].g_col\[1\].pe__2627_/X VGND VGND VPWR
+ VPWR g_row\[0\].g_col\[1\].pe__2702_/D sky130_fd_sc_hd__o211a_2
XFILLER_11_222 VGND VGND VPWR VPWR sky130_fd_sc_hd__fill_2
XFILLER_24_583 VGND VGND VPWR VPWR sky130_fd_sc_hd__decap_3
XFILLER_51_391 VGND VGND VPWR VPWR sky130_fd_sc_hd__fill_1
Xg_row\[0\].g_col\[1\].pe_place1123 g_row\[0\].g_col\[1\].pe__1459_/C VGND VGND VPWR
+ VPWR g_row\[0\].g_col\[1\].pe__2167_/A sky130_fd_sc_hd__buf_6
Xg_row\[0\].g_col\[1\].pe__2559_ g_row\[0\].g_col\[1\].pe__2559_/A g_row\[0\].g_col\[1\].pe__2559_/B
+ VGND VGND VPWR VPWR g_row\[0\].g_col\[1\].pe__2559_/X sky130_fd_sc_hd__or2_2
Xg_row\[0\].g_col\[1\].pe_place1167 g_row\[0\].g_col\[1\].pe__2626_/B1 VGND VGND VPWR
+ VPWR g_row\[0\].g_col\[1\].pe__2381_/A sky130_fd_sc_hd__buf_6
Xg_row\[0\].g_col\[1\].pe_place1156 g_row\[0\].g_col\[1\].pe__2694_/Q VGND VGND VPWR
+ VPWR g_row\[0\].g_col\[1\].pe__2019_/B2 sky130_fd_sc_hd__buf_6
Xg_row\[0\].g_col\[1\].pe_place1145 g_row\[0\].g_col\[1\].pe__2699_/Q VGND VGND VPWR
+ VPWR g_row\[0\].g_col\[1\].pe__2621_/B sky130_fd_sc_hd__buf_6
Xg_row\[0\].g_col\[1\].pe_place1134 g_row\[0\].g_col\[1\].pe__2723_/Q VGND VGND VPWR
+ VPWR g_row\[0\].g_col\[1\].pe__1804_/A sky130_fd_sc_hd__buf_6
XTAP_TAPCELL_ROW_59_1100 VGND VPWR sky130_fd_sc_hd__tapvpwrvgnd_1
XFILLER_59_491 VGND VGND VPWR VPWR sky130_fd_sc_hd__fill_1
XFILLER_93_247 VGND VGND VPWR VPWR sky130_fd_sc_hd__fill_1
Xg_row\[1\].g_col\[0\].pe_hold1839 g_row\[1\].g_col\[0\].pe__2638_/X VGND VGND VPWR
+ VPWR g_row\[1\].g_col\[0\].pe__2640_/A2 sky130_fd_sc_hd__clkbuf_2
Xg_row\[1\].g_col\[0\].pe_hold1828 g_row\[1\].g_col\[0\].pe__2548_/X VGND VGND VPWR
+ VPWR g_row\[1\].g_col\[0\].pe__2549_/B sky130_fd_sc_hd__clkbuf_2
XFILLER_62_601 VGND VGND VPWR VPWR sky130_fd_sc_hd__fill_1
Xg_row\[1\].g_col\[0\].pe__2121_ g_row\[1\].g_col\[0\].pe__2121_/A g_row\[1\].g_col\[0\].pe__2163_/B
+ VGND VGND VPWR VPWR g_row\[1\].g_col\[0\].pe__2123_/B sky130_fd_sc_hd__nand2_2
XFILLER_34_347 VGND VGND VPWR VPWR sky130_fd_sc_hd__decap_3
XFILLER_61_111 VGND VGND VPWR VPWR sky130_fd_sc_hd__fill_1
XFILLER_62_645 VGND VGND VPWR VPWR sky130_fd_sc_hd__fill_1
XFILLER_62_667 VGND VGND VPWR VPWR sky130_fd_sc_hd__decap_3
Xg_row\[1\].g_col\[0\].pe__2052_ g_row\[1\].g_col\[0\].pe__2052_/A g_row\[1\].g_col\[0\].pe__2052_/B
+ g_row\[1\].g_col\[0\].pe__2052_/C VGND VGND VPWR VPWR g_row\[1\].g_col\[0\].pe__2054_/A
+ sky130_fd_sc_hd__or3_4
XTAP_TAPCELL_ROW_45_887 VGND VPWR sky130_fd_sc_hd__tapvpwrvgnd_1
XTAP_TAPCELL_ROW_83_1451 VGND VPWR sky130_fd_sc_hd__tapvpwrvgnd_1
XTAP_TAPCELL_ROW_83_1462 VGND VPWR sky130_fd_sc_hd__tapvpwrvgnd_1
XFILLER_30_531 VGND VGND VPWR VPWR sky130_fd_sc_hd__fill_1
Xg_row\[0\].g_col\[0\].pe__2130_ g_row\[0\].g_col\[0\].pe__2030_/A g_row\[0\].g_col\[0\].pe__1471_/X
+ g_row\[0\].g_col\[0\].pe__1474_/Y g_row\[0\].g_col\[0\].pe__1970_/A VGND VGND VPWR
+ VPWR g_row\[0\].g_col\[0\].pe__2131_/B sky130_fd_sc_hd__a22o_2
XFILLER_30_586 VGND VGND VPWR VPWR sky130_fd_sc_hd__fill_2
Xg_row\[0\].g_col\[0\].pe__2061_ g_row\[0\].g_col\[0\].pe__2062_/A g_row\[0\].g_col\[0\].pe__2062_/C
+ g_row\[0\].g_col\[0\].pe__2150_/C VGND VGND VPWR VPWR g_row\[0\].g_col\[0\].pe__2061_/Y
+ sky130_fd_sc_hd__o21ai_2
Xg_row\[1\].g_col\[1\].pe__1921_ g_row\[1\].g_col\[1\].pe__2703_/Q g_row\[1\].g_col\[1\].pe__1982_/B
+ VGND VGND VPWR VPWR g_row\[1\].g_col\[1\].pe__1924_/B sky130_fd_sc_hd__and2_2
Xg_row\[1\].g_col\[0\].pe__1905_ g_row\[1\].g_col\[0\].pe__1905_/A g_row\[1\].g_col\[0\].pe__1905_/B
+ VGND VGND VPWR VPWR g_row\[1\].g_col\[0\].pe__1906_/B sky130_fd_sc_hd__or2_2
XFILLER_7_782 VGND VGND VPWR VPWR sky130_fd_sc_hd__fill_2
Xg_row\[1\].g_col\[1\].pe__1852_ g_row\[1\].g_col\[1\].pe__1615_/A g_row\[1\].g_col\[1\].pe__1615_/B
+ g_row\[1\].g_col\[1\].pe__1851_/X VGND VGND VPWR VPWR g_row\[1\].g_col\[1\].pe__1859_/A
+ sky130_fd_sc_hd__a21o_2
Xg_row\[1\].g_col\[0\].pe__1836_ g_row\[1\].g_col\[0\].pe__2561_/A g_row\[1\].g_col\[0\].pe__1836_/B
+ VGND VGND VPWR VPWR g_row\[1\].g_col\[0\].pe__1836_/X sky130_fd_sc_hd__and2_2
Xg_row\[1\].g_col\[1\].pe__1783_ g_row\[1\].g_col\[1\].pe__1808_/A g_row\[1\].g_col\[1\].pe__1783_/B
+ VGND VGND VPWR VPWR g_row\[1\].g_col\[1\].pe__1796_/A sky130_fd_sc_hd__xnor2_2
Xg_row\[1\].g_col\[0\].pe__1767_ place1106/A g_row\[1\].g_col\[0\].pe__1982_/B VGND
+ VGND VPWR VPWR g_row\[1\].g_col\[0\].pe__1768_/B sky130_fd_sc_hd__nand2_2
XFILLER_85_704 VGND VGND VPWR VPWR sky130_fd_sc_hd__decap_3
XFILLER_85_726 VGND VGND VPWR VPWR sky130_fd_sc_hd__fill_2
Xg_row\[0\].g_col\[0\].pe__1914_ place1208/X g_row\[0\].g_col\[0\].pe__1657_/B g_row\[0\].g_col\[0\].pe__2247_/B1
+ place1210/A VGND VGND VPWR VPWR g_row\[0\].g_col\[0\].pe__1915_/B sky130_fd_sc_hd__a22o_2
Xhold2139 hold3057/X VGND VGND VPWR VPWR hold2139/X sky130_fd_sc_hd__clkbuf_2
Xg_row\[1\].g_col\[0\].pe__1698_ g_row\[1\].g_col\[0\].pe__1698_/A g_row\[1\].g_col\[0\].pe__1699_/B
+ VGND VGND VPWR VPWR g_row\[1\].g_col\[0\].pe__1823_/B sky130_fd_sc_hd__xnor2_2
Xg_row\[0\].g_col\[1\].pe__1930_ g_row\[0\].g_col\[1\].pe__1994_/A g_row\[0\].g_col\[1\].pe__1994_/B
+ VGND VGND VPWR VPWR g_row\[0\].g_col\[1\].pe__1931_/B sky130_fd_sc_hd__xor2_2
Xhold1438 hold3145/X VGND VGND VPWR VPWR hold3146/A sky130_fd_sc_hd__clkbuf_2
Xhold1449 hold2448/X VGND VGND VPWR VPWR hold2449/A sky130_fd_sc_hd__clkbuf_2
Xg_row\[1\].g_col\[1\].pe__2404_ g_row\[1\].g_col\[1\].pe__2404_/A1 g_row\[1\].g_col\[1\].pe__2403_/Y
+ g_row\[1\].g_col\[1\].pe__2404_/B1 g_row\[1\].g_col\[1\].pe__2010_/A VGND VGND VPWR
+ VPWR g_row\[1\].g_col\[1\].pe__2404_/X sky130_fd_sc_hd__o22a_2
Xg_row\[0\].g_col\[1\].pe__1861_ g_row\[0\].g_col\[1\].pe__2241_/A1 g_row\[0\].g_col\[1\].pe__2026_/B
+ g_row\[0\].g_col\[1\].pe__1449_/Y g_row\[0\].g_col\[1\].pe__2699_/Q VGND VGND VPWR
+ VPWR g_row\[0\].g_col\[1\].pe__1862_/B sky130_fd_sc_hd__a22o_2
Xg_row\[0\].g_col\[0\].pe__1845_ g_row\[0\].g_col\[0\].pe__1636_/B g_row\[0\].g_col\[0\].pe__1845_/B
+ VGND VGND VPWR VPWR g_row\[0\].g_col\[0\].pe__1888_/A sky130_fd_sc_hd__and2b_2
XFILLER_38_697 VGND VGND VPWR VPWR sky130_fd_sc_hd__decap_3
XFILLER_93_770 VGND VGND VPWR VPWR sky130_fd_sc_hd__fill_2
Xg_row\[0\].g_col\[0\].pe__1776_ g_row\[0\].g_col\[0\].pe__1776_/A g_row\[0\].g_col\[0\].pe__1776_/B
+ VGND VGND VPWR VPWR g_row\[0\].g_col\[0\].pe__1777_/B sky130_fd_sc_hd__xor2_2
Xg_row\[1\].g_col\[1\].pe__2335_ g_row\[1\].g_col\[1\].pe__2396_/A g_row\[1\].g_col\[1\].pe__2335_/B
+ VGND VGND VPWR VPWR g_row\[1\].g_col\[1\].pe__2750_/D sky130_fd_sc_hd__nor2_2
Xg_row\[1\].g_col\[0\].pe__2319_ g_row\[1\].g_col\[0\].pe__2319_/A g_row\[1\].g_col\[0\].pe__2319_/B
+ VGND VGND VPWR VPWR g_row\[1\].g_col\[0\].pe__2348_/B sky130_fd_sc_hd__xor2_2
Xg_row\[0\].g_col\[1\].pe__1792_ g_row\[0\].g_col\[1\].pe__1792_/A VGND VGND VPWR
+ VPWR g_row\[0\].g_col\[1\].pe__1795_/A sky130_fd_sc_hd__inv_2
XFILLER_52_122 VGND VGND VPWR VPWR sky130_fd_sc_hd__decap_3
Xg_row\[1\].g_col\[1\].pe__2266_ g_row\[1\].g_col\[1\].pe__2266_/A VGND VGND VPWR
+ VPWR g_row\[1\].g_col\[1\].pe__2266_/Y sky130_fd_sc_hd__inv_2
Xg_row\[1\].g_col\[1\].pe__2197_ g_row\[1\].g_col\[1\].pe__2161_/Y g_row\[1\].g_col\[1\].pe__2157_/B
+ g_row\[1\].g_col\[1\].pe__2200_/B VGND VGND VPWR VPWR g_row\[1\].g_col\[1\].pe__2197_/Y
+ sky130_fd_sc_hd__a21oi_2
Xg_row\[0\].g_col\[1\].pe__2413_ g_row\[0\].g_col\[1\].pe__2421_/A1 g_row\[0\].g_col\[1\].pe__2744_/Q
+ g_row\[0\].g_col\[1\].pe__2445_/B VGND VGND VPWR VPWR g_row\[0\].g_col\[1\].pe__2441_/B
+ sky130_fd_sc_hd__a21oi_2
XFILLER_21_553 VGND VGND VPWR VPWR sky130_fd_sc_hd__decap_3
XFILLER_21_564 VGND VGND VPWR VPWR sky130_fd_sc_hd__fill_2
XTAP_TAPCELL_ROW_23_548 VGND VPWR sky130_fd_sc_hd__tapvpwrvgnd_1
XTAP_TAPCELL_ROW_23_559 VGND VPWR sky130_fd_sc_hd__tapvpwrvgnd_1
Xg_row\[0\].g_col\[1\].pe__2344_ g_row\[0\].g_col\[1\].pe__2368_/A g_row\[0\].g_col\[1\].pe__2345_/B
+ VGND VGND VPWR VPWR g_row\[0\].g_col\[1\].pe__2346_/A sky130_fd_sc_hd__nand2_2
Xg_row\[0\].g_col\[0\].pe__2328_ g_row\[0\].g_col\[0\].pe__2355_/A g_row\[0\].g_col\[0\].pe__2328_/B
+ VGND VGND VPWR VPWR g_row\[0\].g_col\[0\].pe__2329_/B sky130_fd_sc_hd__or2_2
Xinput1337 hold3592/X VGND VGND VPWR VPWR hold3593/A sky130_fd_sc_hd__buf_2
Xinput1326 hold3315/X VGND VGND VPWR VPWR hold3316/A sky130_fd_sc_hd__buf_2
Xinput1315 hold3161/X VGND VGND VPWR VPWR hold3162/A sky130_fd_sc_hd__buf_2
Xinput1304 hold3550/X VGND VGND VPWR VPWR hold3551/A sky130_fd_sc_hd__buf_2
Xg_row\[0\].g_col\[0\].pe__2259_ g_row\[0\].g_col\[0\].pe__2226_/A g_row\[0\].g_col\[0\].pe__2226_/B
+ g_row\[0\].g_col\[0\].pe__2258_/X VGND VGND VPWR VPWR g_row\[0\].g_col\[0\].pe__2330_/B
+ sky130_fd_sc_hd__a21oi_2
Xinput1348 hold3231/X VGND VGND VPWR VPWR hold3232/A sky130_fd_sc_hd__buf_2
Xg_row\[0\].g_col\[1\].pe__2275_ g_row\[0\].g_col\[1\].pe__2632_/B g_row\[0\].g_col\[1\].pe__2733_/Q
+ g_row\[0\].g_col\[1\].pe__1673_/A g_row\[0\].g_col\[1\].pe__1977_/A VGND VGND VPWR
+ VPWR g_row\[0\].g_col\[1\].pe__2276_/B sky130_fd_sc_hd__a211o_2
XFILLER_0_446 VGND VGND VPWR VPWR sky130_fd_sc_hd__fill_2
Xhold3330 hold3330/A VGND VGND VPWR VPWR hold3330/X sky130_fd_sc_hd__clkbuf_2
Xhold3341 hold3341/A VGND VGND VPWR VPWR hold3341/X sky130_fd_sc_hd__clkbuf_2
Xhold3352 hold3352/A VGND VGND VPWR VPWR hold3352/X sky130_fd_sc_hd__clkbuf_2
Xg_row\[1\].g_col\[1\].pe_hold1969 g_row\[1\].g_col\[1\].pe_hold3116/X VGND VGND VPWR
+ VPWR g_row\[1\].g_col\[1\].pe__1391_/A1 sky130_fd_sc_hd__clkbuf_2
Xg_row\[1\].g_col\[1\].pe_hold1947 g_row\[1\].g_col\[1\].pe__2699_/Q VGND VGND VPWR
+ VPWR g_row\[1\].g_col\[1\].pe__2621_/B sky130_fd_sc_hd__clkbuf_2
XFILLER_48_406 VGND VGND VPWR VPWR sky130_fd_sc_hd__fill_2
Xhold2640 _187_/Y VGND VGND VPWR VPWR hold2640/X sky130_fd_sc_hd__clkbuf_2
Xhold3363 hold3363/A VGND VGND VPWR VPWR hold3363/X sky130_fd_sc_hd__clkbuf_2
Xhold3374 hold3374/A VGND VGND VPWR VPWR hold3374/X sky130_fd_sc_hd__clkbuf_2
Xhold3385 hold3385/A VGND VGND VPWR VPWR hold3385/X sky130_fd_sc_hd__clkbuf_2
XFILLER_76_748 VGND VGND VPWR VPWR sky130_fd_sc_hd__decap_3
XFILLER_88_597 VGND VGND VPWR VPWR sky130_fd_sc_hd__decap_3
Xhold2651 hold3374/X VGND VGND VPWR VPWR _253_/B_N sky130_fd_sc_hd__clkbuf_2
Xhold2662 hold3421/X VGND VGND VPWR VPWR hold3422/A sky130_fd_sc_hd__clkbuf_2
Xhold2673 hold3461/X VGND VGND VPWR VPWR hold3462/A sky130_fd_sc_hd__clkbuf_2
Xhold3396 b_inputs_flat[11] VGND VGND VPWR VPWR hold3396/X sky130_fd_sc_hd__clkbuf_2
XTAP_TAPCELL_ROW_3_251 VGND VPWR sky130_fd_sc_hd__tapvpwrvgnd_1
XTAP_TAPCELL_ROW_3_262 VGND VPWR sky130_fd_sc_hd__tapvpwrvgnd_1
Xhold1950 hold1950/A VGND VGND VPWR VPWR hold1950/X sky130_fd_sc_hd__clkbuf_2
Xhold2684 hold3438/X VGND VGND VPWR VPWR hold3439/A sky130_fd_sc_hd__clkbuf_2
Xhold2695 hold2695/A VGND VGND VPWR VPWR _315_/D sky130_fd_sc_hd__clkbuf_2
XFILLER_43_100 VGND VGND VPWR VPWR sky130_fd_sc_hd__decap_3
XFILLER_44_623 VGND VGND VPWR VPWR sky130_fd_sc_hd__fill_1
XFILLER_91_729 VGND VGND VPWR VPWR sky130_fd_sc_hd__decap_3
XFILLER_44_645 VGND VGND VPWR VPWR sky130_fd_sc_hd__fill_2
XFILLER_83_291 VGND VGND VPWR VPWR sky130_fd_sc_hd__fill_1
XFILLER_43_166 VGND VGND VPWR VPWR sky130_fd_sc_hd__fill_2
XTAP_TAPCELL_ROW_42_835 VGND VPWR sky130_fd_sc_hd__tapvpwrvgnd_1
XTAP_TAPCELL_ROW_42_846 VGND VPWR sky130_fd_sc_hd__tapvpwrvgnd_1
XTAP_TAPCELL_ROW_65_1181 VGND VPWR sky130_fd_sc_hd__tapvpwrvgnd_1
XTAP_TAPCELL_ROW_65_1192 VGND VPWR sky130_fd_sc_hd__tapvpwrvgnd_1
XANTENNA_7 a_inputs_flat[17] VGND VGND VPWR VPWR sky130_fd_sc_hd__diode_2
XFILLER_4_730 VGND VGND VPWR VPWR sky130_fd_sc_hd__decap_3
Xg_row\[1\].g_col\[0\].pe__2670_ g_row\[1\].g_col\[0\].pe__2670_/A1 hold2082/X g_row\[1\].g_col\[0\].pe__2670_/B1
+ g_row\[1\].g_col\[0\].pe__2670_/C1 VGND VGND VPWR VPWR g_row\[1\].g_col\[0\].pe__2670_/X
+ sky130_fd_sc_hd__o211a_2
Xg_row\[1\].g_col\[0\].pe__1621_ g_row\[1\].g_col\[0\].pe__1870_/A g_row\[1\].g_col\[0\].pe__1621_/B
+ VGND VGND VPWR VPWR g_row\[1\].g_col\[0\].pe__1875_/C sky130_fd_sc_hd__xor2_2
Xg_row\[1\].g_col\[0\].pe_hold3016 g_row\[1\].g_col\[0\].pe__2752_/Q VGND VGND VPWR
+ VPWR g_row\[1\].g_col\[0\].pe__2380_/B1 sky130_fd_sc_hd__clkbuf_2
Xg_row\[1\].g_col\[0\].pe__1552_ g_row\[1\].g_col\[0\].pe__1545_/A g_row\[1\].g_col\[0\].pe__1552_/B
+ VGND VGND VPWR VPWR g_row\[1\].g_col\[0\].pe__1552_/X sky130_fd_sc_hd__and2b_2
XFILLER_67_726 VGND VGND VPWR VPWR sky130_fd_sc_hd__fill_2
XFILLER_66_203 VGND VGND VPWR VPWR sky130_fd_sc_hd__fill_1
Xg_row\[1\].g_col\[0\].pe__1483_ g_row\[1\].g_col\[0\].pe__1749_/A1 place1082/X place1084/X
+ g_row\[1\].g_col\[0\].pe__1641_/B2 VGND VGND VPWR VPWR g_row\[1\].g_col\[0\].pe__1484_/B
+ sky130_fd_sc_hd__a22o_2
XFILLER_75_770 VGND VGND VPWR VPWR sky130_fd_sc_hd__fill_1
Xg_row\[0\].g_col\[0\].pe__1630_ g_row\[0\].g_col\[0\].pe__1582_/B g_row\[0\].g_col\[0\].pe__1630_/B
+ VGND VGND VPWR VPWR g_row\[0\].g_col\[0\].pe__1630_/X sky130_fd_sc_hd__and2b_2
XFILLER_35_645 VGND VGND VPWR VPWR sky130_fd_sc_hd__decap_3
XFILLER_90_740 VGND VGND VPWR VPWR sky130_fd_sc_hd__fill_1
Xg_row\[0\].g_col\[0\].pe__1561_ g_row\[0\].g_col\[0\].pe__1562_/A g_row\[0\].g_col\[0\].pe__1562_/B
+ g_row\[0\].g_col\[0\].pe__1562_/C VGND VGND VPWR VPWR g_row\[0\].g_col\[0\].pe__1846_/A
+ sky130_fd_sc_hd__o21a_2
Xg_row\[1\].g_col\[1\].pe__2120_ g_row\[1\].g_col\[1\].pe__2078_/A g_row\[1\].g_col\[1\].pe__2078_/B
+ g_row\[1\].g_col\[1\].pe__2119_/X VGND VGND VPWR VPWR g_row\[1\].g_col\[1\].pe__2147_/A
+ sky130_fd_sc_hd__a21o_2
Xg_row\[1\].g_col\[0\].pe__2104_ g_row\[1\].g_col\[0\].pe__2104_/A g_row\[1\].g_col\[0\].pe__2104_/B
+ g_row\[1\].g_col\[0\].pe__2104_/C VGND VGND VPWR VPWR g_row\[1\].g_col\[0\].pe__2106_/A
+ sky130_fd_sc_hd__and3_4
Xg_row\[1\].g_col\[1\].pe__2051_ g_row\[1\].g_col\[1\].pe__2048_/Y g_row\[1\].g_col\[1\].pe__2049_/X
+ g_row\[1\].g_col\[1\].pe__2025_/Y g_row\[1\].g_col\[1\].pe__1991_/X VGND VGND VPWR
+ VPWR g_row\[1\].g_col\[1\].pe__2052_/C sky130_fd_sc_hd__a211oi_2
XFILLER_50_648 VGND VGND VPWR VPWR sky130_fd_sc_hd__fill_1
Xg_row\[0\].g_col\[0\].pe__1492_ place1210/X g_row\[0\].g_col\[0\].pe__1748_/B g_row\[0\].g_col\[0\].pe__1738_/B1
+ g_row\[0\].g_col\[0\].pe__1866_/B2 VGND VGND VPWR VPWR g_row\[0\].g_col\[0\].pe__1493_/B
+ sky130_fd_sc_hd__a22o_2
Xg_row\[1\].g_col\[0\].pe__2035_ g_row\[1\].g_col\[0\].pe__2034_/A g_row\[1\].g_col\[0\].pe__2034_/B
+ g_row\[1\].g_col\[0\].pe__2034_/C g_row\[1\].g_col\[0\].pe__2034_/D VGND VGND VPWR
+ VPWR g_row\[1\].g_col\[0\].pe__2038_/B sky130_fd_sc_hd__a22o_2
XTAP_TAPCELL_ROW_20_507 VGND VPWR sky130_fd_sc_hd__tapvpwrvgnd_1
Xg_row\[0\].g_col\[0\].pe__2113_ g_row\[0\].g_col\[0\].pe__2066_/Y g_row\[0\].g_col\[0\].pe__2061_/Y
+ g_row\[0\].g_col\[0\].pe__2111_/X g_row\[0\].g_col\[0\].pe__2394_/B1 VGND VGND VPWR
+ VPWR g_row\[0\].g_col\[0\].pe__2113_/X sky130_fd_sc_hd__a31o_2
Xg_row\[0\].g_col\[0\].pe__2044_ g_row\[0\].g_col\[0\].pe__2094_/C g_row\[0\].g_col\[0\].pe__2044_/B
+ VGND VGND VPWR VPWR g_row\[0\].g_col\[0\].pe__2047_/A sky130_fd_sc_hd__and2_2
Xplace1201 place1201/A VGND VGND VPWR VPWR place1201/X sky130_fd_sc_hd__buf_6
Xg_row\[1\].g_col\[1\].pe__1904_ g_row\[1\].g_col\[1\].pe__1905_/A g_row\[1\].g_col\[1\].pe__1905_/B
+ VGND VGND VPWR VPWR g_row\[1\].g_col\[1\].pe__1964_/A sky130_fd_sc_hd__nand2_2
Xg_row\[0\].g_col\[1\].pe__2060_ g_row\[0\].g_col\[1\].pe__2153_/A g_row\[0\].g_col\[1\].pe__2153_/B
+ VGND VGND VPWR VPWR g_row\[0\].g_col\[1\].pe__2150_/C sky130_fd_sc_hd__xor2_2
Xplace1212 place1212/A VGND VGND VPWR VPWR place1212/X sky130_fd_sc_hd__buf_6
Xplace1223 place1223/A VGND VGND VPWR VPWR place1223/X sky130_fd_sc_hd__buf_6
Xplace1267 place1271/X VGND VGND VPWR VPWR _219_/A sky130_fd_sc_hd__buf_6
Xg_row\[1\].g_col\[1\].pe__1835_ g_row\[1\].g_col\[1\].pe__1838_/A g_row\[1\].g_col\[1\].pe__1835_/A2
+ g_row\[1\].g_col\[1\].pe__2157_/A g_row\[1\].g_col\[1\].pe__1834_/Y VGND VGND VPWR
+ VPWR g_row\[1\].g_col\[1\].pe__1835_/X sky130_fd_sc_hd__a22o_2
Xg_row\[1\].g_col\[0\].pe__1819_ g_row\[1\].g_col\[0\].pe__1819_/A g_row\[1\].g_col\[0\].pe__1819_/B
+ VGND VGND VPWR VPWR g_row\[1\].g_col\[0\].pe__1820_/A sky130_fd_sc_hd__and2_2
Xplace1278 _271_/A VGND VGND VPWR VPWR _173_/A sky130_fd_sc_hd__buf_6
Xg_row\[1\].g_col\[1\].pe__1766_ g_row\[1\].g_col\[1\].pe__1766_/A g_row\[1\].g_col\[1\].pe__1766_/B
+ VGND VGND VPWR VPWR g_row\[1\].g_col\[1\].pe__1781_/A sky130_fd_sc_hd__xor2_2
Xg_row\[1\].g_col\[1\].pe__1697_ g_row\[1\].g_col\[1\].pe__1697_/A g_row\[1\].g_col\[1\].pe__1697_/B
+ VGND VGND VPWR VPWR g_row\[1\].g_col\[1\].pe__1699_/B sky130_fd_sc_hd__xnor2_2
Xg_row\[1\].g_col\[0\].pe_hold2860 g_row\[1\].g_col\[0\].pe__2670_/X VGND VGND VPWR
+ VPWR g_row\[1\].g_col\[0\].pe_hold2860/X sky130_fd_sc_hd__clkbuf_2
Xg_row\[0\].g_col\[1\].pe__1913_ g_row\[0\].g_col\[1\].pe__1955_/A g_row\[0\].g_col\[1\].pe__1955_/B
+ VGND VGND VPWR VPWR g_row\[0\].g_col\[1\].pe__1916_/A sky130_fd_sc_hd__xor2_2
XFILLER_73_707 VGND VGND VPWR VPWR sky130_fd_sc_hd__decap_3
XFILLER_85_567 VGND VGND VPWR VPWR sky130_fd_sc_hd__fill_2
Xg_row\[1\].g_col\[0\].pe_hold2893 g_row\[1\].g_col\[0\].pe_hold2893/A VGND VGND VPWR
+ VPWR g_row\[1\].g_col\[0\].pe__2628_/A2 sky130_fd_sc_hd__clkbuf_2
Xg_row\[1\].g_col\[0\].pe_hold2882 g_row\[1\].g_col\[0\].pe__2677_/X VGND VGND VPWR
+ VPWR g_row\[1\].g_col\[0\].pe_hold2882/X sky130_fd_sc_hd__clkbuf_2
XTAP_TAPCELL_ROW_0_210 VGND VPWR sky130_fd_sc_hd__tapvpwrvgnd_1
XTAP_TAPCELL_ROW_28_629 VGND VPWR sky130_fd_sc_hd__tapvpwrvgnd_1
Xg_row\[0\].g_col\[0\].pe__1828_ g_row\[0\].g_col\[0\].pe__1828_/A g_row\[0\].g_col\[0\].pe__1828_/B
+ VGND VGND VPWR VPWR g_row\[0\].g_col\[0\].pe__1828_/Y sky130_fd_sc_hd__nand2_2
Xg_row\[0\].g_col\[1\].pe__1844_ g_row\[0\].g_col\[1\].pe__1844_/A g_row\[0\].g_col\[1\].pe__1844_/B
+ VGND VGND VPWR VPWR g_row\[0\].g_col\[1\].pe__1894_/A sky130_fd_sc_hd__and2_2
XFILLER_25_111 VGND VGND VPWR VPWR sky130_fd_sc_hd__fill_1
XFILLER_38_494 VGND VGND VPWR VPWR sky130_fd_sc_hd__fill_2
XFILLER_82_29 VGND VGND VPWR VPWR sky130_fd_sc_hd__decap_3
Xg_row\[1\].g_col\[1\].pe__2318_ g_row\[1\].g_col\[1\].pe__2318_/A g_row\[1\].g_col\[1\].pe__2318_/B
+ VGND VGND VPWR VPWR g_row\[1\].g_col\[1\].pe__2319_/B sky130_fd_sc_hd__xor2_2
Xg_row\[0\].g_col\[1\].pe__1775_ g_row\[0\].g_col\[1\].pe__1801_/A g_row\[0\].g_col\[1\].pe__1748_/B
+ g_row\[0\].g_col\[1\].pe__1760_/B g_row\[0\].g_col\[1\].pe__1774_/Y VGND VGND VPWR
+ VPWR g_row\[0\].g_col\[1\].pe__1777_/A sky130_fd_sc_hd__a31o_2
XFILLER_41_615 VGND VGND VPWR VPWR sky130_fd_sc_hd__fill_1
XFILLER_80_250 VGND VGND VPWR VPWR sky130_fd_sc_hd__fill_2
Xg_row\[0\].g_col\[0\].pe__1759_ g_row\[0\].g_col\[0\].pe__1774_/A g_row\[0\].g_col\[0\].pe__1774_/B
+ VGND VGND VPWR VPWR g_row\[0\].g_col\[0\].pe__1760_/B sky130_fd_sc_hd__xor2_2
XFILLER_41_626 VGND VGND VPWR VPWR sky130_fd_sc_hd__fill_1
Xg_row\[1\].g_col\[1\].pe__2249_ g_row\[1\].g_col\[1\].pe__2250_/A g_row\[1\].g_col\[1\].pe__2250_/B
+ VGND VGND VPWR VPWR g_row\[1\].g_col\[1\].pe__2283_/A sky130_fd_sc_hd__or2_2
XFILLER_41_659 VGND VGND VPWR VPWR sky130_fd_sc_hd__fill_1
XFILLER_5_505 VGND VGND VPWR VPWR sky130_fd_sc_hd__fill_2
Xg_row\[0\].g_col\[1\].pe__2327_ g_row\[0\].g_col\[1\].pe__2327_/A g_row\[0\].g_col\[1\].pe__2327_/B
+ g_row\[0\].g_col\[1\].pe__2327_/C VGND VGND VPWR VPWR g_row\[0\].g_col\[1\].pe__2328_/B
+ sky130_fd_sc_hd__nor3_2
XFILLER_31_55 VGND VGND VPWR VPWR sky130_fd_sc_hd__fill_1
Xclkbuf_4_10_0_clk clkbuf_0_clk/X VGND VGND VPWR VPWR clkbuf_4_10_0_clk/X sky130_fd_sc_hd__clkbuf_16
Xg_row\[1\].g_col\[1\].pe_hold3102 g_row\[1\].g_col\[1\].pe__2729_/Q VGND VGND VPWR
+ VPWR g_row\[1\].g_col\[1\].pe_hold3102/X sky130_fd_sc_hd__clkbuf_2
Xg_row\[1\].g_col\[1\].pe_hold3124 g_row\[1\].g_col\[1\].pe__2742_/Q VGND VGND VPWR
+ VPWR g_row\[1\].g_col\[1\].pe_hold3124/X sky130_fd_sc_hd__clkbuf_2
Xg_row\[0\].g_col\[1\].pe__2258_ g_row\[0\].g_col\[1\].pe__2258_/A g_row\[0\].g_col\[1\].pe__2258_/B
+ VGND VGND VPWR VPWR g_row\[0\].g_col\[1\].pe__2258_/X sky130_fd_sc_hd__and2_2
Xg_row\[1\].g_col\[1\].pe_hold1711 g_row\[1\].g_col\[1\].pe__2432_/A VGND VGND VPWR
+ VPWR g_row\[1\].g_col\[1\].pe__2306_/A2 sky130_fd_sc_hd__clkbuf_2
Xg_row\[0\].g_col\[1\].pe__2189_ g_row\[0\].g_col\[1\].pe__2190_/A g_row\[0\].g_col\[1\].pe__2190_/B
+ VGND VGND VPWR VPWR g_row\[0\].g_col\[1\].pe__2191_/A sky130_fd_sc_hd__and2_4
XFILLER_1_722 VGND VGND VPWR VPWR sky130_fd_sc_hd__decap_3
XTAP_TAPCELL_ROW_8_332 VGND VPWR sky130_fd_sc_hd__tapvpwrvgnd_1
Xhold3160 hold3160/A VGND VGND VPWR VPWR hold3160/X sky130_fd_sc_hd__clkbuf_2
Xg_row\[1\].g_col\[1\].pe_hold1777 g_row\[1\].g_col\[1\].pe_hold3092/X VGND VGND VPWR
+ VPWR g_row\[1\].g_col\[1\].pe__2734_/D sky130_fd_sc_hd__clkbuf_2
Xhold3171 hold3171/A VGND VGND VPWR VPWR hold3171/X sky130_fd_sc_hd__clkbuf_2
Xhold3182 hold3182/A VGND VGND VPWR VPWR hold3182/X sky130_fd_sc_hd__clkbuf_2
Xhold3193 b_inputs_flat[24] VGND VGND VPWR VPWR hold3193/X sky130_fd_sc_hd__clkbuf_2
Xhold2470 hold3204/X VGND VGND VPWR VPWR hold3205/A sky130_fd_sc_hd__clkbuf_2
Xhold2481 hold3230/X VGND VGND VPWR VPWR hold3231/A sky130_fd_sc_hd__clkbuf_2
XFILLER_76_589 VGND VGND VPWR VPWR sky130_fd_sc_hd__fill_1
XTAP_TAPCELL_ROW_47_916 VGND VPWR sky130_fd_sc_hd__tapvpwrvgnd_1
XTAP_TAPCELL_ROW_67_1210 VGND VPWR sky130_fd_sc_hd__tapvpwrvgnd_1
Xhold2492 hold3242/X VGND VGND VPWR VPWR hold3243/A sky130_fd_sc_hd__clkbuf_2
XFILLER_17_623 VGND VGND VPWR VPWR sky130_fd_sc_hd__fill_2
XFILLER_56_85 VGND VGND VPWR VPWR sky130_fd_sc_hd__decap_3
XTAP_TAPCELL_ROW_67_1221 VGND VPWR sky130_fd_sc_hd__tapvpwrvgnd_1
XFILLER_16_144 VGND VGND VPWR VPWR sky130_fd_sc_hd__decap_3
XFILLER_17_667 VGND VGND VPWR VPWR sky130_fd_sc_hd__decap_3
XFILLER_44_464 VGND VGND VPWR VPWR sky130_fd_sc_hd__fill_1
XFILLER_44_486 VGND VGND VPWR VPWR sky130_fd_sc_hd__decap_3
XTAP_TAPCELL_ROW_80_1410 VGND VPWR sky130_fd_sc_hd__tapvpwrvgnd_1
Xg_row\[0\].g_col\[0\].pe_hold2936 _289_/Q VGND VGND VPWR VPWR g_row\[0\].g_col\[0\].pe_hold2936/X
+ sky130_fd_sc_hd__clkbuf_2
Xg_row\[1\].g_col\[0\].pe__2722_ clkbuf_leaf_47_clk/X g_row\[1\].g_col\[0\].pe__2722_/D
+ VGND VGND VPWR VPWR g_row\[1\].g_col\[0\].pe__2722_/Q sky130_fd_sc_hd__dfxtp_2
XTAP_TAPCELL_ROW_78_1383 VGND VPWR sky130_fd_sc_hd__tapvpwrvgnd_1
Xg_row\[1\].g_col\[1\].pe__1620_ g_row\[1\].g_col\[1\].pe__2083_/A g_row\[1\].g_col\[1\].pe__1414_/X
+ g_row\[1\].g_col\[1\].pe__1415_/Y g_row\[1\].g_col\[1\].pe__1920_/A2 g_row\[1\].g_col\[1\].pe__2703_/Q
+ VGND VGND VPWR VPWR g_row\[1\].g_col\[1\].pe__1621_/B sky130_fd_sc_hd__a32o_2
Xg_row\[1\].g_col\[0\].pe__2653_ g_row\[1\].g_col\[0\].pe__2676_/A g_row\[1\].g_col\[0\].pe__2653_/B
+ VGND VGND VPWR VPWR g_row\[1\].g_col\[0\].pe__2653_/X sky130_fd_sc_hd__or2_2
XFILLER_86_309 VGND VGND VPWR VPWR sky130_fd_sc_hd__fill_2
XTAP_TAPCELL_ROW_91_1572 VGND VPWR sky130_fd_sc_hd__tapvpwrvgnd_1
Xg_row\[1\].g_col\[0\].pe_hold2112 g_row\[1\].g_col\[0\].pe__2063_/Y VGND VGND VPWR
+ VPWR g_row\[1\].g_col\[0\].pe__2064_/B sky130_fd_sc_hd__clkbuf_2
Xg_row\[1\].g_col\[0\].pe__2584_ g_row\[1\].g_col\[0\].pe__2585_/A g_row\[1\].g_col\[0\].pe__2585_/B
+ VGND VGND VPWR VPWR g_row\[1\].g_col\[0\].pe__2586_/B sky130_fd_sc_hd__nor2_2
Xg_row\[1\].g_col\[0\].pe__1604_ g_row\[1\].g_col\[0\].pe__1604_/A g_row\[1\].g_col\[0\].pe__1604_/B
+ VGND VGND VPWR VPWR g_row\[1\].g_col\[0\].pe__1605_/B sky130_fd_sc_hd__or2_2
XFILLER_39_225 VGND VGND VPWR VPWR sky130_fd_sc_hd__fill_1
Xg_row\[1\].g_col\[1\].pe__1551_ g_row\[1\].g_col\[1\].pe__1669_/A g_row\[1\].g_col\[1\].pe__1669_/B
+ VGND VGND VPWR VPWR g_row\[1\].g_col\[1\].pe__1830_/B sky130_fd_sc_hd__and2_2
Xg_row\[1\].g_col\[0\].pe__1535_ g_row\[1\].g_col\[0\].pe__2736_/Q g_row\[1\].g_col\[0\].pe__1535_/B
+ VGND VGND VPWR VPWR g_row\[1\].g_col\[0\].pe__1546_/A sky130_fd_sc_hd__nand2_2
XFILLER_67_556 VGND VGND VPWR VPWR sky130_fd_sc_hd__decap_3
Xg_row\[0\].g_col\[0\].pe__2731_ clkbuf_leaf_37_clk/X g_row\[0\].g_col\[0\].pe__2731_/D
+ VGND VGND VPWR VPWR g_row\[0\].g_col\[0\].pe__2731_/Q sky130_fd_sc_hd__dfxtp_2
Xg_row\[1\].g_col\[1\].pe__1482_ g_row\[1\].g_col\[1\].pe__1442_/A g_row\[1\].g_col\[1\].pe__1442_/B
+ g_row\[1\].g_col\[1\].pe__1481_/X VGND VGND VPWR VPWR g_row\[1\].g_col\[1\].pe__1512_/A
+ sky130_fd_sc_hd__a21oi_2
Xg_row\[1\].g_col\[0\].pe__1466_ g_row\[1\].g_col\[0\].pe__2321_/A VGND VGND VPWR
+ VPWR g_row\[1\].g_col\[0\].pe__2348_/A sky130_fd_sc_hd__inv_2
XFILLER_54_206 VGND VGND VPWR VPWR sky130_fd_sc_hd__decap_3
XFILLER_67_589 VGND VGND VPWR VPWR sky130_fd_sc_hd__fill_1
Xg_row\[0\].g_col\[0\].pe__2662_ g_row\[0\].g_col\[0\].pe__2670_/A1 g_row\[0\].g_col\[0\].pe__2662_/A2
+ g_row\[0\].g_col\[0\].pe__2677_/B1 g_row\[0\].g_col\[0\].pe__2662_/C1 VGND VGND
+ VPWR VPWR g_row\[0\].g_col\[0\].pe__2662_/X sky130_fd_sc_hd__o211a_2
XFILLER_35_431 VGND VGND VPWR VPWR sky130_fd_sc_hd__decap_3
Xg_row\[0\].g_col\[0\].pe__1613_ g_row\[0\].g_col\[0\].pe__1866_/B2 g_row\[0\].g_col\[0\].pe__1657_/B
+ g_row\[0\].g_col\[0\].pe__2247_/B1 place1214/X VGND VGND VPWR VPWR g_row\[0\].g_col\[0\].pe__1614_/B
+ sky130_fd_sc_hd__a22o_2
Xg_row\[1\].g_col\[0\].pe__1397_ g_row\[1\].g_col\[0\].pe__2368_/A g_row\[1\].g_col\[0\].pe__2679_/A2
+ g_row\[1\].g_col\[0\].pe__1397_/B1 g_row\[1\].g_col\[0\].pe__1403_/C1 VGND VGND
+ VPWR VPWR g_row\[1\].g_col\[0\].pe__1397_/X sky130_fd_sc_hd__o211a_2
Xg_row\[0\].g_col\[1\].pe__1560_ g_row\[0\].g_col\[1\].pe__1607_/A g_row\[0\].g_col\[1\].pe__1560_/B
+ VGND VGND VPWR VPWR g_row\[0\].g_col\[1\].pe__1562_/C sky130_fd_sc_hd__and2_2
Xg_row\[1\].g_col\[1\].pe__2103_ g_row\[1\].g_col\[1\].pe__2052_/A g_row\[1\].g_col\[1\].pe__2052_/C
+ g_row\[1\].g_col\[1\].pe__2052_/B VGND VGND VPWR VPWR g_row\[1\].g_col\[1\].pe__2104_/C
+ sky130_fd_sc_hd__o21bai_2
XFILLER_23_637 VGND VGND VPWR VPWR sky130_fd_sc_hd__decap_3
XFILLER_50_434 VGND VGND VPWR VPWR sky130_fd_sc_hd__decap_3
XFILLER_90_581 VGND VGND VPWR VPWR sky130_fd_sc_hd__fill_2
Xg_row\[0\].g_col\[0\].pe__1544_ g_row\[0\].g_col\[0\].pe__1602_/A g_row\[0\].g_col\[0\].pe__1544_/B
+ VGND VGND VPWR VPWR g_row\[0\].g_col\[0\].pe__1552_/B sky130_fd_sc_hd__xnor2_2
XFILLER_50_456 VGND VGND VPWR VPWR sky130_fd_sc_hd__fill_1
Xg_row\[0\].g_col\[1\].pe__1491_ g_row\[0\].g_col\[1\].pe__1512_/A g_row\[0\].g_col\[1\].pe__1512_/B
+ VGND VGND VPWR VPWR g_row\[0\].g_col\[1\].pe__1500_/A sky130_fd_sc_hd__xor2_2
Xg_row\[1\].g_col\[1\].pe__2034_ g_row\[1\].g_col\[1\].pe__2034_/A g_row\[1\].g_col\[1\].pe__2034_/B
+ g_row\[1\].g_col\[1\].pe__2034_/C g_row\[1\].g_col\[1\].pe__2034_/D VGND VGND VPWR
+ VPWR g_row\[1\].g_col\[1\].pe__2038_/A sky130_fd_sc_hd__nand4_2
Xg_row\[1\].g_col\[0\].pe__2018_ g_row\[1\].g_col\[0\].pe__1978_/B g_row\[1\].g_col\[0\].pe__1978_/C
+ g_row\[1\].g_col\[0\].pe__1978_/A VGND VGND VPWR VPWR g_row\[1\].g_col\[0\].pe__2023_/A
+ sky130_fd_sc_hd__o21bai_2
XFILLER_10_309 VGND VGND VPWR VPWR sky130_fd_sc_hd__fill_1
XFILLER_31_692 VGND VGND VPWR VPWR sky130_fd_sc_hd__fill_1
XTAP_TAPCELL_ROW_33_698 VGND VPWR sky130_fd_sc_hd__tapvpwrvgnd_1
Xg_row\[0\].g_col\[1\].pe__2112_ g_row\[0\].g_col\[1\].pe__2066_/Y g_row\[0\].g_col\[1\].pe__2061_/Y
+ g_row\[0\].g_col\[1\].pe__2111_/X VGND VGND VPWR VPWR g_row\[0\].g_col\[1\].pe__2112_/Y
+ sky130_fd_sc_hd__a21oi_2
Xg_row\[0\].g_col\[1\].pe__2689__1423 VGND VGND VPWR VPWR g_row\[0\].g_col\[1\].pe__2689__1423/HI
+ g_row\[0\].g_col\[1\].pe__2689_/CIN sky130_fd_sc_hd__conb_1
Xg_row\[0\].g_col\[0\].pe__2027_ g_row\[0\].g_col\[0\].pe__1449_/A g_row\[0\].g_col\[0\].pe__1449_/B
+ g_row\[0\].g_col\[0\].pe__1922_/Y VGND VGND VPWR VPWR g_row\[0\].g_col\[0\].pe__2028_/C
+ sky130_fd_sc_hd__a21o_2
Xg_row\[0\].g_col\[1\].pe__2043_ g_row\[0\].g_col\[1\].pe__2043_/A g_row\[0\].g_col\[1\].pe__2043_/B
+ VGND VGND VPWR VPWR g_row\[0\].g_col\[1\].pe__2044_/B sky130_fd_sc_hd__nand2_2
XFILLER_77_18 VGND VGND VPWR VPWR sky130_fd_sc_hd__fill_1
Xg_row\[1\].g_col\[1\].pe__1818_ g_row\[1\].g_col\[1\].pe__1822_/D g_row\[1\].g_col\[1\].pe__1818_/B
+ VGND VGND VPWR VPWR g_row\[1\].g_col\[1\].pe__1821_/C sky130_fd_sc_hd__xnor2_2
Xplace1086 place1086/A VGND VGND VPWR VPWR place1086/X sky130_fd_sc_hd__buf_6
Xg_row\[1\].g_col\[1\].pe__1749_ g_row\[1\].g_col\[1\].pe__1804_/A g_row\[1\].g_col\[1\].pe__2695_/Q
+ g_row\[1\].g_col\[1\].pe__1761_/A2 g_row\[1\].g_col\[1\].pe__1761_/B2 VGND VGND
+ VPWR VPWR g_row\[1\].g_col\[1\].pe__1750_/B sky130_fd_sc_hd__a22o_2
XFILLER_26_11 VGND VGND VPWR VPWR sky130_fd_sc_hd__fill_2
XFILLER_73_548 VGND VGND VPWR VPWR sky130_fd_sc_hd__decap_3
Xg_row\[0\].g_col\[1\].pe__1827_ g_row\[0\].g_col\[1\].pe__1827_/A g_row\[0\].g_col\[1\].pe__1827_/B
+ VGND VGND VPWR VPWR g_row\[0\].g_col\[1\].pe__1827_/Y sky130_fd_sc_hd__nand2_2
XFILLER_13_103 VGND VGND VPWR VPWR sky130_fd_sc_hd__fill_1
XFILLER_26_99 VGND VGND VPWR VPWR sky130_fd_sc_hd__decap_3
XFILLER_53_261 VGND VGND VPWR VPWR sky130_fd_sc_hd__fill_1
Xg_row\[0\].g_col\[1\].pe__1758_ g_row\[0\].g_col\[1\].pe__1758_/A g_row\[0\].g_col\[1\].pe__1758_/B
+ VGND VGND VPWR VPWR g_row\[0\].g_col\[1\].pe__1774_/B sky130_fd_sc_hd__xnor2_2
XTAP_TAPCELL_ROW_62_1140 VGND VPWR sky130_fd_sc_hd__tapvpwrvgnd_1
Xg_row\[0\].g_col\[1\].pe__1689_ g_row\[0\].g_col\[1\].pe__1721_/A g_row\[0\].g_col\[1\].pe__1721_/B
+ VGND VGND VPWR VPWR g_row\[0\].g_col\[1\].pe__1689_/Y sky130_fd_sc_hd__nand2_2
XFILLER_13_169 VGND VGND VPWR VPWR sky130_fd_sc_hd__fill_2
XTAP_TAPCELL_ROW_52_985 VGND VPWR sky130_fd_sc_hd__tapvpwrvgnd_1
XTAP_TAPCELL_ROW_52_996 VGND VPWR sky130_fd_sc_hd__tapvpwrvgnd_1
X_291_ _291_/CLK _291_/D VGND VGND VPWR VPWR _291_/Q sky130_fd_sc_hd__dfxtp_2
XFILLER_6_836 VGND VGND VPWR VPWR sky130_fd_sc_hd__fill_1
Xg_row\[1\].g_col\[1\].pe_hold2264 g_row\[1\].g_col\[1\].pe__2642_/X VGND VGND VPWR
+ VPWR g_row\[1\].g_col\[1\].pe__2706_/D sky130_fd_sc_hd__clkbuf_2
Xg_row\[1\].g_col\[1\].pe_hold2253 g_row\[1\].g_col\[1\].pe_hold3059/X VGND VGND VPWR
+ VPWR g_row\[1\].g_col\[1\].pe__2709_/D sky130_fd_sc_hd__clkbuf_2
XFILLER_49_523 VGND VGND VPWR VPWR sky130_fd_sc_hd__decap_3
XFILLER_44_250 VGND VGND VPWR VPWR sky130_fd_sc_hd__fill_2
XFILLER_91_378 VGND VGND VPWR VPWR sky130_fd_sc_hd__fill_1
XFILLER_32_467 VGND VGND VPWR VPWR sky130_fd_sc_hd__decap_3
XFILLER_9_652 VGND VGND VPWR VPWR sky130_fd_sc_hd__decap_3
XTAP_TAPCELL_ROW_30_657 VGND VPWR sky130_fd_sc_hd__tapvpwrvgnd_1
XFILLER_66_3 VGND VGND VPWR VPWR sky130_fd_sc_hd__fill_2
XTAP_TAPCELL_ROW_93_1601 VGND VPWR sky130_fd_sc_hd__tapvpwrvgnd_1
XTAP_TAPCELL_ROW_93_1612 VGND VPWR sky130_fd_sc_hd__tapvpwrvgnd_1
XTAP_TAPCELL_ROW_93_1623 VGND VPWR sky130_fd_sc_hd__tapvpwrvgnd_1
Xg_row\[0\].g_col\[0\].pe_place1180 g_row\[0\].g_col\[0\].pe__2730_/Q VGND VGND VPWR
+ VPWR g_row\[0\].g_col\[0\].pe__1910_/A sky130_fd_sc_hd__buf_6
Xg_row\[0\].g_col\[0\].pe_place1191 g_row\[0\].g_col\[0\].pe__1761_/A1 VGND VGND VPWR
+ VPWR g_row\[0\].g_col\[0\].pe__1804_/A sky130_fd_sc_hd__buf_6
Xg_row\[1\].g_col\[1\].pe__2721_ clkbuf_leaf_85_clk/X g_row\[1\].g_col\[1\].pe__2721_/D
+ VGND VGND VPWR VPWR g_row\[1\].g_col\[1\].pe__2721_/Q sky130_fd_sc_hd__dfxtp_2
Xg_row\[1\].g_col\[0\].pe__2705_ _304_/CLK g_row\[1\].g_col\[0\].pe__2705_/D VGND
+ VGND VPWR VPWR hold1766/A sky130_fd_sc_hd__dfxtp_2
Xg_row\[1\].g_col\[1\].pe__2652_ g_row\[1\].g_col\[1\].pe__2656_/A1 g_row\[1\].g_col\[1\].pe__2652_/A2
+ g_row\[1\].g_col\[1\].pe__2687_/C1 g_row\[1\].g_col\[1\].pe__2652_/C1 VGND VGND
+ VPWR VPWR g_row\[1\].g_col\[1\].pe__2652_/X sky130_fd_sc_hd__o211a_2
Xg_row\[1\].g_col\[0\].pe__2636_ _294_/Q _293_/Q _296_/Q _295_/Q VGND VGND VPWR VPWR
+ g_row\[1\].g_col\[0\].pe__2636_/X sky130_fd_sc_hd__or4_2
Xg_row\[1\].g_col\[1\].pe__1603_ g_row\[1\].g_col\[1\].pe__1604_/A g_row\[1\].g_col\[1\].pe__1604_/B
+ VGND VGND VPWR VPWR g_row\[1\].g_col\[1\].pe__1860_/A sky130_fd_sc_hd__nand2_2
Xg_row\[1\].g_col\[1\].pe__1534_ g_row\[1\].g_col\[1\].pe__1588_/A g_row\[1\].g_col\[1\].pe__1588_/B
+ VGND VGND VPWR VPWR g_row\[1\].g_col\[1\].pe__1547_/A sky130_fd_sc_hd__xor2_2
Xg_row\[1\].g_col\[0\].pe__2567_ g_row\[1\].g_col\[0\].pe__2567_/A g_row\[1\].g_col\[0\].pe__2590_/A
+ VGND VGND VPWR VPWR g_row\[1\].g_col\[0\].pe__2567_/X sky130_fd_sc_hd__or2_2
XFILLER_55_515 VGND VGND VPWR VPWR sky130_fd_sc_hd__fill_1
Xg_row\[0\].g_col\[0\].pe__2714_ _319_/CLK g_row\[0\].g_col\[0\].pe__2714_/D VGND
+ VGND VPWR VPWR hold3023/A sky130_fd_sc_hd__dfxtp_2
Xg_row\[1\].g_col\[0\].pe__2498_ g_row\[1\].g_col\[0\].pe__2519_/A g_row\[1\].g_col\[0\].pe__2519_/B
+ VGND VGND VPWR VPWR g_row\[1\].g_col\[0\].pe__2499_/B sky130_fd_sc_hd__or2_2
Xg_row\[1\].g_col\[0\].pe__1518_ place1085/X g_row\[1\].g_col\[0\].pe__1729_/A2 g_row\[1\].g_col\[0\].pe__1729_/A3
+ g_row\[1\].g_col\[0\].pe__1801_/B place1084/X VGND VGND VPWR VPWR g_row\[1\].g_col\[0\].pe__1519_/B
+ sky130_fd_sc_hd__a32o_2
Xg_row\[0\].g_col\[1\].pe__2730_ clkload10/A g_row\[0\].g_col\[1\].pe__2730_/D VGND
+ VGND VPWR VPWR g_row\[0\].g_col\[1\].pe__2730_/Q sky130_fd_sc_hd__dfxtp_2
XFILLER_27_228 VGND VGND VPWR VPWR sky130_fd_sc_hd__fill_1
XFILLER_55_537 VGND VGND VPWR VPWR sky130_fd_sc_hd__fill_1
Xg_row\[1\].g_col\[1\].pe__1465_ g_row\[1\].g_col\[1\].pe__1507_/A g_row\[1\].g_col\[1\].pe__1507_/B
+ VGND VGND VPWR VPWR g_row\[1\].g_col\[1\].pe__1478_/A sky130_fd_sc_hd__xor2_2
Xg_row\[1\].g_col\[0\].pe__1449_ g_row\[1\].g_col\[0\].pe__1449_/A g_row\[1\].g_col\[0\].pe__1449_/B
+ VGND VGND VPWR VPWR g_row\[1\].g_col\[0\].pe__1449_/Y sky130_fd_sc_hd__nand2_2
Xg_row\[0\].g_col\[1\].pe_hold2329 g_row\[0\].g_col\[1\].pe__2513_/Y VGND VGND VPWR
+ VPWR g_row\[0\].g_col\[1\].pe__2514_/B sky130_fd_sc_hd__clkbuf_2
Xg_row\[0\].g_col\[1\].pe__2661_ g_row\[0\].g_col\[1\].pe__2661_/A hold2090/X VGND
+ VGND VPWR VPWR g_row\[0\].g_col\[1\].pe__2661_/X sky130_fd_sc_hd__or2_2
XTAP_TAPCELL_ROW_38_779 VGND VPWR sky130_fd_sc_hd__tapvpwrvgnd_1
Xg_row\[0\].g_col\[0\].pe__2645_ place1257/X hold2048/X VGND VGND VPWR VPWR g_row\[0\].g_col\[0\].pe__2645_/X
+ sky130_fd_sc_hd__or2_2
Xg_row\[0\].g_col\[1\].pe__1612_ g_row\[0\].g_col\[1\].pe__1851_/A g_row\[0\].g_col\[1\].pe__1851_/B
+ VGND VGND VPWR VPWR g_row\[0\].g_col\[1\].pe__1615_/A sky130_fd_sc_hd__xor2_2
Xg_row\[1\].g_col\[1\].pe__1396_ hold2084/X g_row\[1\].g_col\[1\].pe__1398_/B VGND
+ VGND VPWR VPWR g_row\[1\].g_col\[1\].pe__1396_/X sky130_fd_sc_hd__or2_2
Xg_row\[0\].g_col\[0\].pe__2576_ g_row\[0\].g_col\[0\].pe__2576_/A1 g_row\[0\].g_col\[0\].pe__2591_/A2
+ g_row\[0\].g_col\[0\].pe__2591_/B1 g_row\[0\].g_col\[0\].pe__2575_/X VGND VGND VPWR
+ VPWR g_row\[0\].g_col\[0\].pe__2576_/X sky130_fd_sc_hd__a22o_2
Xg_row\[0\].g_col\[1\].pe__2592_ g_row\[0\].g_col\[1\].pe__2592_/A g_row\[0\].g_col\[1\].pe__2592_/B
+ VGND VGND VPWR VPWR g_row\[0\].g_col\[1\].pe__2592_/X sky130_fd_sc_hd__and2_2
XTAP_TAPCELL_ROW_18_481 VGND VPWR sky130_fd_sc_hd__tapvpwrvgnd_1
Xg_row\[0\].g_col\[0\].pe__1527_ g_row\[0\].g_col\[0\].pe__1866_/B2 g_row\[0\].g_col\[0\].pe__1715_/B
+ g_row\[0\].g_col\[0\].pe__1863_/B1 place1213/X VGND VGND VPWR VPWR g_row\[0\].g_col\[0\].pe__1528_/B
+ sky130_fd_sc_hd__a22o_2
Xg_row\[0\].g_col\[1\].pe__1543_ g_row\[0\].g_col\[1\].pe__2603_/B g_row\[0\].g_col\[1\].pe__2313_/A2
+ g_row\[0\].g_col\[1\].pe__1541_/X g_row\[0\].g_col\[1\].pe__2690_/Q VGND VGND VPWR
+ VPWR g_row\[0\].g_col\[1\].pe__1544_/B sky130_fd_sc_hd__a22o_2
XFILLER_23_478 VGND VGND VPWR VPWR sky130_fd_sc_hd__decap_3
XFILLER_50_253 VGND VGND VPWR VPWR sky130_fd_sc_hd__decap_3
Xg_row\[0\].g_col\[1\].pe__1474_ g_row\[0\].g_col\[1\].pe__1977_/A g_row\[0\].g_col\[1\].pe__1471_/A
+ g_row\[0\].g_col\[1\].pe__1473_/X VGND VGND VPWR VPWR g_row\[0\].g_col\[1\].pe__1474_/Y
+ sky130_fd_sc_hd__o21ai_2
Xg_row\[1\].g_col\[1\].pe__2017_ g_row\[1\].g_col\[1\].pe__2017_/A VGND VGND VPWR
+ VPWR g_row\[1\].g_col\[1\].pe__2058_/A sky130_fd_sc_hd__inv_2
XFILLER_50_286 VGND VGND VPWR VPWR sky130_fd_sc_hd__fill_1
Xg_row\[0\].g_col\[0\].pe__1389_ g_row\[0\].g_col\[0\].pe__1389_/A g_row\[0\].g_col\[0\].pe__1402_/B
+ VGND VGND VPWR VPWR g_row\[0\].g_col\[0\].pe__1389_/X sky130_fd_sc_hd__or2_2
Xg_row\[0\].g_col\[1\].pe__2026_ g_row\[0\].g_col\[1\].pe__2121_/A g_row\[0\].g_col\[1\].pe__2026_/B
+ VGND VGND VPWR VPWR g_row\[0\].g_col\[1\].pe__2028_/B sky130_fd_sc_hd__nand2_2
XFILLER_58_386 VGND VGND VPWR VPWR sky130_fd_sc_hd__fill_2
Xg_row\[0\].g_col\[0\].pe_hold2007 g_row\[0\].g_col\[0\].pe_hold2956/X VGND VGND VPWR
+ VPWR g_row\[0\].g_col\[0\].pe__2733_/D sky130_fd_sc_hd__clkbuf_2
XFILLER_42_754 VGND VGND VPWR VPWR sky130_fd_sc_hd__fill_2
Xg_row\[0\].g_col\[0\].pe_hold2018 g_row\[0\].g_col\[0\].pe__2658_/X VGND VGND VPWR
+ VPWR g_row\[0\].g_col\[0\].pe__2714_/D sky130_fd_sc_hd__clkbuf_2
X_274_ _274_/CLK _274_/D VGND VGND VPWR VPWR _274_/Q sky130_fd_sc_hd__dfxtp_2
XTAP_TAPCELL_ROW_75_1331 VGND VPWR sky130_fd_sc_hd__tapvpwrvgnd_1
XTAP_TAPCELL_ROW_75_1342 VGND VPWR sky130_fd_sc_hd__tapvpwrvgnd_1
Xg_row\[1\].g_col\[1\].pe_hold2094 g_row\[1\].g_col\[1\].pe_hold3020/X VGND VGND VPWR
+ VPWR g_row\[1\].g_col\[1\].pe__2719_/D sky130_fd_sc_hd__clkbuf_2
Xg_row\[1\].g_col\[0\].pe__2421_ g_row\[1\].g_col\[0\].pe__2421_/A1 g_row\[1\].g_col\[0\].pe__2752_/Q
+ g_row\[1\].g_col\[0\].pe__2426_/B VGND VGND VPWR VPWR g_row\[1\].g_col\[0\].pe__2484_/A
+ sky130_fd_sc_hd__a21o_2
XFILLER_1_393 VGND VGND VPWR VPWR sky130_fd_sc_hd__fill_2
XFILLER_49_364 VGND VGND VPWR VPWR sky130_fd_sc_hd__decap_3
Xg_row\[1\].g_col\[0\].pe__2352_ g_row\[1\].g_col\[0\].pe__2352_/A g_row\[1\].g_col\[0\].pe__2352_/B
+ g_row\[1\].g_col\[0\].pe__2352_/C VGND VGND VPWR VPWR g_row\[1\].g_col\[0\].pe__2353_/B
+ sky130_fd_sc_hd__and3_2
Xg_row\[1\].g_col\[0\].pe__2283_ g_row\[1\].g_col\[0\].pe__2283_/A g_row\[1\].g_col\[0\].pe__2283_/B
+ VGND VGND VPWR VPWR g_row\[1\].g_col\[0\].pe__2284_/B sky130_fd_sc_hd__and2_2
XFILLER_52_518 VGND VGND VPWR VPWR sky130_fd_sc_hd__decap_3
XFILLER_91_186 VGND VGND VPWR VPWR sky130_fd_sc_hd__fill_1
XFILLER_92_698 VGND VGND VPWR VPWR sky130_fd_sc_hd__fill_2
XTAP_TAPCELL_ROW_35_738 VGND VPWR sky130_fd_sc_hd__tapvpwrvgnd_1
Xg_row\[0\].g_col\[0\].pe__2430_ g_row\[0\].g_col\[0\].pe__2430_/A g_row\[0\].g_col\[0\].pe__2430_/B
+ VGND VGND VPWR VPWR g_row\[0\].g_col\[0\].pe__2476_/B sky130_fd_sc_hd__xnor2_2
XTAP_TAPCELL_ROW_86_1493 VGND VPWR sky130_fd_sc_hd__tapvpwrvgnd_1
XFILLER_32_242 VGND VGND VPWR VPWR sky130_fd_sc_hd__decap_3
XFILLER_32_253 VGND VGND VPWR VPWR sky130_fd_sc_hd__fill_1
XTAP_TAPCELL_ROW_15_440 VGND VPWR sky130_fd_sc_hd__tapvpwrvgnd_1
Xg_row\[0\].g_col\[0\].pe__2361_ place1269/X g_row\[0\].g_col\[0\].pe__2361_/B VGND
+ VGND VPWR VPWR g_row\[0\].g_col\[0\].pe__2751_/D sky130_fd_sc_hd__nor2_2
XFILLER_60_595 VGND VGND VPWR VPWR sky130_fd_sc_hd__decap_3
Xg_row\[0\].g_col\[0\].pe__2292_ g_row\[0\].g_col\[0\].pe__2292_/A g_row\[0\].g_col\[0\].pe__2327_/B
+ VGND VGND VPWR VPWR g_row\[0\].g_col\[0\].pe__2292_/X sky130_fd_sc_hd__or2_2
XFILLER_9_493 VGND VGND VPWR VPWR sky130_fd_sc_hd__fill_1
Xg_row\[1\].g_col\[0\].pe__1998_ g_row\[1\].g_col\[0\].pe__1999_/A g_row\[1\].g_col\[0\].pe__1999_/B
+ VGND VGND VPWR VPWR g_row\[1\].g_col\[0\].pe__1998_/X sky130_fd_sc_hd__and2_2
Xg_row\[1\].g_col\[1\].pe__2704_ clkbuf_leaf_87_clk/X g_row\[1\].g_col\[1\].pe__2704_/D
+ VGND VGND VPWR VPWR g_row\[1\].g_col\[1\].pe__2704_/Q sky130_fd_sc_hd__dfxtp_2
Xg_row\[1\].g_col\[1\].pe__2635_ place1080/X place1082/X hold1989/A g_row\[1\].g_col\[1\].pe__2635_/D
+ VGND VGND VPWR VPWR g_row\[1\].g_col\[1\].pe__2635_/X sky130_fd_sc_hd__or4_2
Xg_row\[1\].g_col\[0\].pe__2619_ g_row\[1\].g_col\[0\].pe__2626_/A1 g_row\[1\].g_col\[0\].pe__2619_/A2
+ g_row\[1\].g_col\[0\].pe__2626_/B1 g_row\[1\].g_col\[0\].pe__2618_/X VGND VGND VPWR
+ VPWR g_row\[1\].g_col\[0\].pe__2619_/X sky130_fd_sc_hd__o211a_2
XFILLER_28_515 VGND VGND VPWR VPWR sky130_fd_sc_hd__fill_2
XFILLER_56_813 VGND VGND VPWR VPWR sky130_fd_sc_hd__fill_1
Xg_row\[1\].g_col\[1\].pe__2497_ g_row\[1\].g_col\[1\].pe__2497_/A g_row\[1\].g_col\[1\].pe__2497_/B
+ VGND VGND VPWR VPWR g_row\[1\].g_col\[1\].pe__2546_/B sky130_fd_sc_hd__nor2_2
Xg_row\[1\].g_col\[1\].pe__1517_ g_row\[1\].g_col\[1\].pe__1728_/A g_row\[1\].g_col\[1\].pe__1517_/B
+ VGND VGND VPWR VPWR g_row\[1\].g_col\[1\].pe__1580_/A sky130_fd_sc_hd__xnor2_2
Xg_row\[0\].g_col\[1\].pe_hold2126 g_row\[0\].g_col\[1\].pe_hold2167/X VGND VGND VPWR
+ VPWR g_row\[0\].g_col\[1\].pe__2673_/C sky130_fd_sc_hd__clkbuf_2
Xg_row\[0\].g_col\[1\].pe_hold2115 g_row\[0\].g_col\[1\].pe_hold3108/X VGND VGND VPWR
+ VPWR g_row\[0\].g_col\[1\].pe__2683_/A1 sky130_fd_sc_hd__clkbuf_2
Xg_row\[1\].g_col\[1\].pe_place1240 place1241/X VGND VGND VPWR VPWR g_row\[1\].g_col\[1\].pe__2676_/A
+ sky130_fd_sc_hd__buf_6
Xg_row\[1\].g_col\[1\].pe__1448_ g_row\[1\].g_col\[1\].pe__2729_/Q g_row\[1\].g_col\[1\].pe__2728_/Q
+ g_row\[1\].g_col\[1\].pe__2730_/Q VGND VGND VPWR VPWR g_row\[1\].g_col\[1\].pe__1449_/B
+ sky130_fd_sc_hd__or3b_4
Xg_row\[0\].g_col\[1\].pe_hold2148 g_row\[0\].g_col\[1\].pe__2652_/X VGND VGND VPWR
+ VPWR g_row\[0\].g_col\[1\].pe__2711_/D sky130_fd_sc_hd__clkbuf_2
Xg_row\[0\].g_col\[1\].pe__2713_ clkbuf_leaf_93_clk/X g_row\[0\].g_col\[1\].pe__2713_/D
+ VGND VGND VPWR VPWR hold2978/A sky130_fd_sc_hd__dfxtp_2
XFILLER_24_710 VGND VGND VPWR VPWR sky130_fd_sc_hd__decap_3
Xg_row\[0\].g_col\[0\].pe__2628_ g_row\[0\].g_col\[0\].pe__2628_/A1 g_row\[0\].g_col\[0\].pe__2628_/A2
+ g_row\[0\].g_col\[0\].pe__2628_/B1 g_row\[0\].g_col\[0\].pe__2627_/X VGND VGND VPWR
+ VPWR g_row\[0\].g_col\[0\].pe__2628_/X sky130_fd_sc_hd__o211a_2
Xg_row\[0\].g_col\[1\].pe__2644_ g_row\[0\].g_col\[1\].pe__2666_/A1 g_row\[0\].g_col\[1\].pe__2683_/A1
+ g_row\[0\].g_col\[1\].pe__2677_/B1 g_row\[0\].g_col\[1\].pe__2644_/C1 VGND VGND
+ VPWR VPWR g_row\[0\].g_col\[1\].pe__2644_/X sky130_fd_sc_hd__o211a_2
XFILLER_24_732 VGND VGND VPWR VPWR sky130_fd_sc_hd__fill_2
Xg_row\[0\].g_col\[1\].pe__2575_ g_row\[0\].g_col\[1\].pe__2575_/A g_row\[0\].g_col\[1\].pe__2586_/A
+ VGND VGND VPWR VPWR g_row\[0\].g_col\[1\].pe__2575_/X sky130_fd_sc_hd__or2_2
XFILLER_90_29 VGND VGND VPWR VPWR sky130_fd_sc_hd__decap_3
Xg_row\[0\].g_col\[0\].pe__2559_ g_row\[0\].g_col\[0\].pe__2559_/A g_row\[0\].g_col\[0\].pe__2559_/B
+ VGND VGND VPWR VPWR g_row\[0\].g_col\[0\].pe__2559_/X sky130_fd_sc_hd__or2_2
Xg_row\[0\].g_col\[1\].pe__1526_ g_row\[0\].g_col\[1\].pe__1862_/A g_row\[0\].g_col\[1\].pe__1526_/B
+ VGND VGND VPWR VPWR g_row\[0\].g_col\[1\].pe__1554_/A sky130_fd_sc_hd__xor2_2
XFILLER_51_584 VGND VGND VPWR VPWR sky130_fd_sc_hd__decap_3
Xg_row\[0\].g_col\[1\].pe__1457_ g_row\[0\].g_col\[1\].pe__2731_/Q g_row\[0\].g_col\[1\].pe__2730_/Q
+ VGND VGND VPWR VPWR g_row\[0\].g_col\[1\].pe__1457_/X sky130_fd_sc_hd__xor2_2
Xg_row\[0\].g_col\[1\].pe__1388_ g_row\[0\].g_col\[1\].pe__1816_/A g_row\[0\].g_col\[1\].pe__2686_/B
+ g_row\[0\].g_col\[1\].pe__1387_/X g_row\[0\].g_col\[1\].pe__2687_/C1 VGND VGND VPWR
+ VPWR g_row\[0\].g_col\[1\].pe__2730_/D sky130_fd_sc_hd__o211a_2
Xg_row\[0\].g_col\[0\].pe_place866 g_row\[0\].g_col\[0\].pe__1541_/X VGND VGND VPWR
+ VPWR g_row\[0\].g_col\[0\].pe__2279_/B1 sky130_fd_sc_hd__buf_6
XTAP_TAPCELL_ROW_57_1061 VGND VPWR sky130_fd_sc_hd__tapvpwrvgnd_1
XTAP_TAPCELL_ROW_57_1072 VGND VPWR sky130_fd_sc_hd__tapvpwrvgnd_1
Xg_row\[0\].g_col\[1\].pe__2009_ g_row\[0\].g_col\[1\].pe__2006_/A g_row\[0\].g_col\[1\].pe__2009_/B
+ g_row\[0\].g_col\[1\].pe__2009_/C VGND VGND VPWR VPWR g_row\[0\].g_col\[1\].pe__2010_/D
+ sky130_fd_sc_hd__and3b_2
XFILLER_59_673 VGND VGND VPWR VPWR sky130_fd_sc_hd__decap_3
XTAP_TAPCELL_ROW_70_1261 VGND VPWR sky130_fd_sc_hd__tapvpwrvgnd_1
XFILLER_19_537 VGND VGND VPWR VPWR sky130_fd_sc_hd__decap_3
XFILLER_46_389 VGND VGND VPWR VPWR sky130_fd_sc_hd__fill_1
XFILLER_15_754 VGND VGND VPWR VPWR sky130_fd_sc_hd__decap_3
XFILLER_27_592 VGND VGND VPWR VPWR sky130_fd_sc_hd__fill_2
XFILLER_64_85 VGND VGND VPWR VPWR sky130_fd_sc_hd__decap_3
X_326_ _340_/CLK _326_/D VGND VGND VPWR VPWR _326_/Q sky130_fd_sc_hd__dfxtp_2
X_257_ _267_/A _257_/B_N VGND VGND VPWR VPWR _257_/Y sky130_fd_sc_hd__nor2b_4
Xg_row\[1\].g_col\[0\].pe__1921_ place1080/X g_row\[1\].g_col\[0\].pe__1982_/B VGND
+ VGND VPWR VPWR g_row\[1\].g_col\[0\].pe__1924_/B sky130_fd_sc_hd__and2_2
Xg_row\[1\].g_col\[0\].pe__1852_ g_row\[1\].g_col\[0\].pe__1615_/A g_row\[1\].g_col\[0\].pe__1615_/B
+ g_row\[1\].g_col\[0\].pe__1851_/X VGND VGND VPWR VPWR g_row\[1\].g_col\[0\].pe__1859_/A
+ sky130_fd_sc_hd__a21o_2
Xg_row\[1\].g_col\[0\].pe__1783_ g_row\[1\].g_col\[0\].pe__1808_/A g_row\[1\].g_col\[0\].pe__1783_/B
+ VGND VGND VPWR VPWR g_row\[1\].g_col\[0\].pe__1796_/A sky130_fd_sc_hd__xnor2_2
Xg_row\[0\].g_col\[0\].pe__1930_ g_row\[0\].g_col\[0\].pe__1994_/A g_row\[0\].g_col\[0\].pe__1994_/B
+ VGND VGND VPWR VPWR g_row\[0\].g_col\[0\].pe__1931_/B sky130_fd_sc_hd__xor2_2
Xg_row\[1\].g_col\[1\].pe__2420_ g_row\[1\].g_col\[1\].pe__2754_/Q g_row\[1\].g_col\[1\].pe__2336_/Y
+ g_row\[1\].g_col\[1\].pe__2429_/B VGND VGND VPWR VPWR g_row\[1\].g_col\[1\].pe__2426_/B
+ sky130_fd_sc_hd__o21ai_2
XFILLER_29_3 VGND VGND VPWR VPWR sky130_fd_sc_hd__fill_1
Xg_row\[0\].g_col\[0\].pe__1861_ place1201/A g_row\[0\].g_col\[0\].pe__2026_/B g_row\[0\].g_col\[0\].pe__1449_/Y
+ hold2339/A VGND VGND VPWR VPWR g_row\[0\].g_col\[0\].pe__1862_/B sky130_fd_sc_hd__a22o_2
Xhold1609 hold3542/X VGND VGND VPWR VPWR hold3543/A sky130_fd_sc_hd__clkbuf_2
Xg_row\[1\].g_col\[0\].pe__2404_ g_row\[1\].g_col\[0\].pe__2404_/A1 g_row\[1\].g_col\[0\].pe__2403_/Y
+ g_row\[1\].g_col\[0\].pe__2404_/B1 g_row\[1\].g_col\[0\].pe__2010_/A VGND VGND VPWR
+ VPWR g_row\[1\].g_col\[0\].pe__2404_/X sky130_fd_sc_hd__o22a_2
XFILLER_65_610 VGND VGND VPWR VPWR sky130_fd_sc_hd__decap_3
XFILLER_65_632 VGND VGND VPWR VPWR sky130_fd_sc_hd__decap_3
XTAP_TAPCELL_ROW_88_1533 VGND VPWR sky130_fd_sc_hd__tapvpwrvgnd_1
Xg_row\[0\].g_col\[0\].pe__1792_ g_row\[0\].g_col\[0\].pe__1792_/A VGND VGND VPWR
+ VPWR g_row\[0\].g_col\[0\].pe__1795_/A sky130_fd_sc_hd__inv_2
Xg_row\[1\].g_col\[1\].pe__2351_ g_row\[1\].g_col\[1\].pe__2352_/A g_row\[1\].g_col\[1\].pe__2352_/B
+ g_row\[1\].g_col\[1\].pe__2352_/C VGND VGND VPWR VPWR g_row\[1\].g_col\[1\].pe__2375_/A
+ sky130_fd_sc_hd__a21oi_2
Xg_row\[1\].g_col\[0\].pe__2335_ place1268/X g_row\[1\].g_col\[0\].pe__2335_/B VGND
+ VGND VPWR VPWR g_row\[1\].g_col\[0\].pe__2750_/D sky130_fd_sc_hd__nor2_2
XFILLER_49_194 VGND VGND VPWR VPWR sky130_fd_sc_hd__fill_1
XFILLER_65_676 VGND VGND VPWR VPWR sky130_fd_sc_hd__fill_1
Xg_row\[1\].g_col\[1\].pe__2282_ g_row\[1\].g_col\[1\].pe__2283_/A g_row\[1\].g_col\[1\].pe__2283_/B
+ VGND VGND VPWR VPWR g_row\[1\].g_col\[1\].pe__2284_/A sky130_fd_sc_hd__nor2_2
XFILLER_65_698 VGND VGND VPWR VPWR sky130_fd_sc_hd__decap_3
Xg_row\[1\].g_col\[0\].pe__2266_ g_row\[1\].g_col\[0\].pe__2266_/A VGND VGND VPWR
+ VPWR g_row\[1\].g_col\[0\].pe__2266_/Y sky130_fd_sc_hd__inv_2
XFILLER_18_592 VGND VGND VPWR VPWR sky130_fd_sc_hd__decap_3
XFILLER_64_197 VGND VGND VPWR VPWR sky130_fd_sc_hd__fill_1
Xg_row\[1\].g_col\[0\].pe_place1114 g_row\[1\].g_col\[0\].pe__2595_/A VGND VGND VPWR
+ VPWR g_row\[1\].g_col\[0\].pe__2561_/A sky130_fd_sc_hd__buf_6
Xg_row\[1\].g_col\[0\].pe_place1103 place1104/A VGND VGND VPWR VPWR g_row\[1\].g_col\[0\].pe__2603_/B
+ sky130_fd_sc_hd__buf_6
Xg_row\[1\].g_col\[0\].pe__2197_ g_row\[1\].g_col\[0\].pe__2161_/Y g_row\[1\].g_col\[0\].pe__2157_/B
+ g_row\[1\].g_col\[0\].pe__2200_/B VGND VGND VPWR VPWR g_row\[1\].g_col\[0\].pe__2197_/Y
+ sky130_fd_sc_hd__a21oi_2
Xg_row\[0\].g_col\[0\].pe__2413_ g_row\[0\].g_col\[0\].pe__2450_/A1 g_row\[0\].g_col\[0\].pe__2744_/Q
+ g_row\[0\].g_col\[0\].pe__2445_/B VGND VGND VPWR VPWR g_row\[0\].g_col\[0\].pe__2441_/B
+ sky130_fd_sc_hd__a21oi_2
XFILLER_21_724 VGND VGND VPWR VPWR sky130_fd_sc_hd__decap_3
XFILLER_33_595 VGND VGND VPWR VPWR sky130_fd_sc_hd__fill_1
Xg_row\[0\].g_col\[0\].pe__2344_ g_row\[0\].g_col\[0\].pe__2345_/A g_row\[0\].g_col\[0\].pe__2345_/B
+ VGND VGND VPWR VPWR g_row\[0\].g_col\[0\].pe__2346_/A sky130_fd_sc_hd__nand2_2
Xg_row\[0\].g_col\[1\].pe__2360_ g_row\[0\].g_col\[1\].pe__2406_/B1 g_row\[0\].g_col\[1\].pe__2360_/A2
+ g_row\[0\].g_col\[1\].pe__2404_/B2 g_row\[0\].g_col\[1\].pe__2359_/Y VGND VGND VPWR
+ VPWR g_row\[0\].g_col\[1\].pe__2360_/X sky130_fd_sc_hd__o22a_2
Xg_row\[0\].g_col\[1\].pe_place963 g_row\[0\].g_col\[1\].pe__1838_/A VGND VGND VPWR
+ VPWR g_row\[0\].g_col\[1\].pe__2633_/A1 sky130_fd_sc_hd__buf_6
Xg_row\[0\].g_col\[1\].pe_place952 g_row\[0\].g_col\[1\].pe__2026_/B VGND VGND VPWR
+ VPWR g_row\[0\].g_col\[1\].pe__1748_/B sky130_fd_sc_hd__buf_6
Xg_row\[0\].g_col\[1\].pe_place941 g_row\[0\].g_col\[1\].pe__2406_/Y VGND VGND VPWR
+ VPWR g_row\[0\].g_col\[1\].pe__2591_/A2 sky130_fd_sc_hd__buf_6
Xg_row\[0\].g_col\[1\].pe__2291_ g_row\[0\].g_col\[1\].pe__2291_/A g_row\[0\].g_col\[1\].pe__2291_/B
+ VGND VGND VPWR VPWR g_row\[0\].g_col\[1\].pe__2327_/B sky130_fd_sc_hd__and2_2
Xg_row\[0\].g_col\[0\].pe__2275_ g_row\[0\].g_col\[0\].pe__2388_/A g_row\[0\].g_col\[0\].pe__2733_/Q
+ g_row\[0\].g_col\[0\].pe__1912_/A g_row\[0\].g_col\[0\].pe__2345_/A VGND VGND VPWR
+ VPWR g_row\[0\].g_col\[0\].pe__2276_/B sky130_fd_sc_hd__a211o_2
Xg_row\[1\].g_col\[1\].pe__1997_ g_row\[1\].g_col\[1\].pe__1997_/A g_row\[1\].g_col\[1\].pe__1997_/B
+ VGND VGND VPWR VPWR g_row\[1\].g_col\[1\].pe__2014_/B sky130_fd_sc_hd__xor2_2
Xhold3501 clear_acc VGND VGND VPWR VPWR hold3501/X sky130_fd_sc_hd__clkbuf_2
XFILLER_0_617 VGND VGND VPWR VPWR sky130_fd_sc_hd__fill_1
Xhold3534 hold3534/A VGND VGND VPWR VPWR hold3534/X sky130_fd_sc_hd__clkbuf_2
Xhold3523 hold3523/A VGND VGND VPWR VPWR hold3523/X sky130_fd_sc_hd__clkbuf_2
Xhold3512 hold3512/A VGND VGND VPWR VPWR hold3512/X sky130_fd_sc_hd__clkbuf_2
XFILLER_0_639 VGND VGND VPWR VPWR sky130_fd_sc_hd__decap_3
XFILLER_88_757 VGND VGND VPWR VPWR sky130_fd_sc_hd__decap_3
Xhold2800 hold3593/X VGND VGND VPWR VPWR hold3594/A sky130_fd_sc_hd__clkbuf_2
Xhold2811 hold3573/X VGND VGND VPWR VPWR hold3574/A sky130_fd_sc_hd__clkbuf_2
Xhold3567 hold3567/A VGND VGND VPWR VPWR hold3567/X sky130_fd_sc_hd__clkbuf_2
Xhold3556 hold3556/A VGND VGND VPWR VPWR hold3556/X sky130_fd_sc_hd__clkbuf_2
Xhold3545 hold3545/A VGND VGND VPWR VPWR hold3545/X sky130_fd_sc_hd__clkbuf_2
Xhold3589 b_inputs_flat[27] VGND VGND VPWR VPWR hold3589/X sky130_fd_sc_hd__clkbuf_2
Xhold3578 hold3578/A VGND VGND VPWR VPWR hold3578/X sky130_fd_sc_hd__clkbuf_2
Xg_row\[1\].g_col\[1\].pe__2618_ place1247/X g_row\[1\].g_col\[1\].pe__2618_/B VGND
+ VGND VPWR VPWR g_row\[1\].g_col\[1\].pe__2618_/X sky130_fd_sc_hd__or2_2
XFILLER_56_632 VGND VGND VPWR VPWR sky130_fd_sc_hd__fill_2
Xg_row\[1\].g_col\[1\].pe__2549_ g_row\[1\].g_col\[1\].pe__2569_/A g_row\[1\].g_col\[1\].pe__2549_/B
+ VGND VGND VPWR VPWR g_row\[1\].g_col\[1\].pe__2761_/D sky130_fd_sc_hd__and2_2
XFILLER_71_624 VGND VGND VPWR VPWR sky130_fd_sc_hd__decap_3
XFILLER_12_713 VGND VGND VPWR VPWR sky130_fd_sc_hd__fill_1
Xg_row\[0\].g_col\[1\].pe__2627_ place1248/X g_row\[0\].g_col\[1\].pe__2627_/B VGND
+ VGND VPWR VPWR g_row\[0\].g_col\[1\].pe__2627_/X sky130_fd_sc_hd__or2_2
XFILLER_12_746 VGND VGND VPWR VPWR sky130_fd_sc_hd__decap_3
XFILLER_51_370 VGND VGND VPWR VPWR sky130_fd_sc_hd__decap_3
Xg_row\[0\].g_col\[1\].pe_place1124 g_row\[0\].g_col\[1\].pe__2730_/Q VGND VGND VPWR
+ VPWR g_row\[0\].g_col\[1\].pe__1459_/C sky130_fd_sc_hd__buf_6
Xg_row\[0\].g_col\[1\].pe__2558_ g_row\[0\].g_col\[1\].pe__2558_/A g_row\[0\].g_col\[1\].pe__2558_/B
+ VGND VGND VPWR VPWR g_row\[0\].g_col\[1\].pe__2559_/B sky130_fd_sc_hd__xor2_2
XFILLER_12_757 VGND VGND VPWR VPWR sky130_fd_sc_hd__decap_3
Xg_row\[0\].g_col\[1\].pe__1509_ g_row\[0\].g_col\[1\].pe__1535_/B g_row\[0\].g_col\[1\].pe__1549_/C
+ VGND VGND VPWR VPWR g_row\[0\].g_col\[1\].pe__1640_/B sky130_fd_sc_hd__xnor2_2
Xg_row\[0\].g_col\[1\].pe_place1157 g_row\[0\].g_col\[1\].pe__1957_/B2 VGND VGND VPWR
+ VPWR g_row\[0\].g_col\[1\].pe__1782_/A2 sky130_fd_sc_hd__buf_6
Xg_row\[0\].g_col\[1\].pe_place1146 g_row\[0\].g_col\[1\].pe__2699_/Q VGND VGND VPWR
+ VPWR g_row\[0\].g_col\[1\].pe__1911_/A1 sky130_fd_sc_hd__buf_6
Xg_row\[0\].g_col\[1\].pe_place1135 g_row\[0\].g_col\[1\].pe__2704_/Q VGND VGND VPWR
+ VPWR g_row\[0\].g_col\[1\].pe__2632_/B sky130_fd_sc_hd__buf_6
Xg_row\[0\].g_col\[1\].pe__2489_ g_row\[0\].g_col\[1\].pe__2474_/Y g_row\[0\].g_col\[1\].pe__2489_/B
+ g_row\[0\].g_col\[1\].pe__2492_/A VGND VGND VPWR VPWR g_row\[0\].g_col\[1\].pe__2490_/B
+ sky130_fd_sc_hd__and3b_2
XFILLER_11_278 VGND VGND VPWR VPWR sky130_fd_sc_hd__fill_2
Xg_row\[0\].g_col\[1\].pe_place1168 g_row\[0\].g_col\[1\].pe__2626_/B1 VGND VGND VPWR
+ VPWR g_row\[0\].g_col\[1\].pe__2679_/C1 sky130_fd_sc_hd__buf_6
XTAP_TAPCELL_ROW_59_1101 VGND VPWR sky130_fd_sc_hd__tapvpwrvgnd_1
XFILLER_79_724 VGND VGND VPWR VPWR sky130_fd_sc_hd__decap_3
XTAP_TAPCELL_ROW_6_293 VGND VPWR sky130_fd_sc_hd__tapvpwrvgnd_1
Xg_row\[1\].g_col\[0\].pe_hold1829 g_row\[1\].g_col\[0\].pe__2762_/Q VGND VGND VPWR
+ VPWR g_row\[1\].g_col\[0\].pe__2554_/A1 sky130_fd_sc_hd__clkbuf_2
XFILLER_47_687 VGND VGND VPWR VPWR sky130_fd_sc_hd__fill_2
Xg_row\[1\].g_col\[0\].pe__2120_ g_row\[1\].g_col\[0\].pe__2078_/A g_row\[1\].g_col\[0\].pe__2078_/B
+ g_row\[1\].g_col\[0\].pe__2119_/X VGND VGND VPWR VPWR g_row\[1\].g_col\[0\].pe__2147_/A
+ sky130_fd_sc_hd__a21o_2
Xg_row\[1\].g_col\[0\].pe__2051_ g_row\[1\].g_col\[0\].pe__2048_/Y g_row\[1\].g_col\[0\].pe__2049_/X
+ g_row\[1\].g_col\[0\].pe__2025_/Y g_row\[1\].g_col\[0\].pe__1991_/X VGND VGND VPWR
+ VPWR g_row\[1\].g_col\[0\].pe__2052_/C sky130_fd_sc_hd__a211oi_2
XTAP_TAPCELL_ROW_45_888 VGND VPWR sky130_fd_sc_hd__tapvpwrvgnd_1
XTAP_TAPCELL_ROW_83_1452 VGND VPWR sky130_fd_sc_hd__tapvpwrvgnd_1
XTAP_TAPCELL_ROW_25_590 VGND VPWR sky130_fd_sc_hd__tapvpwrvgnd_1
X_309_ _309_/CLK _309_/D VGND VGND VPWR VPWR _309_/Q sky130_fd_sc_hd__dfxtp_2
Xg_row\[0\].g_col\[0\].pe__2060_ g_row\[0\].g_col\[0\].pe__2153_/A g_row\[0\].g_col\[0\].pe__2153_/B
+ VGND VGND VPWR VPWR g_row\[0\].g_col\[0\].pe__2150_/C sky130_fd_sc_hd__xor2_2
Xg_row\[1\].g_col\[1\].pe__1920_ g_row\[1\].g_col\[1\].pe__2125_/A g_row\[1\].g_col\[1\].pe__1920_/A2
+ g_row\[1\].g_col\[1\].pe__2043_/A VGND VGND VPWR VPWR g_row\[1\].g_col\[1\].pe__1980_/A
+ sky130_fd_sc_hd__o21bai_2
Xg_row\[1\].g_col\[0\].pe__1904_ g_row\[1\].g_col\[0\].pe__1905_/A g_row\[1\].g_col\[0\].pe__1905_/B
+ VGND VGND VPWR VPWR g_row\[1\].g_col\[0\].pe__1964_/A sky130_fd_sc_hd__nand2_2
Xg_row\[1\].g_col\[1\].pe__1851_ g_row\[1\].g_col\[1\].pe__1851_/A g_row\[1\].g_col\[1\].pe__1851_/B
+ VGND VGND VPWR VPWR g_row\[1\].g_col\[1\].pe__1851_/X sky130_fd_sc_hd__and2_2
Xg_row\[1\].g_col\[0\].pe__1835_ g_row\[1\].g_col\[0\].pe__1950_/A g_row\[1\].g_col\[0\].pe__1835_/A2
+ g_row\[1\].g_col\[0\].pe__2157_/A g_row\[1\].g_col\[0\].pe__1834_/Y VGND VGND VPWR
+ VPWR g_row\[1\].g_col\[0\].pe__1835_/X sky130_fd_sc_hd__a22o_2
Xg_row\[1\].g_col\[1\].pe__1782_ g_row\[1\].g_col\[1\].pe__1804_/A g_row\[1\].g_col\[1\].pe__1782_/A2
+ g_row\[1\].g_col\[1\].pe__2692_/Q g_row\[1\].g_col\[1\].pe__1804_/B VGND VGND VPWR
+ VPWR g_row\[1\].g_col\[1\].pe__1783_/B sky130_fd_sc_hd__a22o_2
Xg_row\[1\].g_col\[0\].pe__1766_ g_row\[1\].g_col\[0\].pe__1766_/A g_row\[1\].g_col\[0\].pe__1766_/B
+ VGND VGND VPWR VPWR g_row\[1\].g_col\[0\].pe__1781_/A sky130_fd_sc_hd__xor2_2
Xg_row\[0\].g_col\[0\].pe__1913_ g_row\[0\].g_col\[0\].pe__1955_/A g_row\[0\].g_col\[0\].pe__1955_/B
+ VGND VGND VPWR VPWR g_row\[0\].g_col\[0\].pe__1916_/A sky130_fd_sc_hd__xor2_2
Xg_row\[1\].g_col\[0\].pe__1697_ g_row\[1\].g_col\[0\].pe__1697_/A g_row\[1\].g_col\[0\].pe__1697_/B
+ VGND VGND VPWR VPWR g_row\[1\].g_col\[0\].pe__1699_/B sky130_fd_sc_hd__xnor2_2
Xg_row\[0\].g_col\[0\].pe__1844_ g_row\[0\].g_col\[0\].pe__1844_/A g_row\[0\].g_col\[0\].pe__1844_/B
+ VGND VGND VPWR VPWR g_row\[0\].g_col\[0\].pe__1894_/A sky130_fd_sc_hd__and2_2
Xhold1439 hold3149/X VGND VGND VPWR VPWR hold3150/A sky130_fd_sc_hd__clkbuf_2
Xg_row\[1\].g_col\[1\].pe__2403_ g_row\[1\].g_col\[1\].pe__2403_/A VGND VGND VPWR
+ VPWR g_row\[1\].g_col\[1\].pe__2403_/Y sky130_fd_sc_hd__inv_2
Xg_row\[0\].g_col\[1\].pe__1860_ g_row\[0\].g_col\[1\].pe__1860_/A g_row\[0\].g_col\[1\].pe__1860_/B
+ VGND VGND VPWR VPWR g_row\[0\].g_col\[1\].pe__1882_/A sky130_fd_sc_hd__xor2_2
XFILLER_93_760 VGND VGND VPWR VPWR sky130_fd_sc_hd__decap_3
Xg_row\[1\].g_col\[1\].pe__2334_ g_row\[1\].g_col\[1\].pe__2334_/A1 g_row\[1\].g_col\[1\].pe__2334_/A2
+ g_row\[1\].g_col\[1\].pe__2331_/X g_row\[1\].g_col\[1\].pe__2333_/Y VGND VGND VPWR
+ VPWR g_row\[1\].g_col\[1\].pe__2334_/X sky130_fd_sc_hd__o22a_2
Xg_row\[0\].g_col\[1\].pe__1791_ g_row\[0\].g_col\[1\].pe__1791_/A g_row\[0\].g_col\[1\].pe__1797_/A
+ VGND VGND VPWR VPWR g_row\[0\].g_col\[1\].pe__1792_/A sky130_fd_sc_hd__nor2_2
XFILLER_1_81 VGND VGND VPWR VPWR sky130_fd_sc_hd__fill_1
Xg_row\[0\].g_col\[0\].pe__1775_ place1221/X g_row\[0\].g_col\[0\].pe__1748_/B g_row\[0\].g_col\[0\].pe__1760_/B
+ g_row\[0\].g_col\[0\].pe__1774_/Y VGND VGND VPWR VPWR g_row\[0\].g_col\[0\].pe__1777_/A
+ sky130_fd_sc_hd__a31o_2
Xg_row\[1\].g_col\[0\].pe__2318_ g_row\[1\].g_col\[0\].pe__2318_/A g_row\[1\].g_col\[0\].pe__2318_/B
+ VGND VGND VPWR VPWR g_row\[1\].g_col\[0\].pe__2319_/B sky130_fd_sc_hd__xor2_2
XFILLER_25_337 VGND VGND VPWR VPWR sky130_fd_sc_hd__fill_2
XFILLER_52_112 VGND VGND VPWR VPWR sky130_fd_sc_hd__fill_2
XFILLER_52_134 VGND VGND VPWR VPWR sky130_fd_sc_hd__fill_2
XFILLER_80_421 VGND VGND VPWR VPWR sky130_fd_sc_hd__fill_1
XFILLER_92_292 VGND VGND VPWR VPWR sky130_fd_sc_hd__fill_1
Xg_row\[1\].g_col\[1\].pe__2265_ g_row\[1\].g_col\[1\].pe__2238_/X g_row\[1\].g_col\[1\].pe__2234_/Y
+ g_row\[1\].g_col\[1\].pe__2263_/X VGND VGND VPWR VPWR g_row\[1\].g_col\[1\].pe__2265_/Y
+ sky130_fd_sc_hd__o21ai_2
Xg_row\[1\].g_col\[0\].pe__2249_ g_row\[1\].g_col\[0\].pe__2250_/A g_row\[1\].g_col\[0\].pe__2250_/B
+ VGND VGND VPWR VPWR g_row\[1\].g_col\[0\].pe__2283_/A sky130_fd_sc_hd__or2_2
XFILLER_40_307 VGND VGND VPWR VPWR sky130_fd_sc_hd__fill_1
Xg_row\[1\].g_col\[1\].pe__2196_ g_row\[1\].g_col\[1\].pe__2161_/Y g_row\[1\].g_col\[1\].pe__2157_/B
+ g_row\[1\].g_col\[1\].pe__2200_/B g_row\[1\].g_col\[1\].pe__2394_/B1 VGND VGND VPWR
+ VPWR g_row\[1\].g_col\[1\].pe__2196_/X sky130_fd_sc_hd__a31o_2
XFILLER_21_521 VGND VGND VPWR VPWR sky130_fd_sc_hd__decap_3
XFILLER_33_370 VGND VGND VPWR VPWR sky130_fd_sc_hd__fill_2
Xg_row\[0\].g_col\[1\].pe__2412_ g_row\[0\].g_col\[1\].pe__2743_/Q g_row\[0\].g_col\[1\].pe__2742_/Q
+ g_row\[0\].g_col\[1\].pe__2741_/Q g_row\[0\].g_col\[1\].pe__2455_/B g_row\[0\].g_col\[1\].pe__2421_/A1
+ VGND VGND VPWR VPWR g_row\[0\].g_col\[1\].pe__2445_/B sky130_fd_sc_hd__o41a_2
XTAP_TAPCELL_ROW_23_549 VGND VPWR sky130_fd_sc_hd__tapvpwrvgnd_1
Xg_row\[0\].g_col\[1\].pe__2343_ g_row\[0\].g_col\[1\].pe__2343_/A g_row\[0\].g_col\[1\].pe__2365_/A
+ VGND VGND VPWR VPWR g_row\[0\].g_col\[1\].pe__2345_/B sky130_fd_sc_hd__xor2_2
Xg_row\[0\].g_col\[0\].pe__2327_ g_row\[0\].g_col\[0\].pe__2327_/A g_row\[0\].g_col\[0\].pe__2327_/B
+ g_row\[0\].g_col\[0\].pe__2327_/C VGND VGND VPWR VPWR g_row\[0\].g_col\[0\].pe__2328_/B
+ sky130_fd_sc_hd__nor3_2
Xinput1327 hold3189/X VGND VGND VPWR VPWR hold3190/A sky130_fd_sc_hd__buf_2
Xinput1316 hold3238/X VGND VGND VPWR VPWR hold3239/A sky130_fd_sc_hd__buf_2
Xinput1305 hold3525/X VGND VGND VPWR VPWR hold3526/A sky130_fd_sc_hd__buf_2
Xg_row\[0\].g_col\[0\].pe__2258_ g_row\[0\].g_col\[0\].pe__2258_/A g_row\[0\].g_col\[0\].pe__2258_/B
+ VGND VGND VPWR VPWR g_row\[0\].g_col\[0\].pe__2258_/X sky130_fd_sc_hd__and2_2
Xinput1349 hold3245/X VGND VGND VPWR VPWR hold3246/A sky130_fd_sc_hd__buf_2
Xinput1338 hold3322/X VGND VGND VPWR VPWR hold3323/A sky130_fd_sc_hd__buf_2
Xg_row\[0\].g_col\[1\].pe__2274_ g_row\[0\].g_col\[1\].pe__2125_/A g_row\[0\].g_col\[1\].pe__2733_/Q
+ g_row\[0\].g_col\[1\].pe__1673_/A g_row\[0\].g_col\[1\].pe__1977_/A VGND VGND VPWR
+ VPWR g_row\[0\].g_col\[1\].pe__2318_/A sky130_fd_sc_hd__o211a_2
XFILLER_20_57 VGND VGND VPWR VPWR sky130_fd_sc_hd__fill_1
Xg_row\[0\].g_col\[0\].pe__2189_ g_row\[0\].g_col\[0\].pe__2190_/A g_row\[0\].g_col\[0\].pe__2190_/B
+ VGND VGND VPWR VPWR g_row\[0\].g_col\[0\].pe__2191_/A sky130_fd_sc_hd__and2_4
XTAP_TAPCELL_ROW_54_1020 VGND VPWR sky130_fd_sc_hd__tapvpwrvgnd_1
XFILLER_0_414 VGND VGND VPWR VPWR sky130_fd_sc_hd__fill_2
Xhold3320 hold3320/A VGND VGND VPWR VPWR hold3320/X sky130_fd_sc_hd__clkbuf_2
Xhold3331 hold3331/A VGND VGND VPWR VPWR hold3331/X sky130_fd_sc_hd__clkbuf_2
Xhold3342 hold3342/A VGND VGND VPWR VPWR hold3342/X sky130_fd_sc_hd__clkbuf_2
Xg_row\[1\].g_col\[1\].pe_hold1948 g_row\[1\].g_col\[1\].pe__2621_/X VGND VGND VPWR
+ VPWR g_row\[1\].g_col\[1\].pe__2622_/C1 sky130_fd_sc_hd__clkbuf_2
XFILLER_0_469 VGND VGND VPWR VPWR sky130_fd_sc_hd__fill_2
Xhold2630 hold3347/X VGND VGND VPWR VPWR hold3348/A sky130_fd_sc_hd__clkbuf_2
Xhold3353 hold3353/A VGND VGND VPWR VPWR hold3353/X sky130_fd_sc_hd__clkbuf_2
Xhold3364 hold3364/A VGND VGND VPWR VPWR hold3364/X sky130_fd_sc_hd__clkbuf_2
Xhold3375 a_inputs_flat[21] VGND VGND VPWR VPWR hold3375/X sky130_fd_sc_hd__clkbuf_2
XFILLER_88_587 VGND VGND VPWR VPWR sky130_fd_sc_hd__fill_1
Xhold2641 hold2641/A VGND VGND VPWR VPWR _299_/D sky130_fd_sc_hd__clkbuf_2
Xhold2652 _253_/Y VGND VGND VPWR VPWR hold2652/X sky130_fd_sc_hd__clkbuf_2
Xhold2663 hold3423/X VGND VGND VPWR VPWR _211_/B_N sky130_fd_sc_hd__clkbuf_2
Xhold2674 hold3463/X VGND VGND VPWR VPWR hold3464/A sky130_fd_sc_hd__clkbuf_2
Xhold3386 hold3386/A VGND VGND VPWR VPWR hold3386/X sky130_fd_sc_hd__clkbuf_2
Xhold3397 hold3397/A VGND VGND VPWR VPWR hold3397/X sky130_fd_sc_hd__clkbuf_2
XTAP_TAPCELL_ROW_3_252 VGND VPWR sky130_fd_sc_hd__tapvpwrvgnd_1
Xhold2685 hold3440/X VGND VGND VPWR VPWR hold3441/A sky130_fd_sc_hd__clkbuf_2
Xhold2696 hold3473/X VGND VGND VPWR VPWR hold3474/A sky130_fd_sc_hd__clkbuf_2
XFILLER_29_676 VGND VGND VPWR VPWR sky130_fd_sc_hd__decap_3
Xg_row\[0\].g_col\[1\].pe__1989_ g_row\[0\].g_col\[1\].pe__1919_/B g_row\[0\].g_col\[1\].pe__1980_/X
+ g_row\[0\].g_col\[1\].pe__1981_/Y g_row\[0\].g_col\[1\].pe__1987_/Y g_row\[0\].g_col\[1\].pe__1988_/X
+ VGND VGND VPWR VPWR g_row\[0\].g_col\[1\].pe__1991_/C sky130_fd_sc_hd__a311o_2
XFILLER_28_197 VGND VGND VPWR VPWR sky130_fd_sc_hd__decap_3
XFILLER_56_495 VGND VGND VPWR VPWR sky130_fd_sc_hd__decap_3
XTAP_TAPCELL_ROW_42_836 VGND VPWR sky130_fd_sc_hd__tapvpwrvgnd_1
XTAP_TAPCELL_ROW_42_847 VGND VPWR sky130_fd_sc_hd__tapvpwrvgnd_1
XTAP_TAPCELL_ROW_65_1182 VGND VPWR sky130_fd_sc_hd__tapvpwrvgnd_1
XFILLER_12_587 VGND VGND VPWR VPWR sky130_fd_sc_hd__fill_1
XANTENNA_8 a_inputs_flat[18] VGND VGND VPWR VPWR sky130_fd_sc_hd__diode_2
XFILLER_4_786 VGND VGND VPWR VPWR sky130_fd_sc_hd__decap_3
Xg_row\[1\].g_col\[0\].pe__1620_ place1082/X g_row\[1\].g_col\[0\].pe__1414_/X g_row\[1\].g_col\[0\].pe__1415_/Y
+ g_row\[1\].g_col\[0\].pe__1801_/B place1080/X VGND VGND VPWR VPWR g_row\[1\].g_col\[0\].pe__1621_/B
+ sky130_fd_sc_hd__a32o_2
Xg_row\[1\].g_col\[0\].pe_hold3017 g_row\[1\].g_col\[0\].pe__2380_/X VGND VGND VPWR
+ VPWR g_row\[1\].g_col\[0\].pe__2381_/B sky130_fd_sc_hd__clkbuf_2
Xg_row\[1\].g_col\[0\].pe__1551_ g_row\[1\].g_col\[0\].pe__1669_/A g_row\[1\].g_col\[0\].pe__1669_/B
+ VGND VGND VPWR VPWR g_row\[1\].g_col\[0\].pe__1830_/B sky130_fd_sc_hd__and2_2
XFILLER_20_7 VGND VGND VPWR VPWR sky130_fd_sc_hd__decap_3
XFILLER_39_418 VGND VGND VPWR VPWR sky130_fd_sc_hd__decap_3
XFILLER_86_61 VGND VGND VPWR VPWR sky130_fd_sc_hd__fill_1
Xg_row\[1\].g_col\[0\].pe__1482_ g_row\[1\].g_col\[0\].pe__1442_/A g_row\[1\].g_col\[0\].pe__1442_/B
+ g_row\[1\].g_col\[0\].pe__1481_/X VGND VGND VPWR VPWR g_row\[1\].g_col\[0\].pe__1512_/A
+ sky130_fd_sc_hd__a21oi_2
XFILLER_66_237 VGND VGND VPWR VPWR sky130_fd_sc_hd__fill_1
Xg_row\[1\].g_col\[0\].pe_hold1659 g_row\[1\].g_col\[0\].pe__2381_/X VGND VGND VPWR
+ VPWR g_row\[1\].g_col\[0\].pe__2752_/D sky130_fd_sc_hd__clkbuf_2
XFILLER_47_462 VGND VGND VPWR VPWR sky130_fd_sc_hd__decap_3
XFILLER_19_175 VGND VGND VPWR VPWR sky130_fd_sc_hd__fill_2
XFILLER_47_484 VGND VGND VPWR VPWR sky130_fd_sc_hd__decap_3
Xg_row\[0\].g_col\[0\].pe__1560_ g_row\[0\].g_col\[0\].pe__1607_/A g_row\[0\].g_col\[0\].pe__1560_/B
+ VGND VGND VPWR VPWR g_row\[0\].g_col\[0\].pe__1562_/C sky130_fd_sc_hd__and2_2
Xg_row\[1\].g_col\[0\].pe__2103_ g_row\[1\].g_col\[0\].pe__2052_/A g_row\[1\].g_col\[0\].pe__2052_/C
+ g_row\[1\].g_col\[0\].pe__2052_/B VGND VGND VPWR VPWR g_row\[1\].g_col\[0\].pe__2104_/C
+ sky130_fd_sc_hd__o21bai_2
XFILLER_34_145 VGND VGND VPWR VPWR sky130_fd_sc_hd__fill_1
Xg_row\[1\].g_col\[1\].pe__2050_ g_row\[1\].g_col\[1\].pe__2025_/Y g_row\[1\].g_col\[1\].pe__1991_/X
+ g_row\[1\].g_col\[1\].pe__2048_/Y g_row\[1\].g_col\[1\].pe__2049_/X VGND VGND VPWR
+ VPWR g_row\[1\].g_col\[1\].pe__2052_/B sky130_fd_sc_hd__o211a_4
XFILLER_22_329 VGND VGND VPWR VPWR sky130_fd_sc_hd__fill_2
XFILLER_50_627 VGND VGND VPWR VPWR sky130_fd_sc_hd__decap_3
Xg_row\[0\].g_col\[0\].pe__1491_ g_row\[0\].g_col\[0\].pe__1512_/A g_row\[0\].g_col\[0\].pe__1512_/B
+ VGND VGND VPWR VPWR g_row\[0\].g_col\[0\].pe__1500_/A sky130_fd_sc_hd__xor2_2
Xg_row\[1\].g_col\[0\].pe__2034_ g_row\[1\].g_col\[0\].pe__2034_/A g_row\[1\].g_col\[0\].pe__2034_/B
+ g_row\[1\].g_col\[0\].pe__2034_/C g_row\[1\].g_col\[0\].pe__2034_/D VGND VGND VPWR
+ VPWR g_row\[1\].g_col\[0\].pe__2038_/A sky130_fd_sc_hd__nand4_2
XFILLER_31_841 VGND VGND VPWR VPWR sky130_fd_sc_hd__fill_1
XTAP_TAPCELL_ROW_20_508 VGND VPWR sky130_fd_sc_hd__tapvpwrvgnd_1
Xg_row\[0\].g_col\[0\].pe__2112_ g_row\[0\].g_col\[0\].pe__2066_/Y g_row\[0\].g_col\[0\].pe__2061_/Y
+ g_row\[0\].g_col\[0\].pe__2111_/X VGND VGND VPWR VPWR g_row\[0\].g_col\[0\].pe__2112_/Y
+ sky130_fd_sc_hd__a21oi_2
Xg_row\[0\].g_col\[0\].pe__2043_ g_row\[0\].g_col\[0\].pe__2043_/A g_row\[0\].g_col\[0\].pe__2043_/B
+ VGND VGND VPWR VPWR g_row\[0\].g_col\[0\].pe__2044_/B sky130_fd_sc_hd__nand2_2
Xg_row\[1\].g_col\[1\].pe__1903_ g_row\[1\].g_col\[1\].pe__2075_/A g_row\[1\].g_col\[1\].pe__1903_/B
+ VGND VGND VPWR VPWR g_row\[1\].g_col\[1\].pe__1905_/B sky130_fd_sc_hd__xnor2_2
Xplace1213 place1214/X VGND VGND VPWR VPWR place1213/X sky130_fd_sc_hd__buf_6
Xplace1246 place1247/X VGND VGND VPWR VPWR place1246/X sky130_fd_sc_hd__buf_6
Xplace1257 place1262/X VGND VGND VPWR VPWR place1257/X sky130_fd_sc_hd__buf_6
Xplace1268 place1269/X VGND VGND VPWR VPWR place1268/X sky130_fd_sc_hd__buf_6
Xg_row\[1\].g_col\[1\].pe__1834_ g_row\[1\].g_col\[1\].pe__1834_/A g_row\[1\].g_col\[1\].pe__1834_/B
+ VGND VGND VPWR VPWR g_row\[1\].g_col\[1\].pe__1834_/Y sky130_fd_sc_hd__xnor2_2
Xg_row\[1\].g_col\[0\].pe__1818_ g_row\[1\].g_col\[0\].pe__1822_/D g_row\[1\].g_col\[0\].pe__1818_/B
+ VGND VGND VPWR VPWR g_row\[1\].g_col\[0\].pe__1821_/C sky130_fd_sc_hd__xnor2_2
Xg_row\[1\].g_col\[1\].pe__1765_ g_row\[1\].g_col\[1\].pe__1766_/A g_row\[1\].g_col\[1\].pe__1766_/B
+ VGND VGND VPWR VPWR g_row\[1\].g_col\[1\].pe__1793_/B sky130_fd_sc_hd__nand2_2
Xg_row\[1\].g_col\[0\].pe__1749_ g_row\[1\].g_col\[0\].pe__1749_/A1 place1096/X place1098/A
+ g_row\[1\].g_col\[0\].pe__1804_/B VGND VGND VPWR VPWR g_row\[1\].g_col\[0\].pe__1750_/B
+ sky130_fd_sc_hd__a22o_2
Xg_row\[1\].g_col\[1\].pe__1696_ g_row\[1\].g_col\[1\].pe__1678_/Y g_row\[1\].g_col\[1\].pe__1703_/B
+ g_row\[1\].g_col\[1\].pe__1695_/X VGND VGND VPWR VPWR g_row\[1\].g_col\[1\].pe__1698_/A
+ sky130_fd_sc_hd__a21oi_2
Xg_row\[1\].g_col\[0\].pe_hold2850 g_row\[1\].g_col\[0\].pe__2706_/Q VGND VGND VPWR
+ VPWR g_row\[1\].g_col\[0\].pe__2641_/B sky130_fd_sc_hd__clkbuf_2
Xg_row\[0\].g_col\[1\].pe__1912_ g_row\[0\].g_col\[1\].pe__2165_/A g_row\[0\].g_col\[1\].pe__1912_/B
+ VGND VGND VPWR VPWR g_row\[0\].g_col\[1\].pe__1955_/B sky130_fd_sc_hd__xnor2_2
XFILLER_38_440 VGND VGND VPWR VPWR sky130_fd_sc_hd__fill_2
XFILLER_57_248 VGND VGND VPWR VPWR sky130_fd_sc_hd__fill_2
Xg_row\[1\].g_col\[0\].pe_hold2861 g_row\[1\].g_col\[0\].pe_hold2861/A VGND VGND VPWR
+ VPWR g_row\[1\].g_col\[0\].pe__2720_/D sky130_fd_sc_hd__clkbuf_2
XTAP_TAPCELL_ROW_0_200 VGND VPWR sky130_fd_sc_hd__tapvpwrvgnd_1
XTAP_TAPCELL_ROW_0_211 VGND VPWR sky130_fd_sc_hd__tapvpwrvgnd_1
Xg_row\[0\].g_col\[0\].pe__1827_ g_row\[0\].g_col\[0\].pe__1827_/A g_row\[0\].g_col\[0\].pe__1827_/B
+ VGND VGND VPWR VPWR g_row\[0\].g_col\[0\].pe__1827_/Y sky130_fd_sc_hd__nand2_2
Xg_row\[1\].g_col\[0\].pe_hold2894 _302_/Q VGND VGND VPWR VPWR g_row\[1\].g_col\[0\].pe_hold2894/X
+ sky130_fd_sc_hd__clkbuf_2
Xg_row\[0\].g_col\[1\].pe__1843_ g_row\[0\].g_col\[1\].pe__1843_/A g_row\[0\].g_col\[1\].pe__1843_/B
+ VGND VGND VPWR VPWR g_row\[0\].g_col\[1\].pe__1891_/A sky130_fd_sc_hd__nand2_2
Xg_row\[0\].g_col\[0\].pe__1758_ g_row\[0\].g_col\[0\].pe__1758_/A g_row\[0\].g_col\[0\].pe__1758_/B
+ VGND VGND VPWR VPWR g_row\[0\].g_col\[0\].pe__1774_/B sky130_fd_sc_hd__xnor2_2
Xg_row\[1\].g_col\[1\].pe__2317_ g_row\[1\].g_col\[1\].pe__2347_/A g_row\[1\].g_col\[1\].pe__2317_/B
+ VGND VGND VPWR VPWR g_row\[1\].g_col\[1\].pe__2318_/B sky130_fd_sc_hd__nor2_2
Xg_row\[0\].g_col\[1\].pe__1774_ g_row\[0\].g_col\[1\].pe__1774_/A g_row\[0\].g_col\[1\].pe__1774_/B
+ VGND VGND VPWR VPWR g_row\[0\].g_col\[1\].pe__1774_/Y sky130_fd_sc_hd__nor2_2
XFILLER_25_167 VGND VGND VPWR VPWR sky130_fd_sc_hd__fill_1
XFILLER_41_605 VGND VGND VPWR VPWR sky130_fd_sc_hd__fill_1
Xg_row\[1\].g_col\[1\].pe__2248_ g_row\[1\].g_col\[1\].pe__2348_/A g_row\[1\].g_col\[1\].pe__2248_/B
+ VGND VGND VPWR VPWR g_row\[1\].g_col\[1\].pe__2250_/B sky130_fd_sc_hd__xnor2_2
XFILLER_13_329 VGND VGND VPWR VPWR sky130_fd_sc_hd__fill_2
XFILLER_15_57 VGND VGND VPWR VPWR sky130_fd_sc_hd__fill_1
Xg_row\[0\].g_col\[0\].pe__1689_ g_row\[0\].g_col\[0\].pe__1721_/A g_row\[0\].g_col\[0\].pe__1721_/B
+ VGND VGND VPWR VPWR g_row\[0\].g_col\[0\].pe__1689_/Y sky130_fd_sc_hd__nand2_2
Xg_row\[1\].g_col\[1\].pe__2179_ g_row\[1\].g_col\[1\].pe__2364_/A g_row\[1\].g_col\[1\].pe__2179_/B
+ VGND VGND VPWR VPWR g_row\[1\].g_col\[1\].pe__2213_/B sky130_fd_sc_hd__xnor2_2
Xg_row\[0\].g_col\[1\].pe__2326_ g_row\[0\].g_col\[1\].pe__2327_/A g_row\[0\].g_col\[1\].pe__2327_/B
+ g_row\[0\].g_col\[1\].pe__2327_/C VGND VGND VPWR VPWR g_row\[0\].g_col\[1\].pe__2355_/A
+ sky130_fd_sc_hd__o21a_2
Xg_row\[1\].g_col\[1\].pe_hold3103 g_row\[1\].g_col\[1\].pe__1386_/X VGND VGND VPWR
+ VPWR g_row\[1\].g_col\[1\].pe_hold3103/X sky130_fd_sc_hd__clkbuf_2
Xg_row\[1\].g_col\[1\].pe_hold3125 g_row\[1\].g_col\[1\].pe__2774_/A VGND VGND VPWR
+ VPWR g_row\[1\].g_col\[1\].pe_hold3125/X sky130_fd_sc_hd__clkbuf_2
Xg_row\[0\].g_col\[1\].pe__2257_ g_row\[0\].g_col\[1\].pe__2257_/A g_row\[0\].g_col\[1\].pe__2272_/B
+ VGND VGND VPWR VPWR g_row\[0\].g_col\[1\].pe__2330_/A sky130_fd_sc_hd__xor2_2
XFILLER_1_701 VGND VGND VPWR VPWR sky130_fd_sc_hd__fill_1
Xg_row\[1\].g_col\[1\].pe_hold1712 g_row\[1\].g_col\[1\].pe__2306_/X VGND VGND VPWR
+ VPWR g_row\[1\].g_col\[1\].pe__2307_/B sky130_fd_sc_hd__clkbuf_2
Xg_row\[1\].g_col\[1\].pe_hold1701 g_row\[1\].g_col\[1\].pe__2748_/Q VGND VGND VPWR
+ VPWR g_row\[1\].g_col\[1\].pe__2266_/A sky130_fd_sc_hd__clkbuf_2
Xg_row\[0\].g_col\[1\].pe__2188_ g_row\[0\].g_col\[1\].pe__2143_/A g_row\[0\].g_col\[1\].pe__2143_/B
+ g_row\[0\].g_col\[1\].pe__2187_/X VGND VGND VPWR VPWR g_row\[0\].g_col\[1\].pe__2190_/B
+ sky130_fd_sc_hd__a21oi_2
XFILLER_89_841 VGND VGND VPWR VPWR sky130_fd_sc_hd__fill_1
XTAP_TAPCELL_ROW_8_333 VGND VPWR sky130_fd_sc_hd__tapvpwrvgnd_1
Xhold3150 hold3150/A VGND VGND VPWR VPWR hold3150/X sky130_fd_sc_hd__clkbuf_2
Xg_row\[1\].g_col\[1\].pe_hold1767 g_row\[1\].g_col\[1\].pe__2638_/X VGND VGND VPWR
+ VPWR g_row\[1\].g_col\[1\].pe__2640_/A2 sky130_fd_sc_hd__clkbuf_2
Xhold3161 hold3161/A VGND VGND VPWR VPWR hold3161/X sky130_fd_sc_hd__clkbuf_2
Xhold3172 a_inputs_flat[31] VGND VGND VPWR VPWR hold3172/X sky130_fd_sc_hd__clkbuf_2
Xhold3183 hold3183/A VGND VGND VPWR VPWR hold3183/X sky130_fd_sc_hd__clkbuf_2
Xhold3194 hold3194/A VGND VGND VPWR VPWR hold3194/X sky130_fd_sc_hd__clkbuf_2
XFILLER_48_237 VGND VGND VPWR VPWR sky130_fd_sc_hd__decap_3
XFILLER_48_248 VGND VGND VPWR VPWR sky130_fd_sc_hd__decap_3
XFILLER_48_259 VGND VGND VPWR VPWR sky130_fd_sc_hd__fill_1
Xhold2460 _243_/Y VGND VGND VPWR VPWR hold2460/X sky130_fd_sc_hd__clkbuf_2
Xhold2471 hold3206/X VGND VGND VPWR VPWR _269_/B_N sky130_fd_sc_hd__clkbuf_2
Xhold2482 hold3232/X VGND VGND VPWR VPWR hold3233/A sky130_fd_sc_hd__clkbuf_2
XTAP_TAPCELL_ROW_47_917 VGND VPWR sky130_fd_sc_hd__tapvpwrvgnd_1
Xhold2493 hold3244/X VGND VGND VPWR VPWR hold3245/A sky130_fd_sc_hd__clkbuf_2
XTAP_TAPCELL_ROW_67_1211 VGND VPWR sky130_fd_sc_hd__tapvpwrvgnd_1
XTAP_TAPCELL_ROW_67_1222 VGND VPWR sky130_fd_sc_hd__tapvpwrvgnd_1
Xhold1781 hold3018/X VGND VGND VPWR VPWR hold1781/X sky130_fd_sc_hd__clkbuf_2
XFILLER_16_167 VGND VGND VPWR VPWR sky130_fd_sc_hd__fill_2
XTAP_TAPCELL_ROW_80_1411 VGND VPWR sky130_fd_sc_hd__tapvpwrvgnd_1
Xg_row\[0\].g_col\[0\].pe_hold2904 _290_/Q VGND VGND VPWR VPWR g_row\[0\].g_col\[0\].pe_hold2904/X
+ sky130_fd_sc_hd__clkbuf_2
Xg_row\[0\].g_col\[0\].pe_hold2937 g_row\[0\].g_col\[0\].pe_hold2937/A VGND VGND VPWR
+ VPWR g_row\[0\].g_col\[0\].pe__2628_/A2 sky130_fd_sc_hd__clkbuf_2
XFILLER_13_841 VGND VGND VPWR VPWR sky130_fd_sc_hd__fill_1
XFILLER_12_340 VGND VGND VPWR VPWR sky130_fd_sc_hd__fill_1
Xg_row\[1\].g_col\[0\].pe__2721_ clkbuf_leaf_48_clk/X g_row\[1\].g_col\[0\].pe__2721_/D
+ VGND VGND VPWR VPWR g_row\[1\].g_col\[0\].pe__2721_/Q sky130_fd_sc_hd__dfxtp_2
XTAP_TAPCELL_ROW_78_1373 VGND VPWR sky130_fd_sc_hd__tapvpwrvgnd_1
XTAP_TAPCELL_ROW_78_1384 VGND VPWR sky130_fd_sc_hd__tapvpwrvgnd_1
Xg_row\[1\].g_col\[0\].pe__2652_ g_row\[1\].g_col\[0\].pe__2652_/A1 hold1896/X g_row\[1\].g_col\[0\].pe__2677_/B1
+ g_row\[1\].g_col\[0\].pe__2652_/C1 VGND VGND VPWR VPWR g_row\[1\].g_col\[0\].pe__2652_/X
+ sky130_fd_sc_hd__o211a_2
Xg_row\[1\].g_col\[0\].pe__1603_ g_row\[1\].g_col\[0\].pe__1604_/A g_row\[1\].g_col\[0\].pe__1604_/B
+ VGND VGND VPWR VPWR g_row\[1\].g_col\[0\].pe__1860_/A sky130_fd_sc_hd__nand2_2
XTAP_TAPCELL_ROW_91_1573 VGND VPWR sky130_fd_sc_hd__tapvpwrvgnd_1
Xg_row\[1\].g_col\[1\].pe_hold2980 g_row\[1\].g_col\[1\].pe__2656_/X VGND VGND VPWR
+ VPWR g_row\[1\].g_col\[1\].pe_hold2980/X sky130_fd_sc_hd__clkbuf_2
Xg_row\[1\].g_col\[1\].pe_hold2991 hold2141/X VGND VGND VPWR VPWR g_row\[1\].g_col\[1\].pe__2652_/A2
+ sky130_fd_sc_hd__clkbuf_2
Xg_row\[1\].g_col\[1\].pe__1550_ g_row\[1\].g_col\[1\].pe__1550_/A g_row\[1\].g_col\[1\].pe__1550_/B
+ VGND VGND VPWR VPWR g_row\[1\].g_col\[1\].pe__1669_/B sky130_fd_sc_hd__xnor2_2
Xg_row\[1\].g_col\[0\].pe_hold2113 g_row\[1\].g_col\[0\].pe__2064_/Y VGND VGND VPWR
+ VPWR g_row\[1\].g_col\[0\].pe__2743_/D sky130_fd_sc_hd__clkbuf_2
XFILLER_67_502 VGND VGND VPWR VPWR sky130_fd_sc_hd__fill_2
Xg_row\[1\].g_col\[0\].pe__1534_ g_row\[1\].g_col\[0\].pe__1588_/A g_row\[1\].g_col\[0\].pe__1588_/B
+ VGND VGND VPWR VPWR g_row\[1\].g_col\[0\].pe__1547_/A sky130_fd_sc_hd__xor2_2
XFILLER_67_568 VGND VGND VPWR VPWR sky130_fd_sc_hd__fill_2
Xg_row\[0\].g_col\[0\].pe__2730_ clkbuf_leaf_22_clk/X g_row\[0\].g_col\[0\].pe__2730_/D
+ VGND VGND VPWR VPWR g_row\[0\].g_col\[0\].pe__2730_/Q sky130_fd_sc_hd__dfxtp_2
Xg_row\[1\].g_col\[1\].pe__1481_ g_row\[1\].g_col\[1\].pe__1481_/A g_row\[1\].g_col\[1\].pe__1481_/B
+ VGND VGND VPWR VPWR g_row\[1\].g_col\[1\].pe__1481_/X sky130_fd_sc_hd__and2_2
Xg_row\[1\].g_col\[0\].pe__1465_ g_row\[1\].g_col\[0\].pe__1507_/A g_row\[1\].g_col\[0\].pe__1507_/B
+ VGND VGND VPWR VPWR g_row\[1\].g_col\[0\].pe__1478_/A sky130_fd_sc_hd__xor2_2
Xg_row\[0\].g_col\[0\].pe__2661_ g_row\[0\].g_col\[0\].pe__2669_/A hold2019/X VGND
+ VGND VPWR VPWR g_row\[0\].g_col\[0\].pe__2661_/X sky130_fd_sc_hd__or2_2
XFILLER_47_270 VGND VGND VPWR VPWR sky130_fd_sc_hd__decap_3
XFILLER_47_281 VGND VGND VPWR VPWR sky130_fd_sc_hd__decap_3
XFILLER_75_590 VGND VGND VPWR VPWR sky130_fd_sc_hd__decap_3
Xg_row\[0\].g_col\[0\].pe__1612_ g_row\[0\].g_col\[0\].pe__1851_/A g_row\[0\].g_col\[0\].pe__1851_/B
+ VGND VGND VPWR VPWR g_row\[0\].g_col\[0\].pe__1615_/A sky130_fd_sc_hd__xor2_2
Xg_row\[1\].g_col\[0\].pe__1396_ hold1889/X g_row\[1\].g_col\[0\].pe__1402_/B VGND
+ VGND VPWR VPWR g_row\[1\].g_col\[0\].pe__1396_/X sky130_fd_sc_hd__or2_2
XFILLER_62_251 VGND VGND VPWR VPWR sky130_fd_sc_hd__fill_1
Xg_row\[0\].g_col\[0\].pe__2592_ g_row\[0\].g_col\[0\].pe__2592_/A g_row\[0\].g_col\[0\].pe__2592_/B
+ VGND VGND VPWR VPWR g_row\[0\].g_col\[0\].pe__2592_/X sky130_fd_sc_hd__and2_2
Xg_row\[1\].g_col\[1\].pe__2102_ g_row\[1\].g_col\[1\].pe__2145_/A g_row\[1\].g_col\[1\].pe__2101_/C
+ g_row\[1\].g_col\[1\].pe__2101_/A VGND VGND VPWR VPWR g_row\[1\].g_col\[1\].pe__2104_/B
+ sky130_fd_sc_hd__o21ai_2
Xg_row\[0\].g_col\[0\].pe__1543_ g_row\[0\].g_col\[0\].pe__1672_/A1 g_row\[0\].g_col\[0\].pe__1549_/B
+ g_row\[0\].g_col\[0\].pe__1541_/X place1223/X VGND VGND VPWR VPWR g_row\[0\].g_col\[0\].pe__1544_/B
+ sky130_fd_sc_hd__a22o_2
Xg_row\[0\].g_col\[0\].pe__1474_ g_row\[0\].g_col\[0\].pe__2368_/A g_row\[0\].g_col\[0\].pe__1471_/A
+ g_row\[0\].g_col\[0\].pe__1473_/X VGND VGND VPWR VPWR g_row\[0\].g_col\[0\].pe__1474_/Y
+ sky130_fd_sc_hd__o21ai_2
Xg_row\[0\].g_col\[1\].pe__1490_ g_row\[0\].g_col\[1\].pe__1490_/A g_row\[0\].g_col\[1\].pe__1490_/B
+ VGND VGND VPWR VPWR g_row\[0\].g_col\[1\].pe__1512_/B sky130_fd_sc_hd__xnor2_2
Xg_row\[1\].g_col\[1\].pe__2033_ g_row\[1\].g_col\[1\].pe__2032_/B g_row\[1\].g_col\[1\].pe__2032_/C
+ g_row\[1\].g_col\[1\].pe__2085_/A VGND VGND VPWR VPWR g_row\[1\].g_col\[1\].pe__2034_/D
+ sky130_fd_sc_hd__a21o_2
Xg_row\[1\].g_col\[0\].pe__2017_ g_row\[1\].g_col\[0\].pe__2017_/A VGND VGND VPWR
+ VPWR g_row\[1\].g_col\[0\].pe__2058_/A sky130_fd_sc_hd__inv_2
XFILLER_31_671 VGND VGND VPWR VPWR sky130_fd_sc_hd__fill_1
XTAP_TAPCELL_ROW_33_699 VGND VPWR sky130_fd_sc_hd__tapvpwrvgnd_1
Xg_row\[0\].g_col\[1\].pe__2111_ g_row\[0\].g_col\[1\].pe__2111_/A g_row\[0\].g_col\[1\].pe__2153_/C
+ VGND VGND VPWR VPWR g_row\[0\].g_col\[1\].pe__2111_/X sky130_fd_sc_hd__or2b_2
Xg_row\[0\].g_col\[1\].pe__2042_ g_row\[0\].g_col\[1\].pe__2043_/A g_row\[0\].g_col\[1\].pe__2043_/B
+ VGND VGND VPWR VPWR g_row\[0\].g_col\[1\].pe__2094_/C sky130_fd_sc_hd__or2_2
Xg_row\[0\].g_col\[0\].pe__2026_ g_row\[0\].g_col\[0\].pe__2121_/A g_row\[0\].g_col\[0\].pe__2026_/B
+ VGND VGND VPWR VPWR g_row\[0\].g_col\[0\].pe__2028_/B sky130_fd_sc_hd__nand2_2
Xg_row\[1\].g_col\[1\].pe__1817_ g_row\[1\].g_col\[1\].pe__1777_/A g_row\[1\].g_col\[1\].pe__1777_/B
+ g_row\[1\].g_col\[1\].pe__1816_/X VGND VGND VPWR VPWR g_row\[1\].g_col\[1\].pe__1818_/B
+ sky130_fd_sc_hd__a21oi_2
Xplace1087 hold3129/X VGND VGND VPWR VPWR place1087/X sky130_fd_sc_hd__buf_6
Xplace1098 place1098/A VGND VGND VPWR VPWR place1098/X sky130_fd_sc_hd__buf_6
XFILLER_58_513 VGND VGND VPWR VPWR sky130_fd_sc_hd__fill_1
Xg_row\[1\].g_col\[1\].pe__1748_ g_row\[1\].g_col\[1\].pe__2599_/B g_row\[1\].g_col\[1\].pe__1748_/B
+ VGND VGND VPWR VPWR g_row\[1\].g_col\[1\].pe__1816_/B sky130_fd_sc_hd__nand2_2
XFILLER_58_568 VGND VGND VPWR VPWR sky130_fd_sc_hd__fill_1
XFILLER_85_343 VGND VGND VPWR VPWR sky130_fd_sc_hd__fill_1
Xg_row\[1\].g_col\[1\].pe__1679_ g_row\[1\].g_col\[1\].pe__1727_/A1 g_row\[1\].g_col\[1\].pe__2698_/Q
+ g_row\[1\].g_col\[1\].pe__2697_/Q g_row\[1\].g_col\[1\].pe__1727_/B2 VGND VGND VPWR
+ VPWR g_row\[1\].g_col\[1\].pe__1680_/B sky130_fd_sc_hd__a22o_2
XFILLER_39_760 VGND VGND VPWR VPWR sky130_fd_sc_hd__fill_2
XFILLER_73_505 VGND VGND VPWR VPWR sky130_fd_sc_hd__fill_2
XFILLER_85_376 VGND VGND VPWR VPWR sky130_fd_sc_hd__fill_1
XFILLER_93_29 VGND VGND VPWR VPWR sky130_fd_sc_hd__fill_2
Xg_row\[0\].g_col\[1\].pe__1826_ g_row\[0\].g_col\[1\].pe__1828_/A g_row\[0\].g_col\[1\].pe__1828_/B
+ VGND VGND VPWR VPWR g_row\[0\].g_col\[1\].pe__1826_/Y sky130_fd_sc_hd__nor2_2
XFILLER_53_284 VGND VGND VPWR VPWR sky130_fd_sc_hd__decap_3
Xg_row\[0\].g_col\[1\].pe__1757_ g_row\[0\].g_col\[1\].pe__1770_/A g_row\[0\].g_col\[1\].pe__1770_/B
+ g_row\[0\].g_col\[1\].pe__1756_/X VGND VGND VPWR VPWR g_row\[0\].g_col\[1\].pe__1774_/A
+ sky130_fd_sc_hd__a21oi_2
XFILLER_13_137 VGND VGND VPWR VPWR sky130_fd_sc_hd__decap_3
X_290_ _292_/CLK _290_/D VGND VGND VPWR VPWR _290_/Q sky130_fd_sc_hd__dfxtp_2
Xg_row\[0\].g_col\[1\].pe__1688_ g_row\[0\].g_col\[1\].pe__1688_/A g_row\[0\].g_col\[1\].pe__1688_/B
+ VGND VGND VPWR VPWR g_row\[0\].g_col\[1\].pe__1721_/B sky130_fd_sc_hd__xnor2_2
XTAP_TAPCELL_ROW_52_986 VGND VPWR sky130_fd_sc_hd__tapvpwrvgnd_1
XTAP_TAPCELL_ROW_52_997 VGND VPWR sky130_fd_sc_hd__tapvpwrvgnd_1
XTAP_TAPCELL_ROW_62_1141 VGND VPWR sky130_fd_sc_hd__tapvpwrvgnd_1
XFILLER_6_804 VGND VGND VPWR VPWR sky130_fd_sc_hd__decap_3
Xg_row\[0\].g_col\[1\].pe__2309_ g_row\[0\].g_col\[1\].pe__2287_/A g_row\[0\].g_col\[1\].pe__2309_/B
+ VGND VGND VPWR VPWR g_row\[0\].g_col\[1\].pe__2327_/A sky130_fd_sc_hd__and2b_2
XFILLER_49_502 VGND VGND VPWR VPWR sky130_fd_sc_hd__fill_2
XFILLER_76_365 VGND VGND VPWR VPWR sky130_fd_sc_hd__fill_2
XFILLER_17_432 VGND VGND VPWR VPWR sky130_fd_sc_hd__fill_2
XFILLER_45_785 VGND VGND VPWR VPWR sky130_fd_sc_hd__decap_3
XPHY_EDGE_ROW_17_Left_111 VGND VGND VPWR VPWR sky130_fd_sc_hd__decap_3
XFILLER_13_671 VGND VGND VPWR VPWR sky130_fd_sc_hd__fill_1
XFILLER_9_620 VGND VGND VPWR VPWR sky130_fd_sc_hd__decap_3
XFILLER_12_170 VGND VGND VPWR VPWR sky130_fd_sc_hd__decap_3
XFILLER_13_682 VGND VGND VPWR VPWR sky130_fd_sc_hd__decap_3
XFILLER_8_141 VGND VGND VPWR VPWR sky130_fd_sc_hd__decap_3
XTAP_TAPCELL_ROW_30_658 VGND VPWR sky130_fd_sc_hd__tapvpwrvgnd_1
XTAP_TAPCELL_ROW_10_360 VGND VPWR sky130_fd_sc_hd__tapvpwrvgnd_1
XFILLER_59_3 VGND VGND VPWR VPWR sky130_fd_sc_hd__fill_1
XTAP_TAPCELL_ROW_93_1602 VGND VPWR sky130_fd_sc_hd__tapvpwrvgnd_1
XTAP_TAPCELL_ROW_93_1613 VGND VPWR sky130_fd_sc_hd__tapvpwrvgnd_1
XTAP_TAPCELL_ROW_93_1624 VGND VPWR sky130_fd_sc_hd__tapvpwrvgnd_1
Xg_row\[0\].g_col\[0\].pe_place1181 g_row\[0\].g_col\[0\].pe__1460_/B VGND VGND VPWR
+ VPWR g_row\[0\].g_col\[0\].pe__2167_/A sky130_fd_sc_hd__buf_6
Xg_row\[0\].g_col\[0\].pe_place1192 g_row\[0\].g_col\[0\].pe__2723_/Q VGND VGND VPWR
+ VPWR g_row\[0\].g_col\[0\].pe__1761_/A1 sky130_fd_sc_hd__buf_6
Xg_row\[1\].g_col\[1\].pe__2720_ clkbuf_leaf_80_clk/X g_row\[1\].g_col\[1\].pe__2720_/D
+ VGND VGND VPWR VPWR g_row\[1\].g_col\[1\].pe__2720_/Q sky130_fd_sc_hd__dfxtp_2
Xg_row\[1\].g_col\[0\].pe__2704_ clkbuf_leaf_43_clk/X g_row\[1\].g_col\[0\].pe__2704_/D
+ VGND VGND VPWR VPWR hold1989/A sky130_fd_sc_hd__dfxtp_2
XPHY_EDGE_ROW_26_Left_120 VGND VGND VPWR VPWR sky130_fd_sc_hd__decap_3
Xg_row\[1\].g_col\[1\].pe__2651_ place1239/X g_row\[1\].g_col\[1\].pe__2651_/B VGND
+ VGND VPWR VPWR g_row\[1\].g_col\[1\].pe__2651_/X sky130_fd_sc_hd__or2_2
Xg_row\[1\].g_col\[0\].pe__2635_ _306_/Q _305_/Q _307_/Q g_row\[1\].g_col\[0\].pe__2635_/D
+ VGND VGND VPWR VPWR g_row\[1\].g_col\[0\].pe__2635_/X sky130_fd_sc_hd__or4_2
Xg_row\[1\].g_col\[1\].pe__2582_ g_row\[1\].g_col\[1\].pe__2592_/A g_row\[1\].g_col\[1\].pe__2582_/B
+ VGND VGND VPWR VPWR g_row\[1\].g_col\[1\].pe__2768_/D sky130_fd_sc_hd__and2_2
Xg_row\[1\].g_col\[1\].pe__1602_ g_row\[1\].g_col\[1\].pe__1602_/A g_row\[1\].g_col\[1\].pe__1602_/B
+ VGND VGND VPWR VPWR g_row\[1\].g_col\[1\].pe__1604_/B sky130_fd_sc_hd__xnor2_2
Xg_row\[1\].g_col\[1\].pe__1533_ g_row\[1\].g_col\[1\].pe__1533_/A g_row\[1\].g_col\[1\].pe__1533_/B
+ VGND VGND VPWR VPWR g_row\[1\].g_col\[1\].pe__1588_/B sky130_fd_sc_hd__xnor2_2
Xg_row\[1\].g_col\[0\].pe__1517_ g_row\[1\].g_col\[0\].pe__1642_/A g_row\[1\].g_col\[0\].pe__1517_/B
+ VGND VGND VPWR VPWR g_row\[1\].g_col\[0\].pe__1580_/A sky130_fd_sc_hd__xnor2_2
XFILLER_67_354 VGND VGND VPWR VPWR sky130_fd_sc_hd__fill_1
XFILLER_83_814 VGND VGND VPWR VPWR sky130_fd_sc_hd__fill_1
Xg_row\[0\].g_col\[0\].pe__2713_ clkbuf_leaf_37_clk/X g_row\[0\].g_col\[0\].pe__2713_/D
+ VGND VGND VPWR VPWR hold3000/A sky130_fd_sc_hd__dfxtp_2
Xg_row\[1\].g_col\[1\].pe__1464_ g_row\[1\].g_col\[1\].pe__1673_/A g_row\[1\].g_col\[1\].pe__1464_/B
+ VGND VGND VPWR VPWR g_row\[1\].g_col\[1\].pe__1507_/B sky130_fd_sc_hd__xnor2_2
Xg_row\[1\].g_col\[0\].pe__2497_ g_row\[1\].g_col\[0\].pe__2497_/A g_row\[1\].g_col\[0\].pe__2497_/B
+ VGND VGND VPWR VPWR g_row\[1\].g_col\[0\].pe__2546_/B sky130_fd_sc_hd__nor2_2
Xg_row\[1\].g_col\[0\].pe__1448_ g_row\[1\].g_col\[0\].pe__2729_/Q g_row\[1\].g_col\[0\].pe__2728_/Q
+ g_row\[1\].g_col\[0\].pe__1460_/B VGND VGND VPWR VPWR g_row\[1\].g_col\[0\].pe__1449_/B
+ sky130_fd_sc_hd__or3b_4
Xg_row\[0\].g_col\[1\].pe__2660_ g_row\[0\].g_col\[1\].pe__2670_/A1 g_row\[0\].g_col\[1\].pe__1392_/A
+ g_row\[0\].g_col\[1\].pe__2670_/B1 g_row\[0\].g_col\[1\].pe__2659_/X VGND VGND VPWR
+ VPWR g_row\[0\].g_col\[1\].pe__2660_/X sky130_fd_sc_hd__o211a_2
Xg_row\[0\].g_col\[0\].pe__2644_ g_row\[0\].g_col\[0\].pe__2656_/A1 g_row\[0\].g_col\[0\].pe__2644_/A2
+ g_row\[0\].g_col\[0\].pe__2687_/C1 g_row\[0\].g_col\[0\].pe__2643_/X VGND VGND VPWR
+ VPWR g_row\[0\].g_col\[0\].pe__2644_/X sky130_fd_sc_hd__o211a_2
Xg_row\[0\].g_col\[1\].pe__1611_ g_row\[0\].g_col\[1\].pe__1864_/A g_row\[0\].g_col\[1\].pe__1611_/B
+ VGND VGND VPWR VPWR g_row\[0\].g_col\[1\].pe__1851_/B sky130_fd_sc_hd__xnor2_2
Xg_row\[1\].g_col\[1\].pe__1395_ g_row\[1\].g_col\[1\].pe__1395_/A1 g_row\[1\].g_col\[1\].pe__1403_/A2
+ g_row\[1\].g_col\[1\].pe__1394_/X g_row\[1\].g_col\[1\].pe__2687_/C1 VGND VGND VPWR
+ VPWR g_row\[1\].g_col\[1\].pe__1395_/X sky130_fd_sc_hd__o211a_2
XFILLER_36_796 VGND VGND VPWR VPWR sky130_fd_sc_hd__fill_2
Xg_row\[0\].g_col\[0\].pe__2575_ g_row\[0\].g_col\[0\].pe__2575_/A g_row\[0\].g_col\[0\].pe__2590_/A
+ VGND VGND VPWR VPWR g_row\[0\].g_col\[0\].pe__2575_/X sky130_fd_sc_hd__or2_2
Xg_row\[0\].g_col\[1\].pe__2591_ g_row\[0\].g_col\[1\].pe__2591_/A1 g_row\[0\].g_col\[1\].pe__2591_/A2
+ g_row\[0\].g_col\[1\].pe__2591_/B1 g_row\[0\].g_col\[1\].pe__2590_/X VGND VGND VPWR
+ VPWR g_row\[0\].g_col\[1\].pe__2591_/X sky130_fd_sc_hd__a22o_2
XTAP_TAPCELL_ROW_18_482 VGND VPWR sky130_fd_sc_hd__tapvpwrvgnd_1
Xg_row\[0\].g_col\[0\].pe__1526_ g_row\[0\].g_col\[0\].pe__1910_/A g_row\[0\].g_col\[0\].pe__1526_/B
+ VGND VGND VPWR VPWR g_row\[0\].g_col\[0\].pe__1554_/A sky130_fd_sc_hd__xor2_2
Xg_row\[0\].g_col\[1\].pe__1473_ g_row\[0\].g_col\[1\].pe__2733_/Q g_row\[0\].g_col\[1\].pe__2250_/A
+ g_row\[0\].g_col\[1\].pe__1977_/A VGND VGND VPWR VPWR g_row\[0\].g_col\[1\].pe__1473_/X
+ sky130_fd_sc_hd__or3b_4
Xg_row\[1\].g_col\[1\].pe__2016_ g_row\[1\].g_col\[1\].pe__1905_/A g_row\[1\].g_col\[1\].pe__1905_/B
+ g_row\[1\].g_col\[1\].pe__1964_/B g_row\[1\].g_col\[1\].pe__1963_/B g_row\[1\].g_col\[1\].pe__1963_/A
+ VGND VGND VPWR VPWR g_row\[1\].g_col\[1\].pe__2017_/A sky130_fd_sc_hd__a32o_2
XFILLER_50_298 VGND VGND VPWR VPWR sky130_fd_sc_hd__decap_3
Xg_row\[0\].g_col\[0\].pe__1457_ g_row\[0\].g_col\[0\].pe__2731_/Q g_row\[0\].g_col\[0\].pe__2730_/Q
+ VGND VGND VPWR VPWR g_row\[0\].g_col\[0\].pe__2163_/B sky130_fd_sc_hd__xor2_2
Xclkbuf_leaf_30_clk clkload3/A VGND VGND VPWR VPWR _323_/CLK sky130_fd_sc_hd__clkbuf_16
Xg_row\[0\].g_col\[0\].pe__1388_ g_row\[0\].g_col\[0\].pe__1910_/A g_row\[0\].g_col\[0\].pe__1399_/A2
+ g_row\[0\].g_col\[0\].pe__1387_/X g_row\[0\].g_col\[0\].pe__2685_/C1 VGND VGND VPWR
+ VPWR g_row\[0\].g_col\[0\].pe__1388_/X sky130_fd_sc_hd__o211a_2
Xg_row\[0\].g_col\[0\].pe__2009_ g_row\[0\].g_col\[0\].pe__2006_/A g_row\[0\].g_col\[0\].pe__2009_/B
+ g_row\[0\].g_col\[0\].pe__2009_/C VGND VGND VPWR VPWR g_row\[0\].g_col\[0\].pe__2010_/D
+ sky130_fd_sc_hd__and3b_2
Xg_row\[0\].g_col\[1\].pe__2025_ g_row\[0\].g_col\[1\].pe__1919_/B g_row\[0\].g_col\[1\].pe__1980_/X
+ g_row\[0\].g_col\[1\].pe__1981_/Y g_row\[0\].g_col\[1\].pe__1987_/Y g_row\[0\].g_col\[1\].pe__1988_/X
+ VGND VGND VPWR VPWR g_row\[0\].g_col\[1\].pe__2025_/Y sky130_fd_sc_hd__a311oi_2
XFILLER_78_619 VGND VGND VPWR VPWR sky130_fd_sc_hd__decap_3
Xclkbuf_leaf_97_clk clkbuf_4_2_0_clk/X VGND VGND VPWR VPWR _327_/CLK sky130_fd_sc_hd__clkbuf_16
XFILLER_46_516 VGND VGND VPWR VPWR sky130_fd_sc_hd__decap_3
XFILLER_58_365 VGND VGND VPWR VPWR sky130_fd_sc_hd__decap_3
Xg_row\[0\].g_col\[1\].pe__1809_ g_row\[0\].g_col\[1\].pe__1795_/A g_row\[0\].g_col\[1\].pe__1795_/B
+ g_row\[0\].g_col\[1\].pe__1795_/C VGND VGND VPWR VPWR g_row\[0\].g_col\[1\].pe__1809_/X
+ sky130_fd_sc_hd__a21o_2
XFILLER_14_446 VGND VGND VPWR VPWR sky130_fd_sc_hd__fill_2
XFILLER_42_733 VGND VGND VPWR VPWR sky130_fd_sc_hd__fill_1
Xg_row\[0\].g_col\[0\].pe_hold2008 _322_/Q VGND VGND VPWR VPWR g_row\[0\].g_col\[0\].pe_hold2008/X
+ sky130_fd_sc_hd__clkbuf_2
X_273_ _279_/CLK _273_/D VGND VGND VPWR VPWR _273_/Q sky130_fd_sc_hd__dfxtp_2
Xclkbuf_leaf_21_clk clkbuf_4_4_0_clk/X VGND VGND VPWR VPWR _287_/CLK sky130_fd_sc_hd__clkbuf_16
XFILLER_5_100 VGND VGND VPWR VPWR sky130_fd_sc_hd__decap_3
XFILLER_6_634 VGND VGND VPWR VPWR sky130_fd_sc_hd__fill_2
XTAP_TAPCELL_ROW_75_1332 VGND VPWR sky130_fd_sc_hd__tapvpwrvgnd_1
XFILLER_2_840 VGND VGND VPWR VPWR sky130_fd_sc_hd__fill_2
Xg_row\[1\].g_col\[0\].pe__2420_ g_row\[1\].g_col\[0\].pe__2754_/Q g_row\[1\].g_col\[0\].pe__2336_/Y
+ g_row\[1\].g_col\[0\].pe__2429_/B VGND VGND VPWR VPWR g_row\[1\].g_col\[0\].pe__2426_/B
+ sky130_fd_sc_hd__o21ai_2
XFILLER_49_332 VGND VGND VPWR VPWR sky130_fd_sc_hd__decap_3
XFILLER_77_630 VGND VGND VPWR VPWR sky130_fd_sc_hd__decap_3
Xclkbuf_leaf_88_clk clkload4/A VGND VGND VPWR VPWR clkload15/A sky130_fd_sc_hd__clkbuf_16
XFILLER_37_505 VGND VGND VPWR VPWR sky130_fd_sc_hd__fill_2
XFILLER_77_652 VGND VGND VPWR VPWR sky130_fd_sc_hd__decap_3
Xg_row\[1\].g_col\[0\].pe__2351_ g_row\[1\].g_col\[0\].pe__2352_/A g_row\[1\].g_col\[0\].pe__2352_/B
+ g_row\[1\].g_col\[0\].pe__2352_/C VGND VGND VPWR VPWR g_row\[1\].g_col\[0\].pe__2375_/A
+ sky130_fd_sc_hd__a21oi_2
XFILLER_49_387 VGND VGND VPWR VPWR sky130_fd_sc_hd__decap_3
XFILLER_64_313 VGND VGND VPWR VPWR sky130_fd_sc_hd__fill_1
Xg_row\[1\].g_col\[0\].pe__2282_ g_row\[1\].g_col\[0\].pe__2283_/A g_row\[1\].g_col\[0\].pe__2283_/B
+ VGND VGND VPWR VPWR g_row\[1\].g_col\[0\].pe__2284_/A sky130_fd_sc_hd__nor2_2
XFILLER_18_741 VGND VGND VPWR VPWR sky130_fd_sc_hd__fill_2
XFILLER_17_273 VGND VGND VPWR VPWR sky130_fd_sc_hd__decap_3
XTAP_TAPCELL_ROW_35_728 VGND VPWR sky130_fd_sc_hd__tapvpwrvgnd_1
XTAP_TAPCELL_ROW_35_739 VGND VPWR sky130_fd_sc_hd__tapvpwrvgnd_1
XFILLER_32_221 VGND VGND VPWR VPWR sky130_fd_sc_hd__decap_3
XTAP_TAPCELL_ROW_86_1494 VGND VPWR sky130_fd_sc_hd__tapvpwrvgnd_1
Xg_row\[0\].g_col\[0\].pe__2360_ g_row\[0\].g_col\[0\].pe__2395_/A1 g_row\[0\].g_col\[0\].pe__2360_/A2
+ g_row\[0\].g_col\[0\].pe__2394_/B1 g_row\[0\].g_col\[0\].pe__2359_/Y VGND VGND VPWR
+ VPWR g_row\[0\].g_col\[0\].pe__2360_/X sky130_fd_sc_hd__o22a_2
XTAP_TAPCELL_ROW_15_430 VGND VPWR sky130_fd_sc_hd__tapvpwrvgnd_1
XTAP_TAPCELL_ROW_15_441 VGND VPWR sky130_fd_sc_hd__tapvpwrvgnd_1
Xg_row\[0\].g_col\[0\].pe__2291_ g_row\[0\].g_col\[0\].pe__2291_/A g_row\[0\].g_col\[0\].pe__2291_/B
+ VGND VGND VPWR VPWR g_row\[0\].g_col\[0\].pe__2327_/B sky130_fd_sc_hd__and2_2
Xclkbuf_leaf_12_clk clkload2/A VGND VGND VPWR VPWR clkload12/A sky130_fd_sc_hd__clkbuf_16
Xg_row\[1\].g_col\[0\].pe__1997_ g_row\[1\].g_col\[0\].pe__1997_/A g_row\[1\].g_col\[0\].pe__1997_/B
+ VGND VGND VPWR VPWR g_row\[1\].g_col\[0\].pe__2014_/B sky130_fd_sc_hd__xor2_2
Xg_row\[1\].g_col\[1\].pe__2703_ clkbuf_leaf_69_clk/X g_row\[1\].g_col\[1\].pe__2703_/D
+ VGND VGND VPWR VPWR g_row\[1\].g_col\[1\].pe__2703_/Q sky130_fd_sc_hd__dfxtp_2
XFILLER_87_416 VGND VGND VPWR VPWR sky130_fd_sc_hd__fill_1
Xg_row\[1\].g_col\[1\].pe__2634_ place1087/X place1089/X place1084/X place1085/X VGND
+ VGND VPWR VPWR g_row\[1\].g_col\[1\].pe__2635_/D sky130_fd_sc_hd__or4_2
Xg_row\[1\].g_col\[0\].pe__2618_ place1246/X place1090/A VGND VGND VPWR VPWR g_row\[1\].g_col\[0\].pe__2618_/X
+ sky130_fd_sc_hd__or2_2
Xclkbuf_leaf_79_clk clkbuf_4_10_0_clk/X VGND VGND VPWR VPWR clkload16/A sky130_fd_sc_hd__clkbuf_16
Xg_row\[1\].g_col\[1\].pe__2565_ g_row\[1\].g_col\[1\].pe__2569_/A g_row\[1\].g_col\[1\].pe__2565_/B
+ VGND VGND VPWR VPWR g_row\[1\].g_col\[1\].pe__2764_/D sky130_fd_sc_hd__and2_2
Xg_row\[1\].g_col\[0\].pe__2549_ g_row\[1\].g_col\[0\].pe__2561_/A g_row\[1\].g_col\[0\].pe__2549_/B
+ VGND VGND VPWR VPWR g_row\[1\].g_col\[0\].pe__2761_/D sky130_fd_sc_hd__and2_2
Xg_row\[1\].g_col\[1\].pe__2496_ g_row\[1\].g_col\[1\].pe__2496_/A g_row\[1\].g_col\[1\].pe__2496_/B
+ VGND VGND VPWR VPWR g_row\[1\].g_col\[1\].pe__2558_/B sky130_fd_sc_hd__nor2_2
Xg_row\[1\].g_col\[1\].pe__1516_ g_row\[1\].g_col\[1\].pe__1727_/A1 g_row\[1\].g_col\[1\].pe__2703_/Q
+ g_row\[1\].g_col\[1\].pe__2702_/Q g_row\[1\].g_col\[1\].pe__1727_/B2 VGND VGND VPWR
+ VPWR g_row\[1\].g_col\[1\].pe__1517_/B sky130_fd_sc_hd__a22o_2
Xg_row\[0\].g_col\[1\].pe_hold2116 g_row\[0\].g_col\[1\].pe_hold3109/X VGND VGND VPWR
+ VPWR g_row\[0\].g_col\[1\].pe__2724_/D sky130_fd_sc_hd__clkbuf_2
Xg_row\[0\].g_col\[1\].pe__2712_ _337_/CLK g_row\[0\].g_col\[1\].pe__2712_/D VGND
+ VGND VPWR VPWR hold2176/A sky130_fd_sc_hd__dfxtp_2
Xg_row\[1\].g_col\[1\].pe__1447_ g_row\[1\].g_col\[1\].pe__1816_/A g_row\[1\].g_col\[1\].pe__2729_/Q
+ g_row\[1\].g_col\[1\].pe__2125_/C VGND VGND VPWR VPWR g_row\[1\].g_col\[1\].pe__1449_/A
+ sky130_fd_sc_hd__nand3b_2
Xg_row\[0\].g_col\[1\].pe_hold2127 g_row\[0\].g_col\[1\].pe__2687_/X VGND VGND VPWR
+ VPWR g_row\[0\].g_col\[1\].pe__2726_/D sky130_fd_sc_hd__clkbuf_2
XFILLER_36_560 VGND VGND VPWR VPWR sky130_fd_sc_hd__decap_3
Xg_row\[0\].g_col\[0\].pe__2627_ _273_/Q hold2359/X VGND VGND VPWR VPWR g_row\[0\].g_col\[0\].pe__2627_/X
+ sky130_fd_sc_hd__or2_2
Xg_row\[1\].g_col\[1\].pe_place1274 hold1641/X VGND VGND VPWR VPWR g_row\[1\].g_col\[1\].pe__2396_/A
+ sky130_fd_sc_hd__buf_6
Xg_row\[0\].g_col\[1\].pe__2643_ g_row\[0\].g_col\[1\].pe__2661_/A hold2162/X VGND
+ VGND VPWR VPWR g_row\[0\].g_col\[1\].pe__2643_/X sky130_fd_sc_hd__or2_2
XFILLER_90_19 VGND VGND VPWR VPWR sky130_fd_sc_hd__fill_2
XFILLER_23_243 VGND VGND VPWR VPWR sky130_fd_sc_hd__fill_1
XFILLER_24_777 VGND VGND VPWR VPWR sky130_fd_sc_hd__fill_2
XFILLER_51_574 VGND VGND VPWR VPWR sky130_fd_sc_hd__decap_3
Xg_row\[0\].g_col\[0\].pe__2558_ g_row\[0\].g_col\[0\].pe__2558_/A g_row\[0\].g_col\[0\].pe__2558_/B
+ VGND VGND VPWR VPWR g_row\[0\].g_col\[0\].pe__2559_/B sky130_fd_sc_hd__xor2_2
Xg_row\[0\].g_col\[1\].pe__1525_ g_row\[0\].g_col\[1\].pe__1704_/A2 g_row\[0\].g_col\[1\].pe__2026_/B
+ g_row\[0\].g_col\[1\].pe__1738_/B1 g_row\[0\].g_col\[1\].pe__1727_/A2 VGND VGND
+ VPWR VPWR g_row\[0\].g_col\[1\].pe__1526_/B sky130_fd_sc_hd__a22o_2
Xg_row\[0\].g_col\[0\].pe__1509_ g_row\[0\].g_col\[0\].pe__1535_/B g_row\[0\].g_col\[0\].pe__1549_/C
+ VGND VGND VPWR VPWR g_row\[0\].g_col\[0\].pe__1640_/B sky130_fd_sc_hd__xnor2_2
Xg_row\[0\].g_col\[0\].pe__2489_ g_row\[0\].g_col\[0\].pe__2474_/Y g_row\[0\].g_col\[0\].pe__2489_/B
+ g_row\[0\].g_col\[0\].pe__2492_/A VGND VGND VPWR VPWR g_row\[0\].g_col\[0\].pe__2490_/B
+ sky130_fd_sc_hd__and3b_2
XFILLER_23_57 VGND VGND VPWR VPWR sky130_fd_sc_hd__decap_3
Xg_row\[0\].g_col\[1\].pe__1387_ g_row\[0\].g_col\[1\].pe__1387_/A g_row\[0\].g_col\[1\].pe__1389_/B
+ VGND VGND VPWR VPWR g_row\[0\].g_col\[1\].pe__1387_/X sky130_fd_sc_hd__or2_2
Xg_row\[0\].g_col\[0\].pe_place867 g_row\[0\].g_col\[0\].pe__1504_/Y VGND VGND VPWR
+ VPWR g_row\[0\].g_col\[0\].pe__1549_/B sky130_fd_sc_hd__buf_6
XFILLER_3_648 VGND VGND VPWR VPWR sky130_fd_sc_hd__decap_3
XTAP_TAPCELL_ROW_57_1062 VGND VPWR sky130_fd_sc_hd__tapvpwrvgnd_1
Xg_row\[0\].g_col\[1\].pe__2008_ g_row\[0\].g_col\[1\].pe__2008_/A g_row\[0\].g_col\[1\].pe__2151_/B
+ VGND VGND VPWR VPWR g_row\[0\].g_col\[1\].pe__2062_/A sky130_fd_sc_hd__nor2_2
XFILLER_19_505 VGND VGND VPWR VPWR sky130_fd_sc_hd__fill_1
XFILLER_59_652 VGND VGND VPWR VPWR sky130_fd_sc_hd__decap_3
XFILLER_86_460 VGND VGND VPWR VPWR sky130_fd_sc_hd__fill_2
XTAP_TAPCELL_ROW_70_1262 VGND VPWR sky130_fd_sc_hd__tapvpwrvgnd_1
XFILLER_59_696 VGND VGND VPWR VPWR sky130_fd_sc_hd__fill_1
XFILLER_74_622 VGND VGND VPWR VPWR sky130_fd_sc_hd__decap_3
XFILLER_58_195 VGND VGND VPWR VPWR sky130_fd_sc_hd__fill_1
XFILLER_14_210 VGND VGND VPWR VPWR sky130_fd_sc_hd__fill_1
Xg_row\[0\].g_col\[1\].pe_hold1971 g_row\[0\].g_col\[1\].pe_hold3073/X VGND VGND VPWR
+ VPWR g_row\[0\].g_col\[1\].pe__1395_/A1 sky130_fd_sc_hd__clkbuf_2
XFILLER_15_788 VGND VGND VPWR VPWR sky130_fd_sc_hd__fill_1
X_325_ _337_/CLK _325_/D VGND VGND VPWR VPWR _325_/Q sky130_fd_sc_hd__dfxtp_2
Xg_row\[1\].g_col\[0\].pe__1920_ g_row\[1\].g_col\[0\].pe__2125_/A g_row\[1\].g_col\[0\].pe__1416_/X
+ g_row\[1\].g_col\[0\].pe__2043_/A VGND VGND VPWR VPWR g_row\[1\].g_col\[0\].pe__1980_/A
+ sky130_fd_sc_hd__o21bai_2
X_187_ _205_/A _187_/B_N VGND VGND VPWR VPWR _187_/Y sky130_fd_sc_hd__nor2b_4
Xg_row\[1\].g_col\[0\].pe__1851_ g_row\[1\].g_col\[0\].pe__1851_/A g_row\[1\].g_col\[0\].pe__1851_/B
+ VGND VGND VPWR VPWR g_row\[1\].g_col\[0\].pe__1851_/X sky130_fd_sc_hd__and2_2
Xg_row\[1\].g_col\[0\].pe__1782_ g_row\[1\].g_col\[0\].pe__1804_/A place1100/A place1102/X
+ g_row\[1\].g_col\[0\].pe__1804_/B VGND VGND VPWR VPWR g_row\[1\].g_col\[0\].pe__1783_/B
+ sky130_fd_sc_hd__a22o_2
Xclkbuf_leaf_1_clk clkbuf_4_0_0_clk/X VGND VGND VPWR VPWR _338_/CLK sky130_fd_sc_hd__clkbuf_16
Xg_row\[0\].g_col\[0\].pe__1860_ g_row\[0\].g_col\[0\].pe__1860_/A g_row\[0\].g_col\[0\].pe__1860_/B
+ VGND VGND VPWR VPWR g_row\[0\].g_col\[0\].pe__1882_/A sky130_fd_sc_hd__xor2_2
Xg_row\[1\].g_col\[0\].pe__2403_ g_row\[1\].g_col\[0\].pe__2403_/A VGND VGND VPWR
+ VPWR g_row\[1\].g_col\[0\].pe__2403_/Y sky130_fd_sc_hd__inv_2
XTAP_TAPCELL_ROW_88_1523 VGND VPWR sky130_fd_sc_hd__tapvpwrvgnd_1
XTAP_TAPCELL_ROW_88_1534 VGND VPWR sky130_fd_sc_hd__tapvpwrvgnd_1
Xg_row\[0\].g_col\[0\].pe__1791_ g_row\[0\].g_col\[0\].pe__1791_/A g_row\[0\].g_col\[0\].pe__1797_/A
+ VGND VGND VPWR VPWR g_row\[0\].g_col\[0\].pe__1792_/A sky130_fd_sc_hd__nor2_2
Xg_row\[1\].g_col\[1\].pe__2350_ g_row\[1\].g_col\[1\].pe__2350_/A g_row\[1\].g_col\[1\].pe__2350_/B
+ VGND VGND VPWR VPWR g_row\[1\].g_col\[1\].pe__2352_/C sky130_fd_sc_hd__xnor2_2
Xg_row\[1\].g_col\[0\].pe__2334_ g_row\[1\].g_col\[0\].pe__2663_/A g_row\[1\].g_col\[0\].pe__2334_/A2
+ g_row\[1\].g_col\[0\].pe__2331_/X g_row\[1\].g_col\[0\].pe__2333_/Y VGND VGND VPWR
+ VPWR g_row\[1\].g_col\[0\].pe__2334_/X sky130_fd_sc_hd__o22a_2
Xg_row\[1\].g_col\[1\].pe__2281_ g_row\[1\].g_col\[1\].pe__2311_/A g_row\[1\].g_col\[1\].pe__2311_/B
+ VGND VGND VPWR VPWR g_row\[1\].g_col\[1\].pe__2283_/B sky130_fd_sc_hd__xor2_2
XFILLER_92_474 VGND VGND VPWR VPWR sky130_fd_sc_hd__fill_2
Xg_row\[1\].g_col\[0\].pe__2265_ g_row\[1\].g_col\[0\].pe__2238_/X g_row\[1\].g_col\[0\].pe__2234_/Y
+ g_row\[1\].g_col\[0\].pe__2263_/X VGND VGND VPWR VPWR g_row\[1\].g_col\[0\].pe__2265_/Y
+ sky130_fd_sc_hd__o21ai_2
XFILLER_80_636 VGND VGND VPWR VPWR sky130_fd_sc_hd__fill_1
Xg_row\[0\].g_col\[0\].pe__2412_ g_row\[0\].g_col\[0\].pe__2743_/Q g_row\[0\].g_col\[0\].pe__2742_/Q
+ g_row\[0\].g_col\[0\].pe__2741_/Q g_row\[0\].g_col\[0\].pe__2455_/B g_row\[0\].g_col\[0\].pe__2450_/A1
+ VGND VGND VPWR VPWR g_row\[0\].g_col\[0\].pe__2445_/B sky130_fd_sc_hd__o41a_2
Xg_row\[1\].g_col\[0\].pe_place1115 g_row\[1\].g_col\[0\].pe__2592_/A VGND VGND VPWR
+ VPWR g_row\[1\].g_col\[0\].pe__2595_/A sky130_fd_sc_hd__buf_6
Xg_row\[1\].g_col\[0\].pe__2196_ g_row\[1\].g_col\[0\].pe__2161_/Y g_row\[1\].g_col\[0\].pe__2157_/B
+ g_row\[1\].g_col\[0\].pe__2200_/B g_row\[1\].g_col\[0\].pe__2236_/A1 VGND VGND VPWR
+ VPWR g_row\[1\].g_col\[0\].pe__2196_/X sky130_fd_sc_hd__a31o_2
Xg_row\[0\].g_col\[0\].pe_hold3040 g_row\[0\].g_col\[0\].pe__2666_/X VGND VGND VPWR
+ VPWR g_row\[0\].g_col\[0\].pe_hold3040/X sky130_fd_sc_hd__clkbuf_2
Xg_row\[0\].g_col\[0\].pe_hold3051 _315_/Q VGND VGND VPWR VPWR g_row\[0\].g_col\[0\].pe_hold3051/X
+ sky130_fd_sc_hd__clkbuf_2
XFILLER_33_574 VGND VGND VPWR VPWR sky130_fd_sc_hd__decap_3
Xg_row\[0\].g_col\[0\].pe__2343_ g_row\[0\].g_col\[0\].pe__2343_/A g_row\[0\].g_col\[0\].pe__2365_/A
+ VGND VGND VPWR VPWR g_row\[0\].g_col\[0\].pe__2345_/B sky130_fd_sc_hd__xor2_2
Xg_row\[0\].g_col\[0\].pe_hold3084 g_row\[0\].g_col\[0\].pe__2727_/Q VGND VGND VPWR
+ VPWR g_row\[0\].g_col\[0\].pe_hold3084/X sky130_fd_sc_hd__clkbuf_2
XFILLER_20_235 VGND VGND VPWR VPWR sky130_fd_sc_hd__fill_2
Xg_row\[0\].g_col\[0\].pe__2274_ g_row\[0\].g_col\[0\].pe__2125_/A g_row\[0\].g_col\[0\].pe__2733_/Q
+ g_row\[0\].g_col\[0\].pe__1912_/A g_row\[0\].g_col\[0\].pe__2345_/A VGND VGND VPWR
+ VPWR g_row\[0\].g_col\[0\].pe__2318_/A sky130_fd_sc_hd__o211a_2
Xg_row\[0\].g_col\[1\].pe_place964 g_row\[0\].g_col\[1\].pe__2624_/A1 VGND VGND VPWR
+ VPWR g_row\[0\].g_col\[1\].pe__1950_/A sky130_fd_sc_hd__buf_6
Xg_row\[0\].g_col\[1\].pe_place953 g_row\[0\].g_col\[1\].pe__2079_/B VGND VGND VPWR
+ VPWR g_row\[0\].g_col\[1\].pe__2026_/B sky130_fd_sc_hd__buf_6
Xg_row\[0\].g_col\[1\].pe_place942 g_row\[0\].g_col\[1\].pe__2399_/Y VGND VGND VPWR
+ VPWR g_row\[0\].g_col\[1\].pe__2421_/A1 sky130_fd_sc_hd__buf_6
Xg_row\[0\].g_col\[1\].pe__2290_ g_row\[0\].g_col\[1\].pe__2291_/A g_row\[0\].g_col\[1\].pe__2291_/B
+ VGND VGND VPWR VPWR g_row\[0\].g_col\[1\].pe__2292_/A sky130_fd_sc_hd__nor2_2
Xg_row\[1\].g_col\[1\].pe__1996_ g_row\[1\].g_col\[1\].pe__2055_/A g_row\[1\].g_col\[1\].pe__2055_/B
+ VGND VGND VPWR VPWR g_row\[1\].g_col\[1\].pe__1997_/B sky130_fd_sc_hd__xor2_2
Xhold3524 hold3524/A VGND VGND VPWR VPWR hold3524/X sky130_fd_sc_hd__clkbuf_2
Xhold3513 hold3513/A VGND VGND VPWR VPWR hold3513/X sky130_fd_sc_hd__clkbuf_2
Xhold3502 hold3502/A VGND VGND VPWR VPWR hold3502/X sky130_fd_sc_hd__clkbuf_2
Xhold2801 hold2801/A VGND VGND VPWR VPWR _261_/B_N sky130_fd_sc_hd__clkbuf_2
Xhold2812 hold3575/X VGND VGND VPWR VPWR hold3576/A sky130_fd_sc_hd__clkbuf_2
Xhold3568 hold3568/A VGND VGND VPWR VPWR hold3568/X sky130_fd_sc_hd__clkbuf_2
Xhold3557 hold3557/A VGND VGND VPWR VPWR hold3557/X sky130_fd_sc_hd__clkbuf_2
Xhold3546 hold3546/A VGND VGND VPWR VPWR hold3546/X sky130_fd_sc_hd__clkbuf_2
Xhold3535 a_inputs_flat[11] VGND VGND VPWR VPWR hold3535/X sky130_fd_sc_hd__clkbuf_2
Xhold3579 hold3579/A VGND VGND VPWR VPWR hold3579/X sky130_fd_sc_hd__clkbuf_2
Xg_row\[1\].g_col\[1\].pe__2617_ g_row\[1\].g_col\[1\].pe__2626_/A1 place1092/X g_row\[1\].g_col\[1\].pe__2626_/B1
+ g_row\[1\].g_col\[1\].pe__2617_/C1 VGND VGND VPWR VPWR g_row\[1\].g_col\[1\].pe__2617_/X
+ sky130_fd_sc_hd__o211a_2
XFILLER_56_622 VGND VGND VPWR VPWR sky130_fd_sc_hd__fill_2
Xg_row\[0\].g_col\[0\].pe__1989_ g_row\[0\].g_col\[0\].pe__1919_/B g_row\[0\].g_col\[0\].pe__1980_/X
+ g_row\[0\].g_col\[0\].pe__1981_/Y g_row\[0\].g_col\[0\].pe__1987_/Y g_row\[0\].g_col\[0\].pe__1988_/X
+ VGND VGND VPWR VPWR g_row\[0\].g_col\[0\].pe__1991_/C sky130_fd_sc_hd__a311o_2
Xg_row\[1\].g_col\[1\].pe__2548_ g_row\[1\].g_col\[1\].pe__2548_/A1 g_row\[1\].g_col\[1\].pe__2568_/A2
+ g_row\[1\].g_col\[1\].pe__2568_/B1 g_row\[1\].g_col\[1\].pe__2547_/X VGND VGND VPWR
+ VPWR g_row\[1\].g_col\[1\].pe__2548_/X sky130_fd_sc_hd__a22o_2
XFILLER_56_655 VGND VGND VPWR VPWR sky130_fd_sc_hd__decap_3
XFILLER_44_839 VGND VGND VPWR VPWR sky130_fd_sc_hd__decap_3
Xg_row\[1\].g_col\[1\].pe__2479_ g_row\[1\].g_col\[1\].pe__2579_/B g_row\[1\].g_col\[1\].pe__2579_/C
+ g_row\[1\].g_col\[1\].pe__2579_/A VGND VGND VPWR VPWR g_row\[1\].g_col\[1\].pe__2479_/X
+ sky130_fd_sc_hd__a21o_2
XFILLER_71_658 VGND VGND VPWR VPWR sky130_fd_sc_hd__fill_1
Xg_row\[0\].g_col\[1\].pe__2626_ g_row\[0\].g_col\[1\].pe__1950_/A place1199/X g_row\[0\].g_col\[1\].pe__2626_/B1
+ g_row\[0\].g_col\[1\].pe__2625_/X VGND VGND VPWR VPWR g_row\[0\].g_col\[1\].pe__2626_/X
+ sky130_fd_sc_hd__o211a_2
XFILLER_34_67 VGND VGND VPWR VPWR sky130_fd_sc_hd__decap_3
Xg_row\[0\].g_col\[1\].pe__2557_ g_row\[0\].g_col\[1\].pe__2551_/A g_row\[0\].g_col\[1\].pe__2551_/B
+ g_row\[0\].g_col\[1\].pe__2551_/C g_row\[0\].g_col\[1\].pe__2444_/A VGND VGND VPWR
+ VPWR g_row\[0\].g_col\[1\].pe__2558_/A sky130_fd_sc_hd__a31o_2
XFILLER_8_707 VGND VGND VPWR VPWR sky130_fd_sc_hd__fill_1
Xg_row\[0\].g_col\[1\].pe__1508_ g_row\[0\].g_col\[1\].pe__1478_/A g_row\[0\].g_col\[1\].pe__1478_/B
+ g_row\[0\].g_col\[1\].pe__1507_/X VGND VGND VPWR VPWR g_row\[0\].g_col\[1\].pe__1549_/C
+ sky130_fd_sc_hd__a21o_2
Xg_row\[0\].g_col\[1\].pe_place1158 g_row\[0\].g_col\[1\].pe__2693_/Q VGND VGND VPWR
+ VPWR g_row\[0\].g_col\[1\].pe__1957_/B2 sky130_fd_sc_hd__buf_6
Xg_row\[0\].g_col\[1\].pe_place1147 g_row\[0\].g_col\[1\].pe__2177_/A1 VGND VGND VPWR
+ VPWR g_row\[0\].g_col\[1\].pe__2036_/B2 sky130_fd_sc_hd__buf_6
Xg_row\[0\].g_col\[1\].pe_place1136 g_row\[0\].g_col\[1\].pe__2704_/Q VGND VGND VPWR
+ VPWR g_row\[0\].g_col\[1\].pe__2163_/A sky130_fd_sc_hd__buf_6
Xg_row\[0\].g_col\[1\].pe_place1125 g_row\[0\].g_col\[1\].pe__1624_/A VGND VGND VPWR
+ VPWR g_row\[0\].g_col\[1\].pe__1789_/A sky130_fd_sc_hd__buf_6
Xg_row\[0\].g_col\[1\].pe__2488_ g_row\[0\].g_col\[1\].pe__2579_/C g_row\[0\].g_col\[1\].pe__2488_/B
+ VGND VGND VPWR VPWR g_row\[0\].g_col\[1\].pe__2575_/A sky130_fd_sc_hd__and2_2
Xclkload0 clkload0/A VGND VGND VPWR VPWR clkload0/X sky130_fd_sc_hd__clkbuf_16
Xg_row\[0\].g_col\[1\].pe_place1169 g_row\[0\].g_col\[1\].pe__2656_/B1 VGND VGND VPWR
+ VPWR g_row\[0\].g_col\[1\].pe__2626_/B1 sky130_fd_sc_hd__buf_6
XTAP_TAPCELL_ROW_59_1102 VGND VPWR sky130_fd_sc_hd__tapvpwrvgnd_1
XFILLER_79_736 VGND VGND VPWR VPWR sky130_fd_sc_hd__decap_3
XFILLER_47_600 VGND VGND VPWR VPWR sky130_fd_sc_hd__decap_3
XTAP_TAPCELL_ROW_6_294 VGND VPWR sky130_fd_sc_hd__tapvpwrvgnd_1
XFILLER_35_806 VGND VGND VPWR VPWR sky130_fd_sc_hd__fill_2
XFILLER_47_633 VGND VGND VPWR VPWR sky130_fd_sc_hd__fill_1
XFILLER_75_41 VGND VGND VPWR VPWR sky130_fd_sc_hd__decap_3
XFILLER_61_113 VGND VGND VPWR VPWR sky130_fd_sc_hd__fill_2
Xg_row\[1\].g_col\[0\].pe__2050_ g_row\[1\].g_col\[0\].pe__2025_/Y g_row\[1\].g_col\[0\].pe__1991_/X
+ g_row\[1\].g_col\[0\].pe__2048_/Y g_row\[1\].g_col\[0\].pe__2049_/X VGND VGND VPWR
+ VPWR g_row\[1\].g_col\[0\].pe__2052_/B sky130_fd_sc_hd__o211a_4
XTAP_TAPCELL_ROW_45_878 VGND VPWR sky130_fd_sc_hd__tapvpwrvgnd_1
XTAP_TAPCELL_ROW_45_889 VGND VPWR sky130_fd_sc_hd__tapvpwrvgnd_1
XTAP_TAPCELL_ROW_83_1453 VGND VPWR sky130_fd_sc_hd__tapvpwrvgnd_1
XFILLER_70_680 VGND VGND VPWR VPWR sky130_fd_sc_hd__fill_2
XFILLER_30_533 VGND VGND VPWR VPWR sky130_fd_sc_hd__decap_3
XTAP_TAPCELL_ROW_25_580 VGND VPWR sky130_fd_sc_hd__tapvpwrvgnd_1
XTAP_TAPCELL_ROW_25_591 VGND VPWR sky130_fd_sc_hd__tapvpwrvgnd_1
X_308_ _308_/CLK _308_/D VGND VGND VPWR VPWR _308_/Q sky130_fd_sc_hd__dfxtp_2
XFILLER_11_780 VGND VGND VPWR VPWR sky130_fd_sc_hd__decap_3
XFILLER_11_791 VGND VGND VPWR VPWR sky130_fd_sc_hd__fill_1
X_239_ _269_/A _239_/B_N VGND VGND VPWR VPWR _239_/Y sky130_fd_sc_hd__nor2b_4
Xg_row\[1\].g_col\[0\].pe__1903_ g_row\[1\].g_col\[0\].pe__2021_/A g_row\[1\].g_col\[0\].pe__1903_/B
+ VGND VGND VPWR VPWR g_row\[1\].g_col\[0\].pe__1905_/B sky130_fd_sc_hd__xnor2_2
Xg_row\[1\].g_col\[1\].pe__1850_ g_row\[1\].g_col\[1\].pe__1850_/A g_row\[1\].g_col\[1\].pe__1850_/B
+ VGND VGND VPWR VPWR g_row\[1\].g_col\[1\].pe__1886_/A sky130_fd_sc_hd__nor2_2
Xg_row\[1\].g_col\[0\].pe__1834_ g_row\[1\].g_col\[0\].pe__1834_/A g_row\[1\].g_col\[0\].pe__1834_/B
+ VGND VGND VPWR VPWR g_row\[1\].g_col\[0\].pe__1834_/Y sky130_fd_sc_hd__xnor2_2
XFILLER_41_3 VGND VGND VPWR VPWR sky130_fd_sc_hd__fill_1
Xg_row\[1\].g_col\[1\].pe__1781_ g_row\[1\].g_col\[1\].pe__1781_/A g_row\[1\].g_col\[1\].pe__1781_/B
+ VGND VGND VPWR VPWR g_row\[1\].g_col\[1\].pe__1791_/A sky130_fd_sc_hd__xnor2_2
Xg_row\[1\].g_col\[0\].pe__1765_ g_row\[1\].g_col\[0\].pe__1766_/A g_row\[1\].g_col\[0\].pe__1766_/B
+ VGND VGND VPWR VPWR g_row\[1\].g_col\[0\].pe__1793_/B sky130_fd_sc_hd__nand2_2
Xg_row\[1\].g_col\[0\].pe__1696_ g_row\[1\].g_col\[0\].pe__1678_/Y g_row\[1\].g_col\[0\].pe__1703_/B
+ g_row\[1\].g_col\[0\].pe__1695_/X VGND VGND VPWR VPWR g_row\[1\].g_col\[0\].pe__1698_/A
+ sky130_fd_sc_hd__a21oi_2
Xg_row\[0\].g_col\[0\].pe__1912_ g_row\[0\].g_col\[0\].pe__1912_/A g_row\[0\].g_col\[0\].pe__1912_/B
+ VGND VGND VPWR VPWR g_row\[0\].g_col\[0\].pe__1955_/B sky130_fd_sc_hd__xnor2_2
Xhold2119 hold3026/X VGND VGND VPWR VPWR hold2119/X sky130_fd_sc_hd__clkbuf_2
Xg_row\[0\].g_col\[0\].pe__1843_ g_row\[0\].g_col\[0\].pe__1843_/A g_row\[0\].g_col\[0\].pe__1843_/B
+ VGND VGND VPWR VPWR g_row\[0\].g_col\[0\].pe__1891_/A sky130_fd_sc_hd__nand2_2
Xhold1429 hold3131/X VGND VGND VPWR VPWR hold3132/A sky130_fd_sc_hd__clkbuf_2
Xg_row\[1\].g_col\[1\].pe__2402_ _195_/A g_row\[1\].g_col\[1\].pe__2402_/B VGND VGND
+ VPWR VPWR g_row\[1\].g_col\[1\].pe__2402_/Y sky130_fd_sc_hd__nor2_2
Xg_row\[1\].g_col\[1\].pe__2333_ g_row\[1\].g_col\[1\].pe__2330_/X g_row\[1\].g_col\[1\].pe__2329_/B
+ g_row\[1\].g_col\[1\].pe__2358_/A g_row\[1\].g_col\[1\].pe__2157_/A VGND VGND VPWR
+ VPWR g_row\[1\].g_col\[1\].pe__2333_/Y sky130_fd_sc_hd__o211ai_2
Xg_row\[0\].g_col\[1\].pe__1790_ g_row\[0\].g_col\[1\].pe__1795_/B g_row\[0\].g_col\[1\].pe__1790_/B
+ VGND VGND VPWR VPWR g_row\[0\].g_col\[1\].pe__1811_/A sky130_fd_sc_hd__nand2_2
XFILLER_53_614 VGND VGND VPWR VPWR sky130_fd_sc_hd__fill_2
XPHY_EDGE_ROW_9_Left_103 VGND VGND VPWR VPWR sky130_fd_sc_hd__decap_3
Xg_row\[0\].g_col\[0\].pe__1774_ g_row\[0\].g_col\[0\].pe__1774_/A g_row\[0\].g_col\[0\].pe__1774_/B
+ VGND VGND VPWR VPWR g_row\[0\].g_col\[0\].pe__1774_/Y sky130_fd_sc_hd__nor2_2
Xg_row\[1\].g_col\[0\].pe__2317_ g_row\[1\].g_col\[0\].pe__2347_/A g_row\[1\].g_col\[0\].pe__2317_/B
+ VGND VGND VPWR VPWR g_row\[1\].g_col\[0\].pe__2318_/B sky130_fd_sc_hd__nor2_2
XFILLER_1_93 VGND VGND VPWR VPWR sky130_fd_sc_hd__fill_1
XFILLER_53_658 VGND VGND VPWR VPWR sky130_fd_sc_hd__fill_1
Xg_row\[1\].g_col\[1\].pe__2264_ g_row\[1\].g_col\[1\].pe__2238_/X g_row\[1\].g_col\[1\].pe__2234_/Y
+ g_row\[1\].g_col\[1\].pe__2263_/X g_row\[1\].g_col\[1\].pe__2157_/A VGND VGND VPWR
+ VPWR g_row\[1\].g_col\[1\].pe__2264_/X sky130_fd_sc_hd__o31a_2
Xg_row\[1\].g_col\[0\].pe__2248_ g_row\[1\].g_col\[0\].pe__2348_/A g_row\[1\].g_col\[0\].pe__2248_/B
+ VGND VGND VPWR VPWR g_row\[1\].g_col\[0\].pe__2250_/B sky130_fd_sc_hd__xnor2_2
Xg_row\[1\].g_col\[1\].pe__2195_ g_row\[1\].g_col\[1\].pe__2231_/A g_row\[1\].g_col\[1\].pe__2231_/B
+ VGND VGND VPWR VPWR g_row\[1\].g_col\[1\].pe__2200_/B sky130_fd_sc_hd__xnor2_2
Xg_row\[1\].g_col\[0\].pe__2179_ g_row\[1\].g_col\[0\].pe__2364_/A g_row\[1\].g_col\[0\].pe__2179_/B
+ VGND VGND VPWR VPWR g_row\[1\].g_col\[0\].pe__2213_/B sky130_fd_sc_hd__xnor2_2
Xg_row\[0\].g_col\[1\].pe__2411_ g_row\[0\].g_col\[1\].pe__2740_/Q g_row\[0\].g_col\[1\].pe__2739_/Q
+ g_row\[0\].g_col\[1\].pe__2754_/Q VGND VGND VPWR VPWR g_row\[0\].g_col\[1\].pe__2455_/B
+ sky130_fd_sc_hd__o21ba_2
Xg_row\[0\].g_col\[0\].pe__2326_ g_row\[0\].g_col\[0\].pe__2327_/A g_row\[0\].g_col\[0\].pe__2327_/B
+ g_row\[0\].g_col\[0\].pe__2327_/C VGND VGND VPWR VPWR g_row\[0\].g_col\[0\].pe__2355_/A
+ sky130_fd_sc_hd__o21a_2
Xg_row\[0\].g_col\[1\].pe__2342_ g_row\[0\].g_col\[1\].pe__2632_/B g_row\[0\].g_col\[1\].pe__1540_/X
+ g_row\[0\].g_col\[1\].pe__2341_/Y g_row\[0\].g_col\[1\].pe__2736_/Q VGND VGND VPWR
+ VPWR g_row\[0\].g_col\[1\].pe__2365_/A sky130_fd_sc_hd__a22o_2
Xinput1328 hold3182/X VGND VGND VPWR VPWR hold3183/A sky130_fd_sc_hd__buf_2
Xinput1317 hold3154/X VGND VGND VPWR VPWR hold3155/A sky130_fd_sc_hd__buf_2
Xinput1306 hold3580/X VGND VGND VPWR VPWR hold3581/A sky130_fd_sc_hd__buf_2
Xg_row\[0\].g_col\[0\].pe__2257_ g_row\[0\].g_col\[0\].pe__2257_/A g_row\[0\].g_col\[0\].pe__2272_/B
+ VGND VGND VPWR VPWR g_row\[0\].g_col\[0\].pe__2330_/A sky130_fd_sc_hd__xor2_2
Xinput1339 hold3133/X VGND VGND VPWR VPWR hold3134/A sky130_fd_sc_hd__buf_2
Xg_row\[0\].g_col\[1\].pe__2273_ g_row\[0\].g_col\[1\].pe__2273_/A g_row\[0\].g_col\[1\].pe__2273_/B
+ VGND VGND VPWR VPWR g_row\[0\].g_col\[1\].pe__2287_/A sky130_fd_sc_hd__or2_2
Xg_row\[0\].g_col\[0\].pe__2188_ g_row\[0\].g_col\[0\].pe__2143_/A g_row\[0\].g_col\[0\].pe__2143_/B
+ g_row\[0\].g_col\[0\].pe__2187_/X VGND VGND VPWR VPWR g_row\[0\].g_col\[0\].pe__2190_/B
+ sky130_fd_sc_hd__a21oi_2
Xg_row\[1\].g_col\[1\].pe_hold1927 g_row\[1\].g_col\[1\].pe__2698_/Q VGND VGND VPWR
+ VPWR g_row\[1\].g_col\[1\].pe__2618_/B sky130_fd_sc_hd__clkbuf_2
Xg_row\[1\].g_col\[1\].pe__1979_ g_row\[1\].g_col\[1\].pe__1978_/A g_row\[1\].g_col\[1\].pe__1978_/B
+ g_row\[1\].g_col\[1\].pe__1978_/C VGND VGND VPWR VPWR g_row\[1\].g_col\[1\].pe__1991_/B
+ sky130_fd_sc_hd__o21ai_2
XFILLER_88_533 VGND VGND VPWR VPWR sky130_fd_sc_hd__fill_2
XTAP_TAPCELL_ROW_54_1021 VGND VPWR sky130_fd_sc_hd__tapvpwrvgnd_1
Xhold3310 hold3310/A VGND VGND VPWR VPWR hold3310/X sky130_fd_sc_hd__clkbuf_2
Xhold3321 hold3321/A VGND VGND VPWR VPWR hold3321/X sky130_fd_sc_hd__clkbuf_2
Xhold3332 hold3332/A VGND VGND VPWR VPWR hold3332/X sky130_fd_sc_hd__clkbuf_2
Xhold3343 hold3343/A VGND VGND VPWR VPWR hold3343/X sky130_fd_sc_hd__clkbuf_2
Xg_row\[1\].g_col\[1\].pe_hold1949 g_row\[1\].g_col\[1\].pe__2622_/X VGND VGND VPWR
+ VPWR g_row\[1\].g_col\[1\].pe__2699_/D sky130_fd_sc_hd__clkbuf_2
XFILLER_29_12 VGND VGND VPWR VPWR sky130_fd_sc_hd__fill_1
XFILLER_76_717 VGND VGND VPWR VPWR sky130_fd_sc_hd__decap_3
Xhold2620 hold3400/X VGND VGND VPWR VPWR hold3401/A sky130_fd_sc_hd__clkbuf_2
Xhold2631 hold3349/X VGND VGND VPWR VPWR hold3350/A sky130_fd_sc_hd__clkbuf_2
Xhold3354 b_inputs_flat[14] VGND VGND VPWR VPWR hold3354/X sky130_fd_sc_hd__clkbuf_2
Xhold3365 hold3365/A VGND VGND VPWR VPWR hold3365/X sky130_fd_sc_hd__clkbuf_2
Xhold3376 hold3376/A VGND VGND VPWR VPWR hold3376/X sky130_fd_sc_hd__clkbuf_2
XFILLER_76_739 VGND VGND VPWR VPWR sky130_fd_sc_hd__decap_3
Xhold2642 hold3445/X VGND VGND VPWR VPWR hold3446/A sky130_fd_sc_hd__clkbuf_2
Xhold2653 hold2653/A VGND VGND VPWR VPWR _332_/D sky130_fd_sc_hd__clkbuf_2
Xhold2664 _211_/Y VGND VGND VPWR VPWR hold2664/X sky130_fd_sc_hd__clkbuf_2
Xhold3387 hold3387/A VGND VGND VPWR VPWR hold3387/X sky130_fd_sc_hd__clkbuf_2
Xhold3398 hold3398/A VGND VGND VPWR VPWR hold3398/X sky130_fd_sc_hd__clkbuf_2
XFILLER_75_238 VGND VGND VPWR VPWR sky130_fd_sc_hd__fill_1
XFILLER_84_750 VGND VGND VPWR VPWR sky130_fd_sc_hd__decap_3
XTAP_TAPCELL_ROW_3_253 VGND VPWR sky130_fd_sc_hd__tapvpwrvgnd_1
Xhold2675 hold3465/X VGND VGND VPWR VPWR _215_/B_N sky130_fd_sc_hd__clkbuf_2
Xhold2686 hold3442/X VGND VGND VPWR VPWR hold3443/A sky130_fd_sc_hd__clkbuf_2
Xhold2697 hold3475/X VGND VGND VPWR VPWR hold3476/A sky130_fd_sc_hd__clkbuf_2
XFILLER_17_817 VGND VGND VPWR VPWR sky130_fd_sc_hd__fill_1
XFILLER_56_474 VGND VGND VPWR VPWR sky130_fd_sc_hd__fill_2
XFILLER_84_783 VGND VGND VPWR VPWR sky130_fd_sc_hd__fill_1
Xg_row\[0\].g_col\[1\].pe__1988_ g_row\[0\].g_col\[1\].pe__2043_/A g_row\[0\].g_col\[1\].pe__1988_/B
+ g_row\[0\].g_col\[1\].pe__1988_/C VGND VGND VPWR VPWR g_row\[0\].g_col\[1\].pe__1988_/X
+ sky130_fd_sc_hd__and3b_4
XFILLER_28_176 VGND VGND VPWR VPWR sky130_fd_sc_hd__fill_1
XFILLER_43_113 VGND VGND VPWR VPWR sky130_fd_sc_hd__decap_3
XTAP_TAPCELL_ROW_42_837 VGND VPWR sky130_fd_sc_hd__tapvpwrvgnd_1
XTAP_TAPCELL_ROW_65_1183 VGND VPWR sky130_fd_sc_hd__tapvpwrvgnd_1
XFILLER_24_393 VGND VGND VPWR VPWR sky130_fd_sc_hd__fill_1
XFILLER_8_504 VGND VGND VPWR VPWR sky130_fd_sc_hd__fill_2
XFILLER_61_54 VGND VGND VPWR VPWR sky130_fd_sc_hd__fill_2
XANTENNA_9 a_inputs_flat[19] VGND VGND VPWR VPWR sky130_fd_sc_hd__diode_2
XFILLER_6_27 VGND VGND VPWR VPWR sky130_fd_sc_hd__fill_1
XFILLER_4_721 VGND VGND VPWR VPWR sky130_fd_sc_hd__decap_3
XFILLER_4_754 VGND VGND VPWR VPWR sky130_fd_sc_hd__fill_2
Xg_row\[1\].g_col\[0\].pe__1550_ g_row\[1\].g_col\[0\].pe__1550_/A g_row\[1\].g_col\[0\].pe__1550_/B
+ VGND VGND VPWR VPWR g_row\[1\].g_col\[0\].pe__1669_/B sky130_fd_sc_hd__xnor2_2
XFILLER_67_706 VGND VGND VPWR VPWR sky130_fd_sc_hd__fill_1
XFILLER_79_544 VGND VGND VPWR VPWR sky130_fd_sc_hd__decap_3
Xg_row\[1\].g_col\[0\].pe__1481_ g_row\[1\].g_col\[0\].pe__1481_/A g_row\[1\].g_col\[0\].pe__1481_/B
+ VGND VGND VPWR VPWR g_row\[1\].g_col\[0\].pe__1481_/X sky130_fd_sc_hd__and2_2
XFILLER_35_614 VGND VGND VPWR VPWR sky130_fd_sc_hd__fill_2
XFILLER_47_452 VGND VGND VPWR VPWR sky130_fd_sc_hd__fill_2
XFILLER_19_187 VGND VGND VPWR VPWR sky130_fd_sc_hd__fill_2
Xg_row\[1\].g_col\[0\].pe__2102_ g_row\[1\].g_col\[0\].pe__2145_/A g_row\[1\].g_col\[0\].pe__2101_/C
+ g_row\[1\].g_col\[0\].pe__2101_/A VGND VGND VPWR VPWR g_row\[1\].g_col\[0\].pe__2104_/B
+ sky130_fd_sc_hd__o21ai_2
XFILLER_90_753 VGND VGND VPWR VPWR sky130_fd_sc_hd__decap_3
Xg_row\[0\].g_col\[0\].pe__1490_ g_row\[0\].g_col\[0\].pe__1490_/A g_row\[0\].g_col\[0\].pe__1490_/B
+ VGND VGND VPWR VPWR g_row\[0\].g_col\[0\].pe__1512_/B sky130_fd_sc_hd__xnor2_2
Xg_row\[1\].g_col\[0\].pe__2033_ g_row\[1\].g_col\[0\].pe__2032_/B g_row\[1\].g_col\[0\].pe__2032_/C
+ g_row\[1\].g_col\[0\].pe__2085_/A VGND VGND VPWR VPWR g_row\[1\].g_col\[0\].pe__2034_/D
+ sky130_fd_sc_hd__a21o_2
XFILLER_62_477 VGND VGND VPWR VPWR sky130_fd_sc_hd__fill_2
XFILLER_89_3 VGND VGND VPWR VPWR sky130_fd_sc_hd__fill_1
XTAP_TAPCELL_ROW_20_509 VGND VPWR sky130_fd_sc_hd__tapvpwrvgnd_1
Xg_row\[0\].g_col\[0\].pe__2111_ g_row\[0\].g_col\[0\].pe__2111_/A g_row\[0\].g_col\[0\].pe__2153_/C
+ VGND VGND VPWR VPWR g_row\[0\].g_col\[0\].pe__2111_/X sky130_fd_sc_hd__or2b_2
Xg_row\[0\].g_col\[0\].pe__2042_ g_row\[0\].g_col\[0\].pe__2043_/A g_row\[0\].g_col\[0\].pe__2043_/B
+ VGND VGND VPWR VPWR g_row\[0\].g_col\[0\].pe__2094_/C sky130_fd_sc_hd__or2_2
Xg_row\[1\].g_col\[1\].pe__1902_ g_row\[1\].g_col\[1\].pe__2612_/B g_row\[1\].g_col\[1\].pe__1504_/Y
+ g_row\[1\].g_col\[1\].pe__1541_/X g_row\[1\].g_col\[1\].pe__2019_/B2 VGND VGND VPWR
+ VPWR g_row\[1\].g_col\[1\].pe__1903_/B sky130_fd_sc_hd__a22o_2
XFILLER_7_570 VGND VGND VPWR VPWR sky130_fd_sc_hd__fill_1
XFILLER_7_592 VGND VGND VPWR VPWR sky130_fd_sc_hd__decap_3
Xplace1214 place1214/A VGND VGND VPWR VPWR place1214/X sky130_fd_sc_hd__buf_6
Xplace1247 place1248/X VGND VGND VPWR VPWR place1247/X sky130_fd_sc_hd__buf_6
Xg_row\[1\].g_col\[1\].pe__1833_ g_row\[1\].g_col\[1\].pe__1702_/X g_row\[1\].g_col\[1\].pe__1829_/Y
+ g_row\[1\].g_col\[1\].pe__1832_/Y VGND VGND VPWR VPWR g_row\[1\].g_col\[1\].pe__1834_/B
+ sky130_fd_sc_hd__a21oi_2
Xg_row\[1\].g_col\[0\].pe__1817_ g_row\[1\].g_col\[0\].pe__1777_/A g_row\[1\].g_col\[0\].pe__1777_/B
+ g_row\[1\].g_col\[0\].pe__1816_/X VGND VGND VPWR VPWR g_row\[1\].g_col\[0\].pe__1818_/B
+ sky130_fd_sc_hd__a21oi_2
Xplace1269 place1271/X VGND VGND VPWR VPWR place1269/X sky130_fd_sc_hd__buf_6
Xg_row\[1\].g_col\[1\].pe__1764_ g_row\[1\].g_col\[1\].pe__1785_/A g_row\[1\].g_col\[1\].pe__1764_/B
+ VGND VGND VPWR VPWR g_row\[1\].g_col\[1\].pe__1766_/B sky130_fd_sc_hd__xor2_2
Xg_row\[1\].g_col\[0\].pe__1748_ place1106/X g_row\[1\].g_col\[0\].pe__1748_/B VGND
+ VGND VPWR VPWR g_row\[1\].g_col\[0\].pe__1816_/B sky130_fd_sc_hd__nand2_2
XFILLER_85_503 VGND VGND VPWR VPWR sky130_fd_sc_hd__fill_1
Xg_row\[1\].g_col\[1\].pe__1695_ g_row\[1\].g_col\[1\].pe__1695_/A g_row\[1\].g_col\[1\].pe__1695_/B
+ VGND VGND VPWR VPWR g_row\[1\].g_col\[1\].pe__1695_/X sky130_fd_sc_hd__and2_2
Xg_row\[1\].g_col\[0\].pe_hold2851 g_row\[1\].g_col\[0\].pe__2641_/X VGND VGND VPWR
+ VPWR g_row\[1\].g_col\[0\].pe__2642_/C1 sky130_fd_sc_hd__clkbuf_2
Xg_row\[1\].g_col\[0\].pe__1679_ g_row\[1\].g_col\[0\].pe__1804_/A place1089/X place1092/X
+ g_row\[1\].g_col\[0\].pe__1804_/B VGND VGND VPWR VPWR g_row\[1\].g_col\[0\].pe__1680_/B
+ sky130_fd_sc_hd__a22o_2
Xg_row\[0\].g_col\[1\].pe__1911_ g_row\[0\].g_col\[1\].pe__1911_/A1 g_row\[0\].g_col\[1\].pe__1457_/X
+ g_row\[0\].g_col\[1\].pe__1461_/Y g_row\[0\].g_col\[1\].pe__2036_/B2 VGND VGND VPWR
+ VPWR g_row\[0\].g_col\[1\].pe__1912_/B sky130_fd_sc_hd__a22o_2
XFILLER_38_430 VGND VGND VPWR VPWR sky130_fd_sc_hd__fill_1
Xg_row\[0\].g_col\[1\].pe__1842_ g_row\[0\].g_col\[1\].pe__1702_/X g_row\[0\].g_col\[1\].pe__1829_/Y
+ g_row\[0\].g_col\[1\].pe__1834_/A g_row\[0\].g_col\[1\].pe__1832_/Y VGND VGND VPWR
+ VPWR g_row\[0\].g_col\[1\].pe__1843_/B sky130_fd_sc_hd__a211o_2
XFILLER_26_603 VGND VGND VPWR VPWR sky130_fd_sc_hd__fill_2
XFILLER_66_750 VGND VGND VPWR VPWR sky130_fd_sc_hd__fill_1
XTAP_TAPCELL_ROW_0_201 VGND VPWR sky130_fd_sc_hd__tapvpwrvgnd_1
XTAP_TAPCELL_ROW_0_212 VGND VPWR sky130_fd_sc_hd__tapvpwrvgnd_1
Xg_row\[0\].g_col\[0\].pe__1826_ g_row\[0\].g_col\[0\].pe__1828_/A g_row\[0\].g_col\[0\].pe__1828_/B
+ VGND VGND VPWR VPWR g_row\[0\].g_col\[0\].pe__1826_/Y sky130_fd_sc_hd__nor2_2
Xg_row\[1\].g_col\[0\].pe_hold2895 g_row\[1\].g_col\[0\].pe_hold2895/A VGND VGND VPWR
+ VPWR g_row\[1\].g_col\[0\].pe__2622_/A2 sky130_fd_sc_hd__clkbuf_2
Xg_row\[0\].g_col\[0\].pe__1757_ g_row\[0\].g_col\[0\].pe__1770_/A g_row\[0\].g_col\[0\].pe__1770_/B
+ g_row\[0\].g_col\[0\].pe__1756_/X VGND VGND VPWR VPWR g_row\[0\].g_col\[0\].pe__1774_/A
+ sky130_fd_sc_hd__a21oi_2
Xg_row\[1\].g_col\[1\].pe__2316_ g_row\[1\].g_col\[1\].pe__2316_/A g_row\[1\].g_col\[1\].pe__2316_/B
+ VGND VGND VPWR VPWR g_row\[1\].g_col\[1\].pe__2317_/B sky130_fd_sc_hd__nor2_2
Xg_row\[0\].g_col\[1\].pe__1773_ g_row\[0\].g_col\[1\].pe__1816_/A g_row\[0\].g_col\[1\].pe__1816_/B
+ VGND VGND VPWR VPWR g_row\[0\].g_col\[1\].pe__1778_/A sky130_fd_sc_hd__nand2_2
XFILLER_25_135 VGND VGND VPWR VPWR sky130_fd_sc_hd__decap_3
XFILLER_25_157 VGND VGND VPWR VPWR sky130_fd_sc_hd__decap_3
XFILLER_53_455 VGND VGND VPWR VPWR sky130_fd_sc_hd__fill_2
Xg_row\[1\].g_col\[1\].pe__2247_ g_row\[1\].g_col\[1\].pe__2388_/A g_row\[1\].g_col\[1\].pe__1657_/B
+ g_row\[1\].g_col\[1\].pe__2247_/B1 g_row\[1\].g_col\[1\].pe__2121_/A VGND VGND VPWR
+ VPWR g_row\[1\].g_col\[1\].pe__2248_/B sky130_fd_sc_hd__a22o_2
XFILLER_13_319 VGND VGND VPWR VPWR sky130_fd_sc_hd__fill_1
Xg_row\[0\].g_col\[0\].pe__1688_ g_row\[0\].g_col\[0\].pe__1688_/A g_row\[0\].g_col\[0\].pe__1688_/B
+ VGND VGND VPWR VPWR g_row\[0\].g_col\[0\].pe__1721_/B sky130_fd_sc_hd__xnor2_2
Xg_row\[1\].g_col\[1\].pe__2178_ g_row\[1\].g_col\[1\].pe__2278_/B2 g_row\[1\].g_col\[1\].pe__2313_/A2
+ g_row\[1\].g_col\[1\].pe__2313_/B1 g_row\[1\].g_col\[1\].pe__2241_/B2 VGND VGND
+ VPWR VPWR g_row\[1\].g_col\[1\].pe__2179_/B sky130_fd_sc_hd__a22o_2
XFILLER_31_35 VGND VGND VPWR VPWR sky130_fd_sc_hd__fill_1
Xg_row\[0\].g_col\[0\].pe__2309_ g_row\[0\].g_col\[0\].pe__2287_/A g_row\[0\].g_col\[0\].pe__2309_/B
+ VGND VGND VPWR VPWR g_row\[0\].g_col\[0\].pe__2327_/A sky130_fd_sc_hd__and2b_2
Xg_row\[0\].g_col\[1\].pe__2325_ g_row\[0\].g_col\[1\].pe__2325_/A g_row\[0\].g_col\[1\].pe__2338_/A
+ VGND VGND VPWR VPWR g_row\[0\].g_col\[1\].pe__2327_/C sky130_fd_sc_hd__xnor2_2
XFILLER_31_57 VGND VGND VPWR VPWR sky130_fd_sc_hd__decap_3
XFILLER_5_529 VGND VGND VPWR VPWR sky130_fd_sc_hd__fill_1
Xg_row\[0\].g_col\[1\].pe__2256_ g_row\[0\].g_col\[1\].pe__2213_/A g_row\[0\].g_col\[1\].pe__2213_/B
+ g_row\[0\].g_col\[1\].pe__2220_/B g_row\[0\].g_col\[1\].pe__2219_/B g_row\[0\].g_col\[1\].pe__2219_/A
+ VGND VGND VPWR VPWR g_row\[0\].g_col\[1\].pe__2272_/B sky130_fd_sc_hd__a32o_2
XFILLER_31_79 VGND VGND VPWR VPWR sky130_fd_sc_hd__fill_2
Xg_row\[1\].g_col\[1\].pe_hold1702 g_row\[1\].g_col\[1\].pe__2266_/Y VGND VGND VPWR
+ VPWR g_row\[1\].g_col\[1\].pe__2267_/B1 sky130_fd_sc_hd__clkbuf_2
Xg_row\[0\].g_col\[1\].pe__2187_ g_row\[0\].g_col\[1\].pe__2142_/A g_row\[0\].g_col\[1\].pe__2187_/B
+ VGND VGND VPWR VPWR g_row\[0\].g_col\[1\].pe__2187_/X sky130_fd_sc_hd__and2b_2
XTAP_TAPCELL_ROW_8_323 VGND VPWR sky130_fd_sc_hd__tapvpwrvgnd_1
XTAP_TAPCELL_ROW_8_334 VGND VPWR sky130_fd_sc_hd__tapvpwrvgnd_1
Xg_row\[1\].g_col\[1\].pe_hold1746 g_row\[1\].g_col\[1\].pe__2767_/Q VGND VGND VPWR
+ VPWR g_row\[1\].g_col\[1\].pe__2576_/A1 sky130_fd_sc_hd__clkbuf_2
Xg_row\[1\].g_col\[1\].pe_hold1713 g_row\[1\].g_col\[1\].pe__2751_/Q VGND VGND VPWR
+ VPWR g_row\[1\].g_col\[1\].pe__2336_/A sky130_fd_sc_hd__clkbuf_2
Xhold3140 hold3140/A VGND VGND VPWR VPWR hold3140/X sky130_fd_sc_hd__clkbuf_2
Xhold3151 a_inputs_flat[9] VGND VGND VPWR VPWR hold3151/X sky130_fd_sc_hd__clkbuf_2
Xg_row\[1\].g_col\[1\].pe_hold1779 g_row\[1\].g_col\[1\].pe__1387_/X VGND VGND VPWR
+ VPWR g_row\[1\].g_col\[1\].pe__1388_/B1 sky130_fd_sc_hd__clkbuf_2
Xg_row\[1\].g_col\[1\].pe_hold1768 g_row\[1\].g_col\[1\].pe__2640_/X VGND VGND VPWR
+ VPWR g_row\[1\].g_col\[1\].pe__2705_/D sky130_fd_sc_hd__clkbuf_2
XFILLER_48_216 VGND VGND VPWR VPWR sky130_fd_sc_hd__fill_2
Xhold3162 hold3162/A VGND VGND VPWR VPWR hold3162/X sky130_fd_sc_hd__clkbuf_2
Xhold3173 hold3173/A VGND VGND VPWR VPWR hold3173/X sky130_fd_sc_hd__clkbuf_2
Xhold3184 hold3184/A VGND VGND VPWR VPWR hold3184/X sky130_fd_sc_hd__clkbuf_2
Xhold2450 hold3207/X VGND VGND VPWR VPWR hold3208/A sky130_fd_sc_hd__clkbuf_2
Xhold2461 hold2461/A VGND VGND VPWR VPWR _327_/D sky130_fd_sc_hd__clkbuf_2
Xhold2472 _269_/Y VGND VGND VPWR VPWR hold2472/X sky130_fd_sc_hd__clkbuf_2
Xhold3195 hold3195/A VGND VGND VPWR VPWR hold3195/X sky130_fd_sc_hd__clkbuf_2
XFILLER_29_452 VGND VGND VPWR VPWR sky130_fd_sc_hd__decap_3
XFILLER_56_65 VGND VGND VPWR VPWR sky130_fd_sc_hd__fill_1
XTAP_TAPCELL_ROW_47_918 VGND VPWR sky130_fd_sc_hd__tapvpwrvgnd_1
Xhold2483 hold3234/X VGND VGND VPWR VPWR _223_/B_N sky130_fd_sc_hd__clkbuf_2
Xhold2494 hold3246/X VGND VGND VPWR VPWR hold3247/A sky130_fd_sc_hd__clkbuf_2
XFILLER_16_102 VGND VGND VPWR VPWR sky130_fd_sc_hd__fill_2
XFILLER_29_474 VGND VGND VPWR VPWR sky130_fd_sc_hd__decap_3
XFILLER_44_411 VGND VGND VPWR VPWR sky130_fd_sc_hd__decap_3
XFILLER_56_271 VGND VGND VPWR VPWR sky130_fd_sc_hd__fill_2
XTAP_TAPCELL_ROW_27_620 VGND VPWR sky130_fd_sc_hd__tapvpwrvgnd_1
XTAP_TAPCELL_ROW_67_1212 VGND VPWR sky130_fd_sc_hd__tapvpwrvgnd_1
XFILLER_44_433 VGND VGND VPWR VPWR sky130_fd_sc_hd__decap_3
XFILLER_56_293 VGND VGND VPWR VPWR sky130_fd_sc_hd__fill_2
XFILLER_72_742 VGND VGND VPWR VPWR sky130_fd_sc_hd__fill_1
XPHY_EDGE_ROW_19_Right_19 VGND VGND VPWR VPWR sky130_fd_sc_hd__decap_3
XFILLER_44_499 VGND VGND VPWR VPWR sky130_fd_sc_hd__fill_1
XFILLER_72_797 VGND VGND VPWR VPWR sky130_fd_sc_hd__fill_2
XTAP_TAPCELL_ROW_80_1412 VGND VPWR sky130_fd_sc_hd__tapvpwrvgnd_1
Xg_row\[0\].g_col\[0\].pe_hold2905 g_row\[0\].g_col\[0\].pe_hold2905/A VGND VGND VPWR
+ VPWR g_row\[0\].g_col\[0\].pe__2631_/A2 sky130_fd_sc_hd__clkbuf_2
XFILLER_72_75 VGND VGND VPWR VPWR sky130_fd_sc_hd__fill_2
Xg_row\[0\].g_col\[0\].pe_hold2938 g_row\[0\].g_col\[0\].pe__2723_/Q VGND VGND VPWR
+ VPWR g_row\[0\].g_col\[0\].pe__1340_/A sky130_fd_sc_hd__clkbuf_2
Xg_row\[0\].g_col\[0\].pe_hold2949 _287_/Q VGND VGND VPWR VPWR g_row\[0\].g_col\[0\].pe_hold2949/X
+ sky130_fd_sc_hd__clkbuf_2
XFILLER_12_363 VGND VGND VPWR VPWR sky130_fd_sc_hd__fill_1
Xg_row\[1\].g_col\[0\].pe__2720_ clkbuf_leaf_47_clk/X g_row\[1\].g_col\[0\].pe__2720_/D
+ VGND VGND VPWR VPWR g_row\[1\].g_col\[0\].pe__2720_/Q sky130_fd_sc_hd__dfxtp_2
XPHY_EDGE_ROW_28_Right_28 VGND VGND VPWR VPWR sky130_fd_sc_hd__decap_3
XTAP_TAPCELL_ROW_78_1374 VGND VPWR sky130_fd_sc_hd__tapvpwrvgnd_1
XTAP_TAPCELL_ROW_78_1385 VGND VPWR sky130_fd_sc_hd__tapvpwrvgnd_1
Xg_row\[1\].g_col\[0\].pe__2651_ g_row\[1\].g_col\[0\].pe__2676_/A g_row\[1\].g_col\[0\].pe__2651_/B
+ VGND VGND VPWR VPWR g_row\[1\].g_col\[0\].pe__2651_/X sky130_fd_sc_hd__or2_2
Xg_row\[1\].g_col\[0\].pe__1602_ g_row\[1\].g_col\[0\].pe__2021_/A g_row\[1\].g_col\[0\].pe__1602_/B
+ VGND VGND VPWR VPWR g_row\[1\].g_col\[0\].pe__1604_/B sky130_fd_sc_hd__xnor2_2
XTAP_TAPCELL_ROW_91_1574 VGND VPWR sky130_fd_sc_hd__tapvpwrvgnd_1
Xg_row\[1\].g_col\[1\].pe_hold2992 g_row\[1\].g_col\[1\].pe__2652_/X VGND VGND VPWR
+ VPWR g_row\[1\].g_col\[1\].pe_hold2992/X sky130_fd_sc_hd__clkbuf_2
Xg_row\[1\].g_col\[0\].pe__2582_ g_row\[1\].g_col\[0\].pe__2595_/A g_row\[1\].g_col\[0\].pe__2582_/B
+ VGND VGND VPWR VPWR g_row\[1\].g_col\[0\].pe__2582_/X sky130_fd_sc_hd__and2_2
XFILLER_79_374 VGND VGND VPWR VPWR sky130_fd_sc_hd__fill_1
Xg_row\[1\].g_col\[0\].pe__1533_ g_row\[1\].g_col\[0\].pe__1533_/A g_row\[1\].g_col\[0\].pe__1533_/B
+ VGND VGND VPWR VPWR g_row\[1\].g_col\[0\].pe__1588_/B sky130_fd_sc_hd__xnor2_2
Xg_row\[1\].g_col\[1\].pe__1480_ g_row\[1\].g_col\[1\].pe__1662_/A g_row\[1\].g_col\[1\].pe__1662_/B
+ g_row\[1\].g_col\[1\].pe__1479_/Y VGND VGND VPWR VPWR g_row\[1\].g_col\[1\].pe__1501_/A
+ sky130_fd_sc_hd__a21oi_2
Xg_row\[1\].g_col\[0\].pe__1464_ g_row\[1\].g_col\[0\].pe__1864_/A g_row\[1\].g_col\[0\].pe__1464_/B
+ VGND VGND VPWR VPWR g_row\[1\].g_col\[0\].pe__1507_/B sky130_fd_sc_hd__xnor2_2
Xg_row\[0\].g_col\[0\].pe__2660_ g_row\[0\].g_col\[0\].pe__2670_/A1 g_row\[0\].g_col\[0\].pe__2660_/A2
+ g_row\[0\].g_col\[0\].pe__2555_/A g_row\[0\].g_col\[0\].pe__2659_/X VGND VGND VPWR
+ VPWR g_row\[0\].g_col\[0\].pe__2660_/X sky130_fd_sc_hd__o211a_2
XFILLER_82_528 VGND VGND VPWR VPWR sky130_fd_sc_hd__decap_3
XPHY_EDGE_ROW_37_Right_37 VGND VGND VPWR VPWR sky130_fd_sc_hd__decap_3
Xg_row\[0\].g_col\[0\].pe__1611_ g_row\[0\].g_col\[0\].pe__1864_/A g_row\[0\].g_col\[0\].pe__1611_/B
+ VGND VGND VPWR VPWR g_row\[0\].g_col\[0\].pe__1851_/B sky130_fd_sc_hd__xnor2_2
Xg_row\[0\].g_col\[0\].pe__2591_ g_row\[0\].g_col\[0\].pe__2591_/A1 g_row\[0\].g_col\[0\].pe__2591_/A2
+ g_row\[0\].g_col\[0\].pe__2591_/B1 g_row\[0\].g_col\[0\].pe__2590_/X VGND VGND VPWR
+ VPWR g_row\[0\].g_col\[0\].pe__2591_/X sky130_fd_sc_hd__a22o_2
Xg_row\[1\].g_col\[0\].pe__1395_ g_row\[1\].g_col\[0\].pe__1395_/A1 g_row\[1\].g_col\[0\].pe__2679_/A2
+ g_row\[1\].g_col\[0\].pe__1394_/X g_row\[1\].g_col\[0\].pe__1403_/C1 VGND VGND VPWR
+ VPWR g_row\[1\].g_col\[0\].pe__1395_/X sky130_fd_sc_hd__o211a_2
XFILLER_62_241 VGND VGND VPWR VPWR sky130_fd_sc_hd__fill_2
Xg_row\[1\].g_col\[1\].pe__2101_ g_row\[1\].g_col\[1\].pe__2101_/A g_row\[1\].g_col\[1\].pe__2145_/A
+ g_row\[1\].g_col\[1\].pe__2101_/C VGND VGND VPWR VPWR g_row\[1\].g_col\[1\].pe__2104_/A
+ sky130_fd_sc_hd__or3_4
XFILLER_35_499 VGND VGND VPWR VPWR sky130_fd_sc_hd__fill_1
XFILLER_22_138 VGND VGND VPWR VPWR sky130_fd_sc_hd__fill_2
Xg_row\[0\].g_col\[0\].pe__1473_ g_row\[0\].g_col\[0\].pe__2733_/Q ANTENNA_182/DIODE
+ g_row\[0\].g_col\[0\].pe__2368_/A VGND VGND VPWR VPWR g_row\[0\].g_col\[0\].pe__1473_/X
+ sky130_fd_sc_hd__or3b_4
Xg_row\[1\].g_col\[1\].pe__2032_ g_row\[1\].g_col\[1\].pe__2085_/A g_row\[1\].g_col\[1\].pe__2032_/B
+ g_row\[1\].g_col\[1\].pe__2032_/C VGND VGND VPWR VPWR g_row\[1\].g_col\[1\].pe__2034_/C
+ sky130_fd_sc_hd__nand3_2
Xg_row\[1\].g_col\[0\].pe__2016_ g_row\[1\].g_col\[0\].pe__1905_/A g_row\[1\].g_col\[0\].pe__1905_/B
+ g_row\[1\].g_col\[0\].pe__1964_/B g_row\[1\].g_col\[0\].pe__1963_/B g_row\[1\].g_col\[0\].pe__1963_/A
+ VGND VGND VPWR VPWR g_row\[1\].g_col\[0\].pe__2017_/A sky130_fd_sc_hd__a32o_2
XFILLER_30_193 VGND VGND VPWR VPWR sky130_fd_sc_hd__decap_3
XPHY_EDGE_ROW_46_Right_46 VGND VGND VPWR VPWR sky130_fd_sc_hd__decap_3
Xg_row\[0\].g_col\[1\].pe__2110_ g_row\[0\].g_col\[1\].pe__2110_/A g_row\[0\].g_col\[1\].pe__2110_/B
+ VGND VGND VPWR VPWR g_row\[0\].g_col\[1\].pe__2153_/C sky130_fd_sc_hd__or2_2
Xg_row\[0\].g_col\[1\].pe__2041_ g_row\[0\].g_col\[1\].pe__2094_/A g_row\[0\].g_col\[1\].pe__2040_/X
+ g_row\[0\].g_col\[1\].pe__1424_/A g_row\[0\].g_col\[1\].pe__2125_/A VGND VGND VPWR
+ VPWR g_row\[0\].g_col\[1\].pe__2043_/B sky130_fd_sc_hd__o2bb2a_2
Xg_row\[0\].g_col\[0\].pe__2025_ g_row\[0\].g_col\[0\].pe__1919_/B g_row\[0\].g_col\[0\].pe__1980_/X
+ g_row\[0\].g_col\[0\].pe__1981_/Y g_row\[0\].g_col\[0\].pe__1987_/Y g_row\[0\].g_col\[0\].pe__1988_/X
+ VGND VGND VPWR VPWR g_row\[0\].g_col\[0\].pe__2025_/Y sky130_fd_sc_hd__a311oi_2
Xg_row\[1\].g_col\[1\].pe__1816_ g_row\[1\].g_col\[1\].pe__1816_/A g_row\[1\].g_col\[1\].pe__1816_/B
+ g_row\[1\].g_col\[1\].pe__1816_/C VGND VGND VPWR VPWR g_row\[1\].g_col\[1\].pe__1816_/X
+ sky130_fd_sc_hd__and3_2
Xplace1099 place1100/X VGND VGND VPWR VPWR place1099/X sky130_fd_sc_hd__buf_6
Xg_row\[1\].g_col\[1\].pe__1747_ g_row\[1\].g_col\[1\].pe__1747_/A g_row\[1\].g_col\[1\].pe__1820_/B
+ VGND VGND VPWR VPWR g_row\[1\].g_col\[1\].pe__1822_/C sky130_fd_sc_hd__or2_2
Xg_row\[1\].g_col\[1\].pe__1678_ g_row\[1\].g_col\[1\].pe__1703_/A VGND VGND VPWR
+ VPWR g_row\[1\].g_col\[1\].pe__1678_/Y sky130_fd_sc_hd__inv_2
XPHY_EDGE_ROW_55_Right_55 VGND VGND VPWR VPWR sky130_fd_sc_hd__decap_3
XFILLER_73_539 VGND VGND VPWR VPWR sky130_fd_sc_hd__fill_1
XFILLER_85_399 VGND VGND VPWR VPWR sky130_fd_sc_hd__decap_3
Xg_row\[0\].g_col\[0\].pe__1809_ g_row\[0\].g_col\[0\].pe__1795_/A g_row\[0\].g_col\[0\].pe__1795_/B
+ g_row\[0\].g_col\[0\].pe__1795_/C VGND VGND VPWR VPWR g_row\[0\].g_col\[0\].pe__1809_/X
+ sky130_fd_sc_hd__a21o_2
Xg_row\[0\].g_col\[1\].pe__1825_ g_row\[0\].g_col\[1\].pe__1747_/A g_row\[0\].g_col\[1\].pe__1820_/B
+ g_row\[0\].g_col\[1\].pe__1824_/X VGND VGND VPWR VPWR g_row\[0\].g_col\[1\].pe__1828_/B
+ sky130_fd_sc_hd__a21oi_2
XFILLER_54_753 VGND VGND VPWR VPWR sky130_fd_sc_hd__decap_3
Xg_row\[0\].g_col\[1\].pe__1756_ g_row\[0\].g_col\[1\].pe__1756_/A g_row\[0\].g_col\[1\].pe__1756_/B
+ VGND VGND VPWR VPWR g_row\[0\].g_col\[1\].pe__1756_/X sky130_fd_sc_hd__and2_2
XFILLER_14_617 VGND VGND VPWR VPWR sky130_fd_sc_hd__decap_3
XFILLER_81_561 VGND VGND VPWR VPWR sky130_fd_sc_hd__decap_3
XFILLER_81_572 VGND VGND VPWR VPWR sky130_fd_sc_hd__fill_2
XFILLER_13_127 VGND VGND VPWR VPWR sky130_fd_sc_hd__fill_1
XFILLER_81_594 VGND VGND VPWR VPWR sky130_fd_sc_hd__fill_2
Xg_row\[0\].g_col\[1\].pe__1687_ g_row\[0\].g_col\[1\].pe__1713_/A g_row\[0\].g_col\[1\].pe__1713_/B
+ g_row\[0\].g_col\[1\].pe__1686_/X VGND VGND VPWR VPWR g_row\[0\].g_col\[1\].pe__1721_/A
+ sky130_fd_sc_hd__a21oi_2
XFILLER_10_801 VGND VGND VPWR VPWR sky130_fd_sc_hd__decap_3
XTAP_TAPCELL_ROW_52_987 VGND VPWR sky130_fd_sc_hd__tapvpwrvgnd_1
XTAP_TAPCELL_ROW_62_1142 VGND VPWR sky130_fd_sc_hd__tapvpwrvgnd_1
XFILLER_22_672 VGND VGND VPWR VPWR sky130_fd_sc_hd__fill_1
XPHY_EDGE_ROW_64_Right_64 VGND VGND VPWR VPWR sky130_fd_sc_hd__decap_3
XFILLER_21_193 VGND VGND VPWR VPWR sky130_fd_sc_hd__decap_3
Xg_row\[0\].g_col\[1\].pe__2308_ g_row\[0\].g_col\[1\].pe__2308_/A VGND VGND VPWR
+ VPWR g_row\[0\].g_col\[1\].pe__2430_/A sky130_fd_sc_hd__inv_2
Xg_row\[1\].g_col\[1\].pe_hold2211 g_row\[1\].g_col\[1\].pe_hold2883/X VGND VGND VPWR
+ VPWR g_row\[1\].g_col\[1\].pe_hold2884/A sky130_fd_sc_hd__clkbuf_2
Xg_row\[0\].g_col\[1\].pe__2239_ g_row\[0\].g_col\[1\].pe__2239_/A g_row\[0\].g_col\[1\].pe__2239_/B
+ VGND VGND VPWR VPWR g_row\[0\].g_col\[1\].pe__2246_/A sky130_fd_sc_hd__nand2_2
XFILLER_88_182 VGND VGND VPWR VPWR sky130_fd_sc_hd__fill_2
XPHY_EDGE_ROW_73_Right_73 VGND VGND VPWR VPWR sky130_fd_sc_hd__decap_3
XFILLER_49_569 VGND VGND VPWR VPWR sky130_fd_sc_hd__decap_3
XFILLER_64_539 VGND VGND VPWR VPWR sky130_fd_sc_hd__fill_1
XFILLER_91_358 VGND VGND VPWR VPWR sky130_fd_sc_hd__decap_3
Xhold1590 hold2718/X VGND VGND VPWR VPWR hold2719/A sky130_fd_sc_hd__clkbuf_2
XFILLER_17_466 VGND VGND VPWR VPWR sky130_fd_sc_hd__fill_2
XFILLER_60_701 VGND VGND VPWR VPWR sky130_fd_sc_hd__fill_1
XFILLER_32_425 VGND VGND VPWR VPWR sky130_fd_sc_hd__decap_3
XFILLER_32_447 VGND VGND VPWR VPWR sky130_fd_sc_hd__fill_2
XPHY_EDGE_ROW_82_Right_82 VGND VGND VPWR VPWR sky130_fd_sc_hd__decap_3
XFILLER_13_694 VGND VGND VPWR VPWR sky130_fd_sc_hd__decap_3
XFILLER_12_193 VGND VGND VPWR VPWR sky130_fd_sc_hd__decap_3
XFILLER_9_676 VGND VGND VPWR VPWR sky130_fd_sc_hd__decap_3
XTAP_TAPCELL_ROW_30_659 VGND VPWR sky130_fd_sc_hd__tapvpwrvgnd_1
XFILLER_8_197 VGND VGND VPWR VPWR sky130_fd_sc_hd__fill_2
XFILLER_9_698 VGND VGND VPWR VPWR sky130_fd_sc_hd__fill_2
XTAP_TAPCELL_ROW_10_361 VGND VPWR sky130_fd_sc_hd__tapvpwrvgnd_1
XTAP_TAPCELL_ROW_93_1603 VGND VPWR sky130_fd_sc_hd__tapvpwrvgnd_1
XTAP_TAPCELL_ROW_93_1614 VGND VPWR sky130_fd_sc_hd__tapvpwrvgnd_1
XTAP_TAPCELL_ROW_93_1625 VGND VPWR sky130_fd_sc_hd__tapvpwrvgnd_1
Xg_row\[0\].g_col\[0\].pe_place1182 g_row\[0\].g_col\[0\].pe__2730_/Q VGND VGND VPWR
+ VPWR g_row\[0\].g_col\[0\].pe__1460_/B sky130_fd_sc_hd__buf_6
Xg_row\[1\].g_col\[0\].pe__2703_ clkbuf_leaf_43_clk/X g_row\[1\].g_col\[0\].pe__2703_/D
+ VGND VGND VPWR VPWR hold1986/A sky130_fd_sc_hd__dfxtp_2
Xg_row\[0\].g_col\[0\].pe_place1193 g_row\[0\].g_col\[0\].pe__2632_/B VGND VGND VPWR
+ VPWR g_row\[0\].g_col\[0\].pe__2388_/A sky130_fd_sc_hd__buf_6
Xg_row\[1\].g_col\[1\].pe__2650_ g_row\[1\].g_col\[1\].pe__2656_/A1 hold2200/X g_row\[1\].g_col\[1\].pe__2687_/C1
+ g_row\[1\].g_col\[1\].pe__2650_/C1 VGND VGND VPWR VPWR g_row\[1\].g_col\[1\].pe__2650_/X
+ sky130_fd_sc_hd__o211a_2
XFILLER_87_609 VGND VGND VPWR VPWR sky130_fd_sc_hd__decap_3
Xg_row\[1\].g_col\[1\].pe__1601_ g_row\[1\].g_col\[1\].pe__1957_/B2 g_row\[1\].g_col\[1\].pe__1549_/B
+ g_row\[1\].g_col\[1\].pe__1541_/X g_row\[1\].g_col\[1\].pe__1901_/B2 VGND VGND VPWR
+ VPWR g_row\[1\].g_col\[1\].pe__1602_/B sky130_fd_sc_hd__a22o_2
Xg_row\[1\].g_col\[0\].pe__2634_ _302_/Q _301_/Q _304_/Q _303_/Q VGND VGND VPWR VPWR
+ g_row\[1\].g_col\[0\].pe__2635_/D sky130_fd_sc_hd__or4_2
XPHY_EDGE_ROW_91_Right_91 VGND VGND VPWR VPWR sky130_fd_sc_hd__decap_3
Xg_row\[1\].g_col\[1\].pe__2581_ g_row\[1\].g_col\[1\].pe__2581_/A1 g_row\[1\].g_col\[1\].pe__2591_/A2
+ g_row\[1\].g_col\[1\].pe__2591_/B1 g_row\[1\].g_col\[1\].pe__2580_/X VGND VGND VPWR
+ VPWR g_row\[1\].g_col\[1\].pe__2581_/X sky130_fd_sc_hd__a22o_2
Xg_row\[1\].g_col\[0\].pe__2565_ g_row\[1\].g_col\[0\].pe__2595_/A g_row\[1\].g_col\[0\].pe__2565_/B
+ VGND VGND VPWR VPWR g_row\[1\].g_col\[0\].pe__2764_/D sky130_fd_sc_hd__and2_2
Xg_row\[1\].g_col\[1\].pe__1532_ g_row\[1\].g_col\[1\].pe__1555_/A g_row\[1\].g_col\[1\].pe__1555_/B
+ VGND VGND VPWR VPWR g_row\[1\].g_col\[1\].pe__1533_/B sky130_fd_sc_hd__xor2_2
Xg_row\[1\].g_col\[0\].pe__1516_ g_row\[1\].g_col\[0\].pe__1749_/A1 place1080/X place1082/X
+ g_row\[1\].g_col\[0\].pe__1641_/B2 VGND VGND VPWR VPWR g_row\[1\].g_col\[0\].pe__1517_/B
+ sky130_fd_sc_hd__a22o_2
Xg_row\[0\].g_col\[0\].pe__2712_ clkbuf_leaf_35_clk/X g_row\[0\].g_col\[0\].pe__2712_/D
+ VGND VGND VPWR VPWR hold3085/A sky130_fd_sc_hd__dfxtp_2
Xg_row\[1\].g_col\[1\].pe__1463_ g_row\[1\].g_col\[1\].pe__1957_/B2 g_row\[1\].g_col\[1\].pe__1715_/B
+ g_row\[1\].g_col\[1\].pe__1863_/B1 g_row\[1\].g_col\[1\].pe__1901_/B2 VGND VGND
+ VPWR VPWR g_row\[1\].g_col\[1\].pe__1464_/B sky130_fd_sc_hd__a22o_2
Xg_row\[1\].g_col\[0\].pe__2496_ g_row\[1\].g_col\[0\].pe__2496_/A g_row\[1\].g_col\[0\].pe__2496_/B
+ VGND VGND VPWR VPWR g_row\[1\].g_col\[0\].pe__2558_/B sky130_fd_sc_hd__nor2_2
Xg_row\[1\].g_col\[0\].pe__1447_ g_row\[1\].g_col\[0\].pe__2167_/A g_row\[1\].g_col\[0\].pe__2729_/Q
+ g_row\[1\].g_col\[0\].pe__2728_/Q VGND VGND VPWR VPWR g_row\[1\].g_col\[0\].pe__1449_/A
+ sky130_fd_sc_hd__nand3b_2
Xg_row\[0\].g_col\[0\].pe__2643_ place1263/X hold2045/X VGND VGND VPWR VPWR g_row\[0\].g_col\[0\].pe__2643_/X
+ sky130_fd_sc_hd__or2_2
Xg_row\[0\].g_col\[1\].pe__1610_ g_row\[0\].g_col\[1\].pe__2697_/Q g_row\[0\].g_col\[1\].pe__1457_/X
+ g_row\[0\].g_col\[1\].pe__1863_/B1 g_row\[0\].g_col\[1\].pe__2138_/B2 VGND VGND
+ VPWR VPWR g_row\[0\].g_col\[1\].pe__1611_/B sky130_fd_sc_hd__a22o_2
Xg_row\[1\].g_col\[1\].pe__1394_ hold2090/X g_row\[1\].g_col\[1\].pe__2680_/B VGND
+ VGND VPWR VPWR g_row\[1\].g_col\[1\].pe__1394_/X sky130_fd_sc_hd__or2_2
XFILLER_63_561 VGND VGND VPWR VPWR sky130_fd_sc_hd__fill_2
Xg_row\[0\].g_col\[1\].pe__2590_ g_row\[0\].g_col\[1\].pe__2590_/A g_row\[0\].g_col\[1\].pe__2508_/Y
+ VGND VGND VPWR VPWR g_row\[0\].g_col\[1\].pe__2590_/X sky130_fd_sc_hd__or2b_2
XTAP_TAPCELL_ROW_18_483 VGND VPWR sky130_fd_sc_hd__tapvpwrvgnd_1
Xg_row\[0\].g_col\[0\].pe__1525_ place1208/X g_row\[0\].g_col\[0\].pe__2026_/B g_row\[0\].g_col\[0\].pe__1738_/B1
+ place1210/X VGND VGND VPWR VPWR g_row\[0\].g_col\[0\].pe__1526_/B sky130_fd_sc_hd__a22o_2
Xg_row\[0\].g_col\[1\].pe__1541_ g_row\[0\].g_col\[1\].pe__2736_/Q g_row\[0\].g_col\[1\].pe__2341_/B
+ g_row\[0\].g_col\[1\].pe__1540_/X VGND VGND VPWR VPWR g_row\[0\].g_col\[1\].pe__1541_/X
+ sky130_fd_sc_hd__a21o_2
XFILLER_50_244 VGND VGND VPWR VPWR sky130_fd_sc_hd__decap_3
XFILLER_50_266 VGND VGND VPWR VPWR sky130_fd_sc_hd__decap_3
Xg_row\[1\].g_col\[1\].pe__2015_ g_row\[1\].g_col\[1\].pe__2002_/A g_row\[1\].g_col\[1\].pe__2002_/B
+ g_row\[1\].g_col\[1\].pe__2014_/X VGND VGND VPWR VPWR g_row\[1\].g_col\[1\].pe__2059_/A
+ sky130_fd_sc_hd__a21o_2
Xg_row\[0\].g_col\[0\].pe__1387_ g_row\[0\].g_col\[0\].pe__1387_/A g_row\[0\].g_col\[0\].pe__1402_/B
+ VGND VGND VPWR VPWR g_row\[0\].g_col\[0\].pe__1387_/X sky130_fd_sc_hd__or2_2
Xg_row\[0\].g_col\[0\].pe__2008_ g_row\[0\].g_col\[0\].pe__2008_/A g_row\[0\].g_col\[0\].pe__2151_/B
+ VGND VGND VPWR VPWR g_row\[0\].g_col\[0\].pe__2062_/A sky130_fd_sc_hd__nor2_2
Xg_row\[0\].g_col\[1\].pe__2024_ g_row\[0\].g_col\[1\].pe__2024_/A g_row\[0\].g_col\[1\].pe__2024_/B
+ VGND VGND VPWR VPWR g_row\[0\].g_col\[1\].pe__2052_/A sky130_fd_sc_hd__xor2_2
XFILLER_86_664 VGND VGND VPWR VPWR sky130_fd_sc_hd__decap_3
XFILLER_39_580 VGND VGND VPWR VPWR sky130_fd_sc_hd__decap_3
XFILLER_26_230 VGND VGND VPWR VPWR sky130_fd_sc_hd__fill_1
XFILLER_37_78 VGND VGND VPWR VPWR sky130_fd_sc_hd__fill_2
XFILLER_37_89 VGND VGND VPWR VPWR sky130_fd_sc_hd__decap_3
Xg_row\[0\].g_col\[1\].pe__1808_ g_row\[0\].g_col\[1\].pe__1808_/A g_row\[0\].g_col\[1\].pe__1808_/B
+ g_row\[0\].g_col\[1\].pe__1808_/C g_row\[0\].g_col\[1\].pe__1811_/C VGND VGND VPWR
+ VPWR g_row\[0\].g_col\[1\].pe__1808_/X sky130_fd_sc_hd__or4b_4
XFILLER_42_701 VGND VGND VPWR VPWR sky130_fd_sc_hd__fill_1
XTAP_TAPCELL_ROW_37_770 VGND VPWR sky130_fd_sc_hd__tapvpwrvgnd_1
XFILLER_54_594 VGND VGND VPWR VPWR sky130_fd_sc_hd__decap_3
Xg_row\[0\].g_col\[0\].pe_hold2009 g_row\[0\].g_col\[0\].pe__2672_/A VGND VGND VPWR
+ VPWR g_row\[0\].g_col\[0\].pe__2668_/A2 sky130_fd_sc_hd__clkbuf_2
Xg_row\[0\].g_col\[1\].pe__1739_ g_row\[0\].g_col\[1\].pe__1816_/A g_row\[0\].g_col\[1\].pe__1739_/B
+ VGND VGND VPWR VPWR g_row\[0\].g_col\[1\].pe__1776_/B sky130_fd_sc_hd__xor2_2
XFILLER_42_778 VGND VGND VPWR VPWR sky130_fd_sc_hd__fill_1
XFILLER_10_620 VGND VGND VPWR VPWR sky130_fd_sc_hd__decap_3
XTAP_TAPCELL_ROW_75_1333 VGND VPWR sky130_fd_sc_hd__tapvpwrvgnd_1
Xg_row\[1\].g_col\[1\].pe_hold2085 g_row\[1\].g_col\[1\].pe_hold2840/X VGND VGND VPWR
+ VPWR g_row\[1\].g_col\[1\].pe_hold2841/A sky130_fd_sc_hd__clkbuf_2
XFILLER_89_480 VGND VGND VPWR VPWR sky130_fd_sc_hd__fill_1
Xg_row\[1\].g_col\[0\].pe__2350_ g_row\[1\].g_col\[0\].pe__2350_/A g_row\[1\].g_col\[0\].pe__2350_/B
+ VGND VGND VPWR VPWR g_row\[1\].g_col\[0\].pe__2352_/C sky130_fd_sc_hd__xnor2_2
XFILLER_77_686 VGND VGND VPWR VPWR sky130_fd_sc_hd__fill_1
Xg_row\[1\].g_col\[0\].pe__2281_ g_row\[1\].g_col\[0\].pe__2311_/A g_row\[1\].g_col\[0\].pe__2311_/B
+ VGND VGND VPWR VPWR g_row\[1\].g_col\[0\].pe__2283_/B sky130_fd_sc_hd__xor2_2
XFILLER_64_347 VGND VGND VPWR VPWR sky130_fd_sc_hd__decap_3
XFILLER_17_263 VGND VGND VPWR VPWR sky130_fd_sc_hd__fill_2
XFILLER_91_177 VGND VGND VPWR VPWR sky130_fd_sc_hd__fill_2
XTAP_TAPCELL_ROW_35_729 VGND VPWR sky130_fd_sc_hd__tapvpwrvgnd_1
Xg_row\[0\].g_col\[1\].pe__2688__1424 VGND VGND VPWR VPWR g_row\[0\].g_col\[1\].pe__2688__1424/HI
+ g_row\[0\].g_col\[1\].pe__2688_/CIN sky130_fd_sc_hd__conb_1
XFILLER_60_531 VGND VGND VPWR VPWR sky130_fd_sc_hd__fill_1
XTAP_TAPCELL_ROW_86_1495 VGND VPWR sky130_fd_sc_hd__tapvpwrvgnd_1
XTAP_TAPCELL_ROW_15_431 VGND VPWR sky130_fd_sc_hd__tapvpwrvgnd_1
XTAP_TAPCELL_ROW_15_442 VGND VPWR sky130_fd_sc_hd__tapvpwrvgnd_1
Xg_row\[0\].g_col\[0\].pe__2290_ g_row\[0\].g_col\[0\].pe__2291_/A g_row\[0\].g_col\[0\].pe__2291_/B
+ VGND VGND VPWR VPWR g_row\[0\].g_col\[0\].pe__2292_/A sky130_fd_sc_hd__nor2_2
Xg_row\[1\].g_col\[0\].pe__1996_ g_row\[1\].g_col\[0\].pe__2055_/A g_row\[1\].g_col\[0\].pe__2055_/B
+ VGND VGND VPWR VPWR g_row\[1\].g_col\[0\].pe__1997_/B sky130_fd_sc_hd__xor2_2
Xg_row\[1\].g_col\[1\].pe__2702_ clkbuf_leaf_87_clk/X g_row\[1\].g_col\[1\].pe__2702_/D
+ VGND VGND VPWR VPWR g_row\[1\].g_col\[1\].pe__2702_/Q sky130_fd_sc_hd__dfxtp_2
Xg_row\[1\].g_col\[1\].pe__2633_ g_row\[1\].g_col\[1\].pe__2633_/A1 hold1989/X g_row\[1\].g_col\[1\].pe__2679_/C1
+ g_row\[1\].g_col\[1\].pe__2632_/X VGND VGND VPWR VPWR g_row\[1\].g_col\[1\].pe__2633_/X
+ sky130_fd_sc_hd__o211a_2
Xg_row\[1\].g_col\[0\].pe__2617_ g_row\[1\].g_col\[0\].pe__2640_/A1 g_row\[1\].g_col\[0\].pe__2617_/A2
+ g_row\[1\].g_col\[0\].pe__2640_/C1 g_row\[1\].g_col\[0\].pe__2616_/X VGND VGND VPWR
+ VPWR g_row\[1\].g_col\[0\].pe__2617_/X sky130_fd_sc_hd__o211a_2
XFILLER_4_71 VGND VGND VPWR VPWR sky130_fd_sc_hd__fill_1
Xg_row\[1\].g_col\[1\].pe__2564_ g_row\[1\].g_col\[1\].pe__2564_/A1 g_row\[1\].g_col\[1\].pe__2568_/A2
+ g_row\[1\].g_col\[1\].pe__2568_/B1 g_row\[1\].g_col\[1\].pe__2563_/X VGND VGND VPWR
+ VPWR g_row\[1\].g_col\[1\].pe__2564_/X sky130_fd_sc_hd__a22o_2
XFILLER_68_642 VGND VGND VPWR VPWR sky130_fd_sc_hd__fill_2
Xg_row\[1\].g_col\[1\].pe__1515_ g_row\[1\].g_col\[1\].pe__1490_/A g_row\[1\].g_col\[1\].pe__1490_/B
+ g_row\[1\].g_col\[1\].pe__1514_/X VGND VGND VPWR VPWR g_row\[1\].g_col\[1\].pe__1584_/A
+ sky130_fd_sc_hd__a21oi_2
Xg_row\[1\].g_col\[0\].pe__2548_ g_row\[1\].g_col\[0\].pe__2548_/A1 g_row\[1\].g_col\[0\].pe__2560_/A2
+ g_row\[1\].g_col\[0\].pe__2560_/B1 g_row\[1\].g_col\[0\].pe__2547_/X VGND VGND VPWR
+ VPWR g_row\[1\].g_col\[0\].pe__2548_/X sky130_fd_sc_hd__a22o_2
XFILLER_55_314 VGND VGND VPWR VPWR sky130_fd_sc_hd__fill_1
Xg_row\[1\].g_col\[1\].pe__2495_ g_row\[1\].g_col\[1\].pe__2495_/A VGND VGND VPWR
+ VPWR g_row\[1\].g_col\[1\].pe__2496_/A sky130_fd_sc_hd__inv_2
Xg_row\[1\].g_col\[0\].pe__2479_ g_row\[1\].g_col\[0\].pe__2579_/B g_row\[1\].g_col\[0\].pe__2579_/C
+ g_row\[1\].g_col\[0\].pe__2579_/A VGND VGND VPWR VPWR g_row\[1\].g_col\[0\].pe__2479_/X
+ sky130_fd_sc_hd__a21o_2
Xg_row\[0\].g_col\[1\].pe_hold2117 g_row\[0\].g_col\[1\].pe_hold3121/X VGND VGND VPWR
+ VPWR g_row\[0\].g_col\[1\].pe__2681_/A1 sky130_fd_sc_hd__clkbuf_2
Xg_row\[0\].g_col\[1\].pe__2711_ _327_/CLK g_row\[0\].g_col\[1\].pe__2711_/D VGND
+ VGND VPWR VPWR hold2990/A sky130_fd_sc_hd__dfxtp_2
Xg_row\[0\].g_col\[1\].pe_hold2128 ANTENNA_169/DIODE VGND VGND VPWR VPWR g_row\[0\].g_col\[1\].pe__2672_/B
+ sky130_fd_sc_hd__clkbuf_2
XFILLER_24_701 VGND VGND VPWR VPWR sky130_fd_sc_hd__decap_3
XFILLER_55_369 VGND VGND VPWR VPWR sky130_fd_sc_hd__decap_3
Xg_row\[0\].g_col\[0\].pe__2626_ g_row\[0\].g_col\[0\].pe__2628_/A1 g_row\[0\].g_col\[0\].pe__2626_/A2
+ g_row\[0\].g_col\[0\].pe__2628_/B1 g_row\[0\].g_col\[0\].pe__2625_/X VGND VGND VPWR
+ VPWR g_row\[0\].g_col\[0\].pe__2626_/X sky130_fd_sc_hd__o211a_2
Xg_row\[1\].g_col\[1\].pe_place1242 g_row\[1\].g_col\[1\].pe__2404_/A1 VGND VGND VPWR
+ VPWR g_row\[1\].g_col\[1\].pe__2334_/A1 sky130_fd_sc_hd__buf_6
Xg_row\[1\].g_col\[1\].pe__1377_ hold1640/X VGND VGND VPWR VPWR g_row\[1\].g_col\[1\].pe__2595_/A
+ sky130_fd_sc_hd__inv_2
Xg_row\[0\].g_col\[1\].pe__2642_ g_row\[0\].g_col\[1\].pe__2668_/A1 g_row\[0\].g_col\[1\].pe__2681_/A1
+ g_row\[0\].g_col\[1\].pe__2670_/B1 g_row\[0\].g_col\[1\].pe__2641_/X VGND VGND VPWR
+ VPWR g_row\[0\].g_col\[1\].pe__2642_/X sky130_fd_sc_hd__o211a_2
XFILLER_36_583 VGND VGND VPWR VPWR sky130_fd_sc_hd__decap_3
XFILLER_63_391 VGND VGND VPWR VPWR sky130_fd_sc_hd__fill_1
Xg_row\[0\].g_col\[1\].pe__2573_ g_row\[0\].g_col\[1\].pe__2595_/A g_row\[0\].g_col\[1\].pe__2573_/B
+ VGND VGND VPWR VPWR g_row\[0\].g_col\[1\].pe__2766_/D sky130_fd_sc_hd__and2_2
Xg_row\[0\].g_col\[0\].pe__2557_ g_row\[0\].g_col\[0\].pe__2551_/A g_row\[0\].g_col\[0\].pe__2551_/B
+ g_row\[0\].g_col\[0\].pe__2551_/C g_row\[0\].g_col\[0\].pe__2444_/A VGND VGND VPWR
+ VPWR g_row\[0\].g_col\[0\].pe__2558_/A sky130_fd_sc_hd__a31o_2
Xg_row\[0\].g_col\[1\].pe__1524_ g_row\[0\].g_col\[1\].pe__1584_/A g_row\[0\].g_col\[1\].pe__1584_/B
+ VGND VGND VPWR VPWR g_row\[0\].g_col\[1\].pe__1533_/A sky130_fd_sc_hd__xor2_2
XFILLER_51_597 VGND VGND VPWR VPWR sky130_fd_sc_hd__decap_3
Xg_row\[0\].g_col\[0\].pe__1508_ g_row\[0\].g_col\[0\].pe__1478_/A g_row\[0\].g_col\[0\].pe__1478_/B
+ g_row\[0\].g_col\[0\].pe__1507_/X VGND VGND VPWR VPWR g_row\[0\].g_col\[0\].pe__1549_/C
+ sky130_fd_sc_hd__a21o_2
Xg_row\[0\].g_col\[0\].pe__2488_ g_row\[0\].g_col\[0\].pe__2579_/C g_row\[0\].g_col\[0\].pe__2488_/B
+ VGND VGND VPWR VPWR g_row\[0\].g_col\[0\].pe__2575_/A sky130_fd_sc_hd__and2_2
Xg_row\[0\].g_col\[1\].pe__1386_ g_row\[0\].g_col\[1\].pe__1386_/A1 g_row\[0\].g_col\[1\].pe__2678_/A
+ g_row\[0\].g_col\[1\].pe__1385_/X g_row\[0\].g_col\[1\].pe__2670_/B1 VGND VGND VPWR
+ VPWR g_row\[0\].g_col\[1\].pe__1386_/X sky130_fd_sc_hd__o211a_2
XFILLER_3_605 VGND VGND VPWR VPWR sky130_fd_sc_hd__fill_2
XFILLER_3_627 VGND VGND VPWR VPWR sky130_fd_sc_hd__decap_3
Xg_row\[0\].g_col\[0\].pe_place868 g_row\[0\].g_col\[0\].pe__1504_/Y VGND VGND VPWR
+ VPWR g_row\[0\].g_col\[0\].pe__2279_/A2 sky130_fd_sc_hd__buf_6
XTAP_TAPCELL_ROW_57_1063 VGND VPWR sky130_fd_sc_hd__tapvpwrvgnd_1
Xg_row\[0\].g_col\[1\].pe__2007_ g_row\[0\].g_col\[1\].pe__2009_/C g_row\[0\].g_col\[1\].pe__2008_/A
+ g_row\[0\].g_col\[1\].pe__2151_/B VGND VGND VPWR VPWR g_row\[0\].g_col\[1\].pe__2010_/B
+ sky130_fd_sc_hd__and3b_2
XFILLER_59_620 VGND VGND VPWR VPWR sky130_fd_sc_hd__decap_3
XFILLER_78_428 VGND VGND VPWR VPWR sky130_fd_sc_hd__fill_1
XFILLER_58_141 VGND VGND VPWR VPWR sky130_fd_sc_hd__fill_1
XTAP_TAPCELL_ROW_70_1263 VGND VPWR sky130_fd_sc_hd__tapvpwrvgnd_1
XFILLER_19_528 VGND VGND VPWR VPWR sky130_fd_sc_hd__fill_2
XFILLER_59_686 VGND VGND VPWR VPWR sky130_fd_sc_hd__fill_1
XPHY_EDGE_ROW_45_Left_139 VGND VGND VPWR VPWR sky130_fd_sc_hd__decap_3
XFILLER_74_645 VGND VGND VPWR VPWR sky130_fd_sc_hd__decap_3
XFILLER_27_561 VGND VGND VPWR VPWR sky130_fd_sc_hd__decap_3
XFILLER_61_306 VGND VGND VPWR VPWR sky130_fd_sc_hd__fill_1
XFILLER_74_689 VGND VGND VPWR VPWR sky130_fd_sc_hd__decap_3
XFILLER_42_531 VGND VGND VPWR VPWR sky130_fd_sc_hd__fill_1
XFILLER_9_27 VGND VGND VPWR VPWR sky130_fd_sc_hd__decap_3
Xg_row\[0\].g_col\[1\].pe_hold1972 g_row\[0\].g_col\[1\].pe__1395_/X VGND VGND VPWR
+ VPWR g_row\[0\].g_col\[1\].pe__2733_/D sky130_fd_sc_hd__clkbuf_2
X_324_ _324_/CLK _324_/D VGND VGND VPWR VPWR _324_/Q sky130_fd_sc_hd__dfxtp_2
XPHY_EDGE_ROW_54_Left_148 VGND VGND VPWR VPWR sky130_fd_sc_hd__decap_3
X_255_ _267_/A _255_/B_N VGND VGND VPWR VPWR _255_/Y sky130_fd_sc_hd__nor2b_4
Xg_row\[1\].g_col\[0\].pe__1850_ g_row\[1\].g_col\[0\].pe__1850_/A g_row\[1\].g_col\[0\].pe__1850_/B
+ VGND VGND VPWR VPWR g_row\[1\].g_col\[0\].pe__1886_/A sky130_fd_sc_hd__nor2_2
Xg_row\[1\].g_col\[0\].pe__1781_ g_row\[1\].g_col\[0\].pe__1781_/A g_row\[1\].g_col\[0\].pe__1781_/B
+ VGND VGND VPWR VPWR g_row\[1\].g_col\[0\].pe__1791_/A sky130_fd_sc_hd__xnor2_2
XPHY_EDGE_ROW_63_Left_157 VGND VGND VPWR VPWR sky130_fd_sc_hd__decap_3
Xg_row\[1\].g_col\[0\].pe__2402_ place1268/X g_row\[1\].g_col\[0\].pe__2402_/B VGND
+ VGND VPWR VPWR g_row\[1\].g_col\[0\].pe__2754_/D sky130_fd_sc_hd__nor2_2
XFILLER_49_174 VGND VGND VPWR VPWR sky130_fd_sc_hd__fill_1
XFILLER_65_601 VGND VGND VPWR VPWR sky130_fd_sc_hd__decap_3
XTAP_TAPCELL_ROW_88_1524 VGND VPWR sky130_fd_sc_hd__tapvpwrvgnd_1
Xg_row\[0\].g_col\[0\].pe__1790_ g_row\[0\].g_col\[0\].pe__1795_/B g_row\[0\].g_col\[0\].pe__1790_/B
+ VGND VGND VPWR VPWR g_row\[0\].g_col\[0\].pe__1811_/A sky130_fd_sc_hd__nand2_2
Xg_row\[1\].g_col\[0\].pe__2333_ g_row\[1\].g_col\[0\].pe__2330_/X g_row\[1\].g_col\[0\].pe__2329_/B
+ g_row\[1\].g_col\[0\].pe__2358_/A g_row\[1\].g_col\[0\].pe__2157_/A VGND VGND VPWR
+ VPWR g_row\[1\].g_col\[0\].pe__2333_/Y sky130_fd_sc_hd__o211ai_2
XFILLER_49_185 VGND VGND VPWR VPWR sky130_fd_sc_hd__decap_3
XTAP_TAPCELL_ROW_88_1535 VGND VPWR sky130_fd_sc_hd__tapvpwrvgnd_1
Xg_row\[1\].g_col\[1\].pe__2280_ g_row\[1\].g_col\[1\].pe__2364_/A g_row\[1\].g_col\[1\].pe__2280_/B
+ VGND VGND VPWR VPWR g_row\[1\].g_col\[1\].pe__2311_/B sky130_fd_sc_hd__xnor2_2
Xg_row\[1\].g_col\[0\].pe__2264_ g_row\[1\].g_col\[0\].pe__2238_/X g_row\[1\].g_col\[0\].pe__2234_/Y
+ g_row\[1\].g_col\[0\].pe__2263_/X g_row\[1\].g_col\[0\].pe__2157_/A VGND VGND VPWR
+ VPWR g_row\[1\].g_col\[0\].pe__2264_/X sky130_fd_sc_hd__o31a_2
XFILLER_52_306 VGND VGND VPWR VPWR sky130_fd_sc_hd__fill_2
Xg_row\[0\].g_col\[0\].pe__2411_ g_row\[0\].g_col\[0\].pe__2740_/Q g_row\[0\].g_col\[0\].pe__2739_/Q
+ g_row\[0\].g_col\[0\].pe__2754_/Q VGND VGND VPWR VPWR g_row\[0\].g_col\[0\].pe__2455_/B
+ sky130_fd_sc_hd__o21ba_2
Xg_row\[1\].g_col\[0\].pe_place1105 place1106/A VGND VGND VPWR VPWR g_row\[1\].g_col\[0\].pe__2599_/B
+ sky130_fd_sc_hd__buf_6
Xg_row\[1\].g_col\[0\].pe__2195_ g_row\[1\].g_col\[0\].pe__2231_/A g_row\[1\].g_col\[0\].pe__2231_/B
+ VGND VGND VPWR VPWR g_row\[1\].g_col\[0\].pe__2200_/B sky130_fd_sc_hd__xnor2_2
XFILLER_33_542 VGND VGND VPWR VPWR sky130_fd_sc_hd__decap_3
Xg_row\[0\].g_col\[0\].pe_hold3041 _317_/Q VGND VGND VPWR VPWR g_row\[0\].g_col\[0\].pe_hold3041/X
+ sky130_fd_sc_hd__clkbuf_2
Xg_row\[0\].g_col\[0\].pe_hold3052 g_row\[0\].g_col\[0\].pe__2674_/D VGND VGND VPWR
+ VPWR g_row\[0\].g_col\[0\].pe__2654_/A2 sky130_fd_sc_hd__clkbuf_2
XPHY_EDGE_ROW_72_Left_166 VGND VGND VPWR VPWR sky130_fd_sc_hd__decap_3
Xg_row\[0\].g_col\[0\].pe__2342_ g_row\[0\].g_col\[0\].pe__2388_/A g_row\[0\].g_col\[0\].pe__1540_/X
+ g_row\[0\].g_col\[0\].pe__2341_/Y g_row\[0\].g_col\[0\].pe__2736_/Q VGND VGND VPWR
+ VPWR g_row\[0\].g_col\[0\].pe__2365_/A sky130_fd_sc_hd__a22o_2
Xg_row\[0\].g_col\[0\].pe__2273_ g_row\[0\].g_col\[0\].pe__2273_/A g_row\[0\].g_col\[0\].pe__2273_/B
+ VGND VGND VPWR VPWR g_row\[0\].g_col\[0\].pe__2287_/A sky130_fd_sc_hd__or2_2
Xg_row\[0\].g_col\[1\].pe_place965 g_row\[0\].g_col\[1\].pe__1838_/A VGND VGND VPWR
+ VPWR g_row\[0\].g_col\[1\].pe__2624_/A1 sky130_fd_sc_hd__buf_6
Xg_row\[0\].g_col\[1\].pe_place954 g_row\[0\].g_col\[1\].pe__1982_/B VGND VGND VPWR
+ VPWR g_row\[0\].g_col\[1\].pe__1732_/A2 sky130_fd_sc_hd__buf_6
Xg_row\[0\].g_col\[1\].pe_place943 g_row\[0\].g_col\[1\].pe__2364_/A VGND VGND VPWR
+ VPWR g_row\[0\].g_col\[1\].pe__2179_/A sky130_fd_sc_hd__buf_6
Xg_row\[1\].g_col\[1\].pe__1995_ g_row\[1\].g_col\[1\].pe__1931_/A g_row\[1\].g_col\[1\].pe__1931_/B
+ g_row\[1\].g_col\[1\].pe__1994_/Y VGND VGND VPWR VPWR g_row\[1\].g_col\[1\].pe__2055_/B
+ sky130_fd_sc_hd__a21oi_2
Xg_row\[1\].g_col\[0\].pe__1979_ g_row\[1\].g_col\[0\].pe__1978_/A g_row\[1\].g_col\[0\].pe__1978_/B
+ g_row\[1\].g_col\[0\].pe__1978_/C VGND VGND VPWR VPWR g_row\[1\].g_col\[0\].pe__1991_/B
+ sky130_fd_sc_hd__o21ai_2
XPHY_EDGE_ROW_81_Left_175 VGND VGND VPWR VPWR sky130_fd_sc_hd__decap_3
Xhold3525 hold3525/A VGND VGND VPWR VPWR hold3525/X sky130_fd_sc_hd__clkbuf_2
Xhold3514 hold3514/A VGND VGND VPWR VPWR hold3514/X sky130_fd_sc_hd__clkbuf_2
Xhold3503 hold3503/A VGND VGND VPWR VPWR hold3503/X sky130_fd_sc_hd__clkbuf_2
Xhold2802 _261_/Y VGND VGND VPWR VPWR hold2802/X sky130_fd_sc_hd__clkbuf_2
Xhold2813 hold2813/A VGND VGND VPWR VPWR _203_/B_N sky130_fd_sc_hd__clkbuf_2
Xhold3558 hold3558/A VGND VGND VPWR VPWR hold3558/X sky130_fd_sc_hd__clkbuf_2
Xhold3547 a_inputs_flat[26] VGND VGND VPWR VPWR hold3547/X sky130_fd_sc_hd__clkbuf_2
Xhold3536 hold3536/A VGND VGND VPWR VPWR hold3536/X sky130_fd_sc_hd__clkbuf_2
Xg_row\[1\].g_col\[1\].pe__2616_ g_row\[1\].g_col\[1\].pe__2639_/A g_row\[1\].g_col\[1\].pe__2616_/B
+ VGND VGND VPWR VPWR g_row\[1\].g_col\[1\].pe__2616_/X sky130_fd_sc_hd__or2_2
Xhold3569 hold3569/A VGND VGND VPWR VPWR hold3569/X sky130_fd_sc_hd__clkbuf_2
Xg_row\[0\].g_col\[0\].pe__1988_ g_row\[0\].g_col\[0\].pe__2043_/A g_row\[0\].g_col\[0\].pe__1988_/B
+ g_row\[0\].g_col\[0\].pe__1988_/C VGND VGND VPWR VPWR g_row\[0\].g_col\[0\].pe__1988_/X
+ sky130_fd_sc_hd__and3b_4
Xg_row\[1\].g_col\[1\].pe__2547_ g_row\[1\].g_col\[1\].pe__2559_/A g_row\[1\].g_col\[1\].pe__2547_/B
+ g_row\[1\].g_col\[1\].pe__2546_/Y VGND VGND VPWR VPWR g_row\[1\].g_col\[1\].pe__2547_/X
+ sky130_fd_sc_hd__or3b_2
XFILLER_56_645 VGND VGND VPWR VPWR sky130_fd_sc_hd__fill_2
XFILLER_83_431 VGND VGND VPWR VPWR sky130_fd_sc_hd__fill_2
Xg_row\[1\].g_col\[1\].pe__2478_ g_row\[1\].g_col\[1\].pe__2478_/A g_row\[1\].g_col\[1\].pe__2478_/B
+ VGND VGND VPWR VPWR g_row\[1\].g_col\[1\].pe__2579_/A sky130_fd_sc_hd__xnor2_2
Xg_row\[1\].g_col\[1\].pe__1429_ g_row\[1\].g_col\[1\].pe__1650_/A g_row\[1\].g_col\[1\].pe__1650_/B
+ g_row\[1\].g_col\[1\].pe__1428_/X VGND VGND VPWR VPWR g_row\[1\].g_col\[1\].pe__1479_/A
+ sky130_fd_sc_hd__a21oi_2
XFILLER_55_199 VGND VGND VPWR VPWR sky130_fd_sc_hd__fill_2
Xg_row\[1\].g_col\[1\].pe_place1050 g_row\[1\].g_col\[1\].pe__2640_/C1 VGND VGND VPWR
+ VPWR g_row\[1\].g_col\[1\].pe__2666_/B1 sky130_fd_sc_hd__buf_6
Xg_row\[0\].g_col\[1\].pe__2625_ g_row\[0\].g_col\[1\].pe__2663_/A g_row\[0\].g_col\[1\].pe__2625_/B
+ VGND VGND VPWR VPWR g_row\[0\].g_col\[1\].pe__2625_/X sky130_fd_sc_hd__or2_2
XFILLER_12_704 VGND VGND VPWR VPWR sky130_fd_sc_hd__fill_1
XPHY_EDGE_ROW_90_Left_184 VGND VGND VPWR VPWR sky130_fd_sc_hd__decap_3
XFILLER_24_586 VGND VGND VPWR VPWR sky130_fd_sc_hd__fill_2
Xg_row\[0\].g_col\[1\].pe__1507_ g_row\[0\].g_col\[1\].pe__1507_/A g_row\[0\].g_col\[1\].pe__1507_/B
+ VGND VGND VPWR VPWR g_row\[0\].g_col\[1\].pe__1507_/X sky130_fd_sc_hd__and2_2
Xg_row\[0\].g_col\[1\].pe_place1148 g_row\[0\].g_col\[1\].pe__2698_/Q VGND VGND VPWR
+ VPWR g_row\[0\].g_col\[1\].pe__2177_/A1 sky130_fd_sc_hd__buf_6
Xg_row\[0\].g_col\[1\].pe_place1137 g_row\[0\].g_col\[1\].pe__2703_/Q VGND VGND VPWR
+ VPWR g_row\[0\].g_col\[1\].pe__2630_/B sky130_fd_sc_hd__buf_6
Xg_row\[0\].g_col\[1\].pe_place1126 g_row\[0\].g_col\[1\].pe__2728_/Q VGND VGND VPWR
+ VPWR g_row\[0\].g_col\[1\].pe__1624_/A sky130_fd_sc_hd__buf_6
Xg_row\[0\].g_col\[1\].pe__2487_ g_row\[0\].g_col\[1\].pe__2487_/A g_row\[0\].g_col\[1\].pe__2487_/B
+ g_row\[0\].g_col\[1\].pe__2490_/A VGND VGND VPWR VPWR g_row\[0\].g_col\[1\].pe__2488_/B
+ sky130_fd_sc_hd__or3_2
Xclkload1 clkload1/A VGND VGND VPWR VPWR clkload1/X sky130_fd_sc_hd__clkbuf_16
Xg_row\[0\].g_col\[1\].pe__1438_ g_row\[0\].g_col\[1\].pe__1481_/A g_row\[0\].g_col\[1\].pe__1481_/B
+ VGND VGND VPWR VPWR g_row\[0\].g_col\[1\].pe__1442_/A sky130_fd_sc_hd__xor2_2
Xg_row\[0\].g_col\[1\].pe_place1159 g_row\[0\].g_col\[1\].pe_hold2365/X VGND VGND
+ VPWR VPWR g_row\[0\].g_col\[1\].pe__2605_/B sky130_fd_sc_hd__buf_6
Xg_row\[0\].g_col\[1\].pe__1369_ g_row\[0\].g_col\[1\].pe__2770_/Q VGND VGND VPWR
+ VPWR g_row\[0\].g_col\[1\].pe__2424_/A sky130_fd_sc_hd__inv_2
XFILLER_1_3 VGND VGND VPWR VPWR sky130_fd_sc_hd__decap_3
XPHY_EDGE_ROW_3_Left_97 VGND VGND VPWR VPWR sky130_fd_sc_hd__decap_3
XTAP_TAPCELL_ROW_6_295 VGND VPWR sky130_fd_sc_hd__tapvpwrvgnd_1
XFILLER_46_111 VGND VGND VPWR VPWR sky130_fd_sc_hd__fill_2
XFILLER_46_122 VGND VGND VPWR VPWR sky130_fd_sc_hd__fill_1
XFILLER_47_667 VGND VGND VPWR VPWR sky130_fd_sc_hd__decap_3
XFILLER_62_615 VGND VGND VPWR VPWR sky130_fd_sc_hd__decap_3
XFILLER_74_475 VGND VGND VPWR VPWR sky130_fd_sc_hd__fill_1
XTAP_TAPCELL_ROW_45_879 VGND VPWR sky130_fd_sc_hd__tapvpwrvgnd_1
XTAP_TAPCELL_ROW_83_1454 VGND VPWR sky130_fd_sc_hd__tapvpwrvgnd_1
XFILLER_30_501 VGND VGND VPWR VPWR sky130_fd_sc_hd__fill_1
XFILLER_30_545 VGND VGND VPWR VPWR sky130_fd_sc_hd__decap_3
XTAP_TAPCELL_ROW_25_581 VGND VPWR sky130_fd_sc_hd__tapvpwrvgnd_1
XTAP_TAPCELL_ROW_25_592 VGND VPWR sky130_fd_sc_hd__tapvpwrvgnd_1
X_307_ _307_/CLK _307_/D VGND VGND VPWR VPWR _307_/Q sky130_fd_sc_hd__dfxtp_2
XFILLER_30_589 VGND VGND VPWR VPWR sky130_fd_sc_hd__decap_3
Xg_row\[1\].g_col\[0\].pe__1902_ g_row\[1\].g_col\[0\].pe__2612_/B g_row\[1\].g_col\[0\].pe__1504_/Y
+ g_row\[1\].g_col\[0\].pe__2074_/B1 place1098/A VGND VGND VPWR VPWR g_row\[1\].g_col\[0\].pe__1903_/B
+ sky130_fd_sc_hd__a22o_2
XFILLER_7_785 VGND VGND VPWR VPWR sky130_fd_sc_hd__decap_3
X_169_ _173_/A _169_/B_N VGND VGND VPWR VPWR _169_/Y sky130_fd_sc_hd__nor2b_4
Xg_row\[1\].g_col\[0\].pe__1833_ g_row\[1\].g_col\[0\].pe__1702_/X g_row\[1\].g_col\[0\].pe__1829_/Y
+ g_row\[1\].g_col\[0\].pe__1832_/Y VGND VGND VPWR VPWR g_row\[1\].g_col\[0\].pe__1834_/B
+ sky130_fd_sc_hd__a21oi_2
Xg_row\[1\].g_col\[1\].pe__1780_ g_row\[1\].g_col\[1\].pe__1780_/A g_row\[1\].g_col\[1\].pe__1794_/A
+ VGND VGND VPWR VPWR g_row\[1\].g_col\[1\].pe__1780_/Y sky130_fd_sc_hd__nor2_2
Xg_row\[1\].g_col\[0\].pe__1764_ g_row\[1\].g_col\[0\].pe__1785_/A g_row\[1\].g_col\[0\].pe__1764_/B
+ VGND VGND VPWR VPWR g_row\[1\].g_col\[0\].pe__1766_/B sky130_fd_sc_hd__xor2_2
XFILLER_34_3 VGND VGND VPWR VPWR sky130_fd_sc_hd__fill_1
Xg_row\[1\].g_col\[0\].pe__1695_ g_row\[1\].g_col\[0\].pe__1695_/A g_row\[1\].g_col\[0\].pe__1695_/B
+ VGND VGND VPWR VPWR g_row\[1\].g_col\[0\].pe__1695_/X sky130_fd_sc_hd__and2_2
XFILLER_69_247 VGND VGND VPWR VPWR sky130_fd_sc_hd__decap_3
XFILLER_85_707 VGND VGND VPWR VPWR sky130_fd_sc_hd__fill_2
Xg_row\[0\].g_col\[0\].pe__1911_ hold2339/A g_row\[0\].g_col\[0\].pe__2163_/B g_row\[0\].g_col\[0\].pe__1461_/Y
+ g_row\[0\].g_col\[0\].pe__2215_/B2 VGND VGND VPWR VPWR g_row\[0\].g_col\[0\].pe__1912_/B
+ sky130_fd_sc_hd__a22o_2
XFILLER_78_781 VGND VGND VPWR VPWR sky130_fd_sc_hd__decap_3
XFILLER_85_729 VGND VGND VPWR VPWR sky130_fd_sc_hd__fill_2
Xg_row\[0\].g_col\[0\].pe__1842_ g_row\[0\].g_col\[0\].pe__1702_/X g_row\[0\].g_col\[0\].pe__1829_/Y
+ g_row\[0\].g_col\[0\].pe__1834_/A g_row\[0\].g_col\[0\].pe__1832_/Y VGND VGND VPWR
+ VPWR g_row\[0\].g_col\[0\].pe__1843_/B sky130_fd_sc_hd__a211o_2
Xg_row\[1\].g_col\[1\].pe__2401_ g_row\[1\].g_col\[1\].pe__2010_/A g_row\[1\].g_col\[1\].pe__2401_/A2
+ g_row\[1\].g_col\[1\].pe__2398_/X g_row\[1\].g_col\[1\].pe__2399_/Y g_row\[1\].g_col\[1\].pe__2404_/A1
+ VGND VGND VPWR VPWR g_row\[1\].g_col\[1\].pe__2401_/X sky130_fd_sc_hd__o32a_2
Xg_row\[1\].g_col\[1\].pe__2332_ g_row\[1\].g_col\[1\].pe__2304_/A g_row\[1\].g_col\[1\].pe__2304_/B
+ g_row\[1\].g_col\[1\].pe__2304_/C g_row\[1\].g_col\[1\].pe__2329_/Y g_row\[1\].g_col\[1\].pe__2305_/A
+ VGND VGND VPWR VPWR g_row\[1\].g_col\[1\].pe__2358_/A sky130_fd_sc_hd__a311o_4
XFILLER_26_818 VGND VGND VPWR VPWR sky130_fd_sc_hd__fill_1
Xg_row\[0\].g_col\[0\].pe__1773_ g_row\[0\].g_col\[0\].pe__1816_/A g_row\[0\].g_col\[0\].pe__1816_/B
+ VGND VGND VPWR VPWR g_row\[0\].g_col\[0\].pe__1778_/A sky130_fd_sc_hd__nand2_2
Xg_row\[1\].g_col\[0\].pe__2316_ g_row\[1\].g_col\[0\].pe__2316_/A g_row\[1\].g_col\[0\].pe__2316_/B
+ VGND VGND VPWR VPWR g_row\[1\].g_col\[0\].pe__2317_/B sky130_fd_sc_hd__nor2_2
Xg_row\[1\].g_col\[1\].pe__2263_ g_row\[1\].g_col\[1\].pe__2261_/Y g_row\[1\].g_col\[1\].pe__2263_/B
+ VGND VGND VPWR VPWR g_row\[1\].g_col\[1\].pe__2263_/X sky130_fd_sc_hd__and2b_2
Xg_row\[1\].g_col\[0\].pe__2247_ g_row\[1\].g_col\[0\].pe__2388_/A g_row\[1\].g_col\[0\].pe__1471_/X
+ g_row\[1\].g_col\[0\].pe__1474_/Y g_row\[1\].g_col\[0\].pe__2121_/A VGND VGND VPWR
+ VPWR g_row\[1\].g_col\[0\].pe__2248_/B sky130_fd_sc_hd__a22o_2
Xg_row\[1\].g_col\[1\].pe__2194_ g_row\[1\].g_col\[1\].pe__2202_/A g_row\[1\].g_col\[1\].pe__2202_/B
+ VGND VGND VPWR VPWR g_row\[1\].g_col\[1\].pe__2231_/B sky130_fd_sc_hd__xor2_2
Xg_row\[1\].g_col\[0\].pe__2178_ place1086/A g_row\[1\].g_col\[0\].pe__1549_/B g_row\[1\].g_col\[0\].pe__1541_/X
+ g_row\[1\].g_col\[0\].pe__2241_/B2 VGND VGND VPWR VPWR g_row\[1\].g_col\[0\].pe__2179_/B
+ sky130_fd_sc_hd__a22o_2
Xg_row\[0\].g_col\[1\].pe__2410_ g_row\[0\].g_col\[1\].pe__2775_/A g_row\[0\].g_col\[1\].pe__2410_/B
+ VGND VGND VPWR VPWR g_row\[0\].g_col\[1\].pe__2499_/A sky130_fd_sc_hd__and2_2
XFILLER_21_556 VGND VGND VPWR VPWR sky130_fd_sc_hd__decap_3
Xg_row\[0\].g_col\[0\].pe__2325_ g_row\[0\].g_col\[0\].pe__2325_/A g_row\[0\].g_col\[0\].pe__2338_/A
+ VGND VGND VPWR VPWR g_row\[0\].g_col\[0\].pe__2327_/C sky130_fd_sc_hd__xnor2_2
Xg_row\[0\].g_col\[1\].pe__2341_ g_row\[0\].g_col\[1\].pe__2632_/B g_row\[0\].g_col\[1\].pe__2341_/B
+ VGND VGND VPWR VPWR g_row\[0\].g_col\[1\].pe__2341_/Y sky130_fd_sc_hd__nand2_2
Xinput1318 hold3329/X VGND VGND VPWR VPWR hold3330/A sky130_fd_sc_hd__buf_2
Xinput1307 hold3586/X VGND VGND VPWR VPWR hold3587/A sky130_fd_sc_hd__buf_2
Xg_row\[0\].g_col\[1\].pe__2272_ g_row\[0\].g_col\[1\].pe__2257_/A g_row\[0\].g_col\[1\].pe__2272_/B
+ VGND VGND VPWR VPWR g_row\[0\].g_col\[1\].pe__2295_/B sky130_fd_sc_hd__and2b_2
Xg_row\[0\].g_col\[0\].pe__2256_ g_row\[0\].g_col\[0\].pe__2213_/A g_row\[0\].g_col\[0\].pe__2213_/B
+ g_row\[0\].g_col\[0\].pe__2220_/B g_row\[0\].g_col\[0\].pe__2219_/B g_row\[0\].g_col\[0\].pe__2219_/A
+ VGND VGND VPWR VPWR g_row\[0\].g_col\[0\].pe__2272_/B sky130_fd_sc_hd__a32o_2
Xinput1329 hold3364/X VGND VGND VPWR VPWR hold3365/A sky130_fd_sc_hd__buf_2
Xg_row\[0\].g_col\[0\].pe__2187_ g_row\[0\].g_col\[0\].pe__2142_/A g_row\[0\].g_col\[0\].pe__2187_/B
+ VGND VGND VPWR VPWR g_row\[0\].g_col\[0\].pe__2187_/X sky130_fd_sc_hd__and2b_2
Xhold3300 hold3300/A VGND VGND VPWR VPWR hold3300/X sky130_fd_sc_hd__clkbuf_2
Xg_row\[1\].g_col\[1\].pe_hold1928 g_row\[1\].g_col\[1\].pe__2618_/X VGND VGND VPWR
+ VPWR g_row\[1\].g_col\[1\].pe__2619_/C1 sky130_fd_sc_hd__clkbuf_2
Xg_row\[1\].g_col\[1\].pe__1978_ g_row\[1\].g_col\[1\].pe__1978_/A g_row\[1\].g_col\[1\].pe__1978_/B
+ g_row\[1\].g_col\[1\].pe__1978_/C VGND VGND VPWR VPWR g_row\[1\].g_col\[1\].pe__1991_/A
+ sky130_fd_sc_hd__or3_4
XTAP_TAPCELL_ROW_54_1022 VGND VPWR sky130_fd_sc_hd__tapvpwrvgnd_1
Xhold3311 hold3311/A VGND VGND VPWR VPWR hold3311/X sky130_fd_sc_hd__clkbuf_2
Xhold3322 hold3322/A VGND VGND VPWR VPWR hold3322/X sky130_fd_sc_hd__clkbuf_2
Xhold3333 a_inputs_flat[12] VGND VGND VPWR VPWR hold3333/X sky130_fd_sc_hd__clkbuf_2
Xg_row\[1\].g_col\[1\].pe_hold1939 g_row\[1\].g_col\[1\].pe__2626_/X VGND VGND VPWR
+ VPWR g_row\[1\].g_col\[1\].pe__2701_/D sky130_fd_sc_hd__clkbuf_2
XFILLER_0_449 VGND VGND VPWR VPWR sky130_fd_sc_hd__decap_3
Xhold2610 _209_/Y VGND VGND VPWR VPWR hold2610/X sky130_fd_sc_hd__clkbuf_2
Xhold2621 hold3402/X VGND VGND VPWR VPWR _229_/B_N sky130_fd_sc_hd__clkbuf_2
Xhold3344 hold3344/A VGND VGND VPWR VPWR hold3344/X sky130_fd_sc_hd__clkbuf_2
Xhold3355 hold3355/A VGND VGND VPWR VPWR hold3355/X sky130_fd_sc_hd__clkbuf_2
Xhold3366 hold3366/A VGND VGND VPWR VPWR hold3366/X sky130_fd_sc_hd__clkbuf_2
XFILLER_29_57 VGND VGND VPWR VPWR sky130_fd_sc_hd__fill_2
XFILLER_88_589 VGND VGND VPWR VPWR sky130_fd_sc_hd__fill_2
Xhold2632 hold3351/X VGND VGND VPWR VPWR hold3352/A sky130_fd_sc_hd__clkbuf_2
Xhold2643 hold3447/X VGND VGND VPWR VPWR hold3448/A sky130_fd_sc_hd__clkbuf_2
Xhold2654 hold3382/X VGND VGND VPWR VPWR hold3383/A sky130_fd_sc_hd__clkbuf_2
Xhold2665 hold2665/A VGND VGND VPWR VPWR _311_/D sky130_fd_sc_hd__clkbuf_2
Xhold3377 hold3377/A VGND VGND VPWR VPWR hold3377/X sky130_fd_sc_hd__clkbuf_2
Xhold3388 hold3388/A VGND VGND VPWR VPWR hold3388/X sky130_fd_sc_hd__clkbuf_2
Xhold3399 hold3399/A VGND VGND VPWR VPWR hold3399/X sky130_fd_sc_hd__clkbuf_2
XFILLER_29_656 VGND VGND VPWR VPWR sky130_fd_sc_hd__fill_2
Xhold2676 _215_/Y VGND VGND VPWR VPWR hold2676/X sky130_fd_sc_hd__clkbuf_2
Xhold2687 hold3444/X VGND VGND VPWR VPWR _179_/B_N sky130_fd_sc_hd__clkbuf_2
Xhold2698 hold3477/X VGND VGND VPWR VPWR hold3478/A sky130_fd_sc_hd__clkbuf_2
Xg_row\[0\].g_col\[1\].pe__1987_ g_row\[0\].g_col\[1\].pe__1988_/B g_row\[0\].g_col\[1\].pe__1988_/C
+ g_row\[0\].g_col\[1\].pe__2043_/A VGND VGND VPWR VPWR g_row\[0\].g_col\[1\].pe__1987_/Y
+ sky130_fd_sc_hd__a21boi_2
XTAP_TAPCELL_ROW_3_254 VGND VPWR sky130_fd_sc_hd__tapvpwrvgnd_1
Xhold1986 hold1986/A VGND VGND VPWR VPWR hold1986/X sky130_fd_sc_hd__clkbuf_2
XFILLER_44_637 VGND VGND VPWR VPWR sky130_fd_sc_hd__fill_1
XTAP_TAPCELL_ROW_42_838 VGND VPWR sky130_fd_sc_hd__tapvpwrvgnd_1
Xg_row\[0\].g_col\[1\].pe__2608_ g_row\[0\].g_col\[1\].pe__1838_/A place1216/X g_row\[0\].g_col\[1\].pe__2381_/A
+ g_row\[0\].g_col\[1\].pe__2608_/C1 VGND VGND VPWR VPWR g_row\[0\].g_col\[1\].pe__2608_/X
+ sky130_fd_sc_hd__o211a_2
XTAP_TAPCELL_ROW_65_1184 VGND VPWR sky130_fd_sc_hd__tapvpwrvgnd_1
Xg_row\[0\].g_col\[1\].pe__2539_ g_row\[0\].g_col\[1\].pe__2538_/B g_row\[0\].g_col\[1\].pe__2538_/C
+ g_row\[0\].g_col\[1\].pe__2538_/A VGND VGND VPWR VPWR g_row\[0\].g_col\[1\].pe__2539_/X
+ sky130_fd_sc_hd__a21o_2
XFILLER_12_578 VGND VGND VPWR VPWR sky130_fd_sc_hd__decap_3
XFILLER_12_589 VGND VGND VPWR VPWR sky130_fd_sc_hd__decap_3
XTAP_TAPCELL_ROW_22_540 VGND VPWR sky130_fd_sc_hd__tapvpwrvgnd_1
XFILLER_6_39 VGND VGND VPWR VPWR sky130_fd_sc_hd__fill_2
XFILLER_4_733 VGND VGND VPWR VPWR sky130_fd_sc_hd__fill_2
XFILLER_3_221 VGND VGND VPWR VPWR sky130_fd_sc_hd__decap_3
XFILLER_79_567 VGND VGND VPWR VPWR sky130_fd_sc_hd__decap_3
Xg_row\[1\].g_col\[0\].pe__1480_ g_row\[1\].g_col\[0\].pe__1662_/A g_row\[1\].g_col\[0\].pe__1662_/B
+ g_row\[1\].g_col\[0\].pe__1479_/Y VGND VGND VPWR VPWR g_row\[1\].g_col\[0\].pe__1501_/A
+ sky130_fd_sc_hd__a21oi_2
XFILLER_86_85 VGND VGND VPWR VPWR sky130_fd_sc_hd__fill_2
XFILLER_35_648 VGND VGND VPWR VPWR sky130_fd_sc_hd__decap_3
XFILLER_74_261 VGND VGND VPWR VPWR sky130_fd_sc_hd__fill_1
Xg_row\[1\].g_col\[0\].pe__2101_ g_row\[1\].g_col\[0\].pe__2101_/A g_row\[1\].g_col\[0\].pe__2145_/A
+ g_row\[1\].g_col\[0\].pe__2101_/C VGND VGND VPWR VPWR g_row\[1\].g_col\[0\].pe__2104_/A
+ sky130_fd_sc_hd__or3_4
XFILLER_90_765 VGND VGND VPWR VPWR sky130_fd_sc_hd__fill_2
Xg_row\[1\].g_col\[0\].pe__2032_ g_row\[1\].g_col\[0\].pe__2085_/A g_row\[1\].g_col\[0\].pe__2032_/B
+ g_row\[1\].g_col\[0\].pe__2032_/C VGND VGND VPWR VPWR g_row\[1\].g_col\[0\].pe__2034_/C
+ sky130_fd_sc_hd__nand3_2
Xg_row\[0\].g_col\[0\].pe__2110_ g_row\[0\].g_col\[0\].pe__2110_/A g_row\[0\].g_col\[0\].pe__2110_/B
+ VGND VGND VPWR VPWR g_row\[0\].g_col\[0\].pe__2153_/C sky130_fd_sc_hd__or2_2
Xg_row\[0\].g_col\[0\].pe__2041_ g_row\[0\].g_col\[0\].pe__2094_/A g_row\[0\].g_col\[0\].pe__2040_/X
+ g_row\[0\].g_col\[0\].pe__1424_/A g_row\[0\].g_col\[0\].pe__2125_/A VGND VGND VPWR
+ VPWR g_row\[0\].g_col\[0\].pe__2043_/B sky130_fd_sc_hd__o2bb2a_2
Xg_row\[1\].g_col\[1\].pe__1901_ g_row\[1\].g_col\[1\].pe__1957_/B2 g_row\[1\].g_col\[1\].pe__2177_/A2
+ g_row\[1\].g_col\[1\].pe__2177_/B1 g_row\[1\].g_col\[1\].pe__1901_/B2 VGND VGND
+ VPWR VPWR g_row\[1\].g_col\[1\].pe__1905_/A sky130_fd_sc_hd__a22o_2
Xplace1204 hold2339/X VGND VGND VPWR VPWR place1204/X sky130_fd_sc_hd__buf_6
Xg_row\[1\].g_col\[1\].pe__1832_ g_row\[1\].g_col\[1\].pe__1840_/A g_row\[1\].g_col\[1\].pe__1832_/B
+ g_row\[1\].g_col\[1\].pe__1832_/C VGND VGND VPWR VPWR g_row\[1\].g_col\[1\].pe__1832_/Y
+ sky130_fd_sc_hd__nand3_2
Xplace1248 place1249/X VGND VGND VPWR VPWR place1248/X sky130_fd_sc_hd__buf_6
Xg_row\[1\].g_col\[0\].pe__1816_ g_row\[1\].g_col\[0\].pe__1816_/A g_row\[1\].g_col\[0\].pe__1816_/B
+ g_row\[1\].g_col\[0\].pe__1816_/C VGND VGND VPWR VPWR g_row\[1\].g_col\[0\].pe__1816_/X
+ sky130_fd_sc_hd__and3_2
Xg_row\[1\].g_col\[1\].pe__1763_ g_row\[1\].g_col\[1\].pe__2691_/Q g_row\[1\].g_col\[1\].pe__1414_/X
+ g_row\[1\].g_col\[1\].pe__1415_/Y g_row\[1\].g_col\[1\].pe__1801_/B g_row\[1\].g_col\[1\].pe__2692_/Q
+ VGND VGND VPWR VPWR g_row\[1\].g_col\[1\].pe__1764_/B sky130_fd_sc_hd__a32o_2
Xg_row\[1\].g_col\[0\].pe__1747_ g_row\[1\].g_col\[0\].pe__1747_/A g_row\[1\].g_col\[0\].pe__1820_/B
+ VGND VGND VPWR VPWR g_row\[1\].g_col\[0\].pe__1822_/C sky130_fd_sc_hd__or2_2
Xg_row\[1\].g_col\[1\].pe__1694_ g_row\[1\].g_col\[1\].pe__1695_/A g_row\[1\].g_col\[1\].pe__1695_/B
+ VGND VGND VPWR VPWR g_row\[1\].g_col\[1\].pe__1703_/B sky130_fd_sc_hd__xor2_2
XFILLER_57_217 VGND VGND VPWR VPWR sky130_fd_sc_hd__decap_3
Xg_row\[1\].g_col\[0\].pe_hold2830 g_row\[1\].g_col\[0\].pe__2710_/Q VGND VGND VPWR
+ VPWR g_row\[1\].g_col\[0\].pe__2649_/B sky130_fd_sc_hd__clkbuf_2
Xg_row\[1\].g_col\[0\].pe__1678_ g_row\[1\].g_col\[0\].pe__1703_/A VGND VGND VPWR
+ VPWR g_row\[1\].g_col\[0\].pe__1678_/Y sky130_fd_sc_hd__inv_2
Xg_row\[0\].g_col\[1\].pe__1910_ g_row\[0\].g_col\[1\].pe__2167_/A g_row\[0\].g_col\[1\].pe__1910_/B
+ VGND VGND VPWR VPWR g_row\[0\].g_col\[1\].pe__1955_/A sky130_fd_sc_hd__xor2_2
Xg_row\[1\].g_col\[0\].pe_hold2852 g_row\[1\].g_col\[0\].pe__2642_/X VGND VGND VPWR
+ VPWR g_row\[1\].g_col\[0\].pe_hold2852/X sky130_fd_sc_hd__clkbuf_2
Xg_row\[0\].g_col\[1\].pe__1841_ g_row\[0\].g_col\[1\].pe__1841_/A VGND VGND VPWR
+ VPWR g_row\[0\].g_col\[1\].pe__1843_/A sky130_fd_sc_hd__inv_2
XTAP_TAPCELL_ROW_0_202 VGND VPWR sky130_fd_sc_hd__tapvpwrvgnd_1
Xg_row\[0\].g_col\[0\].pe__1825_ g_row\[0\].g_col\[0\].pe__1747_/A g_row\[0\].g_col\[0\].pe__1820_/B
+ g_row\[0\].g_col\[0\].pe__1824_/X VGND VGND VPWR VPWR g_row\[0\].g_col\[0\].pe__1828_/B
+ sky130_fd_sc_hd__a21oi_2
Xg_row\[1\].g_col\[0\].pe_hold2896 g_row\[1\].g_col\[0\].pe__2622_/X VGND VGND VPWR
+ VPWR g_row\[1\].g_col\[0\].pe_hold2896/X sky130_fd_sc_hd__clkbuf_2
XFILLER_66_795 VGND VGND VPWR VPWR sky130_fd_sc_hd__fill_1
XFILLER_81_732 VGND VGND VPWR VPWR sky130_fd_sc_hd__decap_3
XTAP_TAPCELL_ROW_0_213 VGND VPWR sky130_fd_sc_hd__tapvpwrvgnd_1
Xg_row\[0\].g_col\[0\].pe__1756_ g_row\[0\].g_col\[0\].pe__1756_/A g_row\[0\].g_col\[0\].pe__1756_/B
+ VGND VGND VPWR VPWR g_row\[0\].g_col\[0\].pe__1756_/X sky130_fd_sc_hd__and2_2
Xg_row\[1\].g_col\[1\].pe__2315_ g_row\[1\].g_col\[1\].pe__2316_/A g_row\[1\].g_col\[1\].pe__2316_/B
+ VGND VGND VPWR VPWR g_row\[1\].g_col\[1\].pe__2347_/A sky130_fd_sc_hd__and2_2
Xg_row\[0\].g_col\[1\].pe__1772_ g_row\[0\].g_col\[1\].pe__1780_/A g_row\[0\].g_col\[1\].pe__1794_/A
+ VGND VGND VPWR VPWR g_row\[0\].g_col\[1\].pe__1813_/A sky130_fd_sc_hd__and2_2
XFILLER_65_294 VGND VGND VPWR VPWR sky130_fd_sc_hd__fill_2
Xg_row\[1\].g_col\[1\].pe__2246_ g_row\[1\].g_col\[1\].pe__2246_/A g_row\[1\].g_col\[1\].pe__2246_/B
+ VGND VGND VPWR VPWR g_row\[1\].g_col\[1\].pe__2273_/A sky130_fd_sc_hd__xnor2_2
XFILLER_25_169 VGND VGND VPWR VPWR sky130_fd_sc_hd__decap_3
XFILLER_34_670 VGND VGND VPWR VPWR sky130_fd_sc_hd__fill_2
XFILLER_53_478 VGND VGND VPWR VPWR sky130_fd_sc_hd__decap_3
Xg_row\[0\].g_col\[0\].pe__1687_ g_row\[0\].g_col\[0\].pe__1713_/A g_row\[0\].g_col\[0\].pe__1713_/B
+ g_row\[0\].g_col\[0\].pe__1686_/X VGND VGND VPWR VPWR g_row\[0\].g_col\[0\].pe__1721_/A
+ sky130_fd_sc_hd__a21oi_2
Xg_row\[1\].g_col\[1\].pe__2177_ g_row\[1\].g_col\[1\].pe__2215_/B2 g_row\[1\].g_col\[1\].pe__2177_/A2
+ g_row\[1\].g_col\[1\].pe__2177_/B1 g_row\[1\].g_col\[1\].pe__2177_/B2 VGND VGND
+ VPWR VPWR g_row\[1\].g_col\[1\].pe__2213_/A sky130_fd_sc_hd__a22o_2
Xg_row\[0\].g_col\[1\].pe__2324_ g_row\[0\].g_col\[1\].pe__2285_/A g_row\[0\].g_col\[1\].pe__2285_/B
+ g_row\[0\].g_col\[1\].pe__2284_/B VGND VGND VPWR VPWR g_row\[0\].g_col\[1\].pe__2338_/A
+ sky130_fd_sc_hd__a21oi_2
Xg_row\[0\].g_col\[0\].pe__2308_ g_row\[0\].g_col\[0\].pe__2308_/A VGND VGND VPWR
+ VPWR g_row\[0\].g_col\[0\].pe__2430_/A sky130_fd_sc_hd__inv_2
Xg_row\[0\].g_col\[0\].pe__2239_ g_row\[0\].g_col\[0\].pe__2239_/A g_row\[0\].g_col\[0\].pe__2239_/B
+ VGND VGND VPWR VPWR g_row\[0\].g_col\[0\].pe__2246_/A sky130_fd_sc_hd__nand2_2
Xg_row\[1\].g_col\[1\].pe_hold3105 g_row\[1\].g_col\[1\].pe__2728_/Q VGND VGND VPWR
+ VPWR g_row\[1\].g_col\[1\].pe__1384_/A1 sky130_fd_sc_hd__clkbuf_2
Xg_row\[1\].g_col\[1\].pe_hold3116 g_row\[1\].g_col\[1\].pe__2731_/Q VGND VGND VPWR
+ VPWR g_row\[1\].g_col\[1\].pe_hold3116/X sky130_fd_sc_hd__clkbuf_2
Xg_row\[0\].g_col\[1\].pe__2255_ g_row\[0\].g_col\[1\].pe__2271_/A g_row\[0\].g_col\[1\].pe__2271_/B
+ VGND VGND VPWR VPWR g_row\[0\].g_col\[1\].pe__2257_/A sky130_fd_sc_hd__xnor2_2
Xg_row\[1\].g_col\[1\].pe_hold3127 g_row\[1\].g_col\[1\].pe__2703_/Q VGND VGND VPWR
+ VPWR g_row\[1\].g_col\[1\].pe__2630_/B sky130_fd_sc_hd__clkbuf_2
Xg_row\[0\].g_col\[1\].pe__2186_ g_row\[0\].g_col\[1\].pe__2203_/B g_row\[0\].g_col\[1\].pe__2186_/B
+ VGND VGND VPWR VPWR g_row\[0\].g_col\[1\].pe__2190_/A sky130_fd_sc_hd__xor2_2
XFILLER_1_725 VGND VGND VPWR VPWR sky130_fd_sc_hd__decap_3
XTAP_TAPCELL_ROW_8_324 VGND VPWR sky130_fd_sc_hd__tapvpwrvgnd_1
XTAP_TAPCELL_ROW_8_335 VGND VPWR sky130_fd_sc_hd__tapvpwrvgnd_1
Xg_row\[1\].g_col\[1\].pe_hold1736 g_row\[1\].g_col\[1\].pe__2769_/Q VGND VGND VPWR
+ VPWR g_row\[1\].g_col\[1\].pe__2587_/A1 sky130_fd_sc_hd__clkbuf_2
Xg_row\[1\].g_col\[1\].pe_hold1714 g_row\[1\].g_col\[1\].pe__2336_/Y VGND VGND VPWR
+ VPWR g_row\[1\].g_col\[1\].pe__2360_/A2 sky130_fd_sc_hd__clkbuf_2
Xhold3130 b_inputs_flat[29] VGND VGND VPWR VPWR hold3130/X sky130_fd_sc_hd__clkbuf_2
Xhold3141 hold3141/A VGND VGND VPWR VPWR hold3141/X sky130_fd_sc_hd__clkbuf_2
Xg_row\[1\].g_col\[1\].pe_hold1747 g_row\[1\].g_col\[1\].pe__2576_/X VGND VGND VPWR
+ VPWR g_row\[1\].g_col\[1\].pe__2577_/B sky130_fd_sc_hd__clkbuf_2
Xhold2440 hold3183/X VGND VGND VPWR VPWR hold3184/A sky130_fd_sc_hd__clkbuf_2
Xhold3152 hold3152/A VGND VGND VPWR VPWR hold3152/X sky130_fd_sc_hd__clkbuf_2
Xhold3163 hold3163/A VGND VGND VPWR VPWR hold3163/X sky130_fd_sc_hd__clkbuf_2
Xhold3174 hold3174/A VGND VGND VPWR VPWR hold3174/X sky130_fd_sc_hd__clkbuf_2
Xhold3185 hold3185/A VGND VGND VPWR VPWR hold3185/X sky130_fd_sc_hd__clkbuf_2
XFILLER_76_548 VGND VGND VPWR VPWR sky130_fd_sc_hd__decap_3
Xhold2451 hold3209/X VGND VGND VPWR VPWR hold3210/A sky130_fd_sc_hd__clkbuf_2
Xhold2462 hold3158/X VGND VGND VPWR VPWR hold3159/A sky130_fd_sc_hd__clkbuf_2
Xhold2473 hold2473/A VGND VGND VPWR VPWR _340_/D sky130_fd_sc_hd__clkbuf_2
Xhold3196 hold3196/A VGND VGND VPWR VPWR hold3196/X sky130_fd_sc_hd__clkbuf_2
XTAP_TAPCELL_ROW_47_908 VGND VPWR sky130_fd_sc_hd__tapvpwrvgnd_1
XTAP_TAPCELL_ROW_47_919 VGND VPWR sky130_fd_sc_hd__tapvpwrvgnd_1
Xhold2484 _223_/Y VGND VGND VPWR VPWR hold2484/X sky130_fd_sc_hd__clkbuf_2
Xhold2495 hold3248/X VGND VGND VPWR VPWR _225_/B_N sky130_fd_sc_hd__clkbuf_2
XFILLER_17_615 VGND VGND VPWR VPWR sky130_fd_sc_hd__fill_1
XFILLER_56_261 VGND VGND VPWR VPWR sky130_fd_sc_hd__fill_2
XFILLER_72_710 VGND VGND VPWR VPWR sky130_fd_sc_hd__fill_1
XFILLER_91_529 VGND VGND VPWR VPWR sky130_fd_sc_hd__fill_2
XTAP_TAPCELL_ROW_27_610 VGND VPWR sky130_fd_sc_hd__tapvpwrvgnd_1
XTAP_TAPCELL_ROW_67_1213 VGND VPWR sky130_fd_sc_hd__tapvpwrvgnd_1
XFILLER_16_147 VGND VGND VPWR VPWR sky130_fd_sc_hd__fill_1
XTAP_TAPCELL_ROW_27_621 VGND VPWR sky130_fd_sc_hd__tapvpwrvgnd_1
XFILLER_44_489 VGND VGND VPWR VPWR sky130_fd_sc_hd__fill_2
XFILLER_31_117 VGND VGND VPWR VPWR sky130_fd_sc_hd__fill_1
XTAP_TAPCELL_ROW_80_1413 VGND VPWR sky130_fd_sc_hd__tapvpwrvgnd_1
Xg_row\[0\].g_col\[0\].pe_hold2939 g_row\[0\].g_col\[0\].pe__2689_/A VGND VGND VPWR
+ VPWR g_row\[0\].g_col\[0\].pe__2680_/A sky130_fd_sc_hd__clkbuf_2
XFILLER_40_662 VGND VGND VPWR VPWR sky130_fd_sc_hd__fill_2
XTAP_TAPCELL_ROW_78_1375 VGND VPWR sky130_fd_sc_hd__tapvpwrvgnd_1
XTAP_TAPCELL_ROW_78_1386 VGND VPWR sky130_fd_sc_hd__tapvpwrvgnd_1
Xg_row\[1\].g_col\[0\].pe__2650_ g_row\[1\].g_col\[0\].pe__2652_/A1 hold1894/X g_row\[1\].g_col\[0\].pe__2677_/B1
+ g_row\[1\].g_col\[0\].pe__2650_/C1 VGND VGND VPWR VPWR g_row\[1\].g_col\[0\].pe__2650_/X
+ sky130_fd_sc_hd__o211a_2
Xg_row\[1\].g_col\[0\].pe__1601_ place1100/X g_row\[1\].g_col\[0\].pe__1504_/Y g_row\[1\].g_col\[0\].pe__2074_/B1
+ g_row\[1\].g_col\[0\].pe__2605_/B VGND VGND VPWR VPWR g_row\[1\].g_col\[0\].pe__1602_/B
+ sky130_fd_sc_hd__a22o_2
XFILLER_4_596 VGND VGND VPWR VPWR sky130_fd_sc_hd__decap_3
XTAP_TAPCELL_ROW_91_1575 VGND VPWR sky130_fd_sc_hd__tapvpwrvgnd_1
Xg_row\[1\].g_col\[0\].pe__2581_ g_row\[1\].g_col\[0\].pe__2581_/A1 g_row\[1\].g_col\[0\].pe__2591_/A2
+ g_row\[1\].g_col\[0\].pe__2591_/B1 g_row\[1\].g_col\[0\].pe__2580_/X VGND VGND VPWR
+ VPWR g_row\[1\].g_col\[0\].pe__2581_/X sky130_fd_sc_hd__a22o_2
Xg_row\[1\].g_col\[0\].pe__1532_ g_row\[1\].g_col\[0\].pe__1555_/A g_row\[1\].g_col\[0\].pe__1555_/B
+ VGND VGND VPWR VPWR g_row\[1\].g_col\[0\].pe__1533_/B sky130_fd_sc_hd__xor2_2
XFILLER_67_559 VGND VGND VPWR VPWR sky130_fd_sc_hd__fill_1
Xg_row\[1\].g_col\[0\].pe__1463_ place1099/X g_row\[1\].g_col\[0\].pe__1715_/B g_row\[1\].g_col\[0\].pe__1863_/B1
+ hold2198/A VGND VGND VPWR VPWR g_row\[1\].g_col\[0\].pe__1464_/B sky130_fd_sc_hd__a22o_2
XFILLER_82_518 VGND VGND VPWR VPWR sky130_fd_sc_hd__fill_1
Xg_row\[1\].g_col\[0\].pe__1394_ hold2019/X g_row\[1\].g_col\[0\].pe__1402_/B VGND
+ VGND VPWR VPWR g_row\[1\].g_col\[0\].pe__1394_/X sky130_fd_sc_hd__or2_2
XFILLER_35_401 VGND VGND VPWR VPWR sky130_fd_sc_hd__decap_3
XFILLER_47_250 VGND VGND VPWR VPWR sky130_fd_sc_hd__decap_3
Xg_row\[0\].g_col\[0\].pe__1610_ place1208/X g_row\[0\].g_col\[0\].pe__1715_/B g_row\[0\].g_col\[0\].pe__1863_/B1
+ place1210/X VGND VGND VPWR VPWR g_row\[0\].g_col\[0\].pe__1611_/B sky130_fd_sc_hd__a22o_2
Xg_row\[0\].g_col\[0\].pe__2590_ g_row\[0\].g_col\[0\].pe__2590_/A g_row\[0\].g_col\[0\].pe__2508_/Y
+ VGND VGND VPWR VPWR g_row\[0\].g_col\[0\].pe__2590_/X sky130_fd_sc_hd__or2b_2
XFILLER_35_434 VGND VGND VPWR VPWR sky130_fd_sc_hd__fill_2
XFILLER_35_445 VGND VGND VPWR VPWR sky130_fd_sc_hd__decap_3
XFILLER_35_456 VGND VGND VPWR VPWR sky130_fd_sc_hd__decap_3
Xg_row\[0\].g_col\[0\].pe__1541_ g_row\[0\].g_col\[0\].pe__2736_/Q g_row\[0\].g_col\[0\].pe__2341_/B
+ g_row\[0\].g_col\[0\].pe__1540_/X VGND VGND VPWR VPWR g_row\[0\].g_col\[0\].pe__1541_/X
+ sky130_fd_sc_hd__a21o_2
Xg_row\[1\].g_col\[1\].pe__2100_ g_row\[1\].g_col\[1\].pe__2099_/A g_row\[1\].g_col\[1\].pe__2184_/B
+ g_row\[1\].g_col\[1\].pe__2099_/C VGND VGND VPWR VPWR g_row\[1\].g_col\[1\].pe__2101_/C
+ sky130_fd_sc_hd__a21oi_2
XFILLER_90_573 VGND VGND VPWR VPWR sky130_fd_sc_hd__decap_3
Xg_row\[1\].g_col\[1\].pe__2031_ g_row\[1\].g_col\[1\].pe__1461_/A g_row\[1\].g_col\[1\].pe__1461_/B
+ g_row\[1\].g_col\[1\].pe__1970_/A VGND VGND VPWR VPWR g_row\[1\].g_col\[1\].pe__2032_/C
+ sky130_fd_sc_hd__a21bo_2
XFILLER_15_180 VGND VGND VPWR VPWR sky130_fd_sc_hd__decap_3
Xg_row\[1\].g_col\[0\].pe__2015_ g_row\[1\].g_col\[0\].pe__2002_/A g_row\[1\].g_col\[0\].pe__2002_/B
+ g_row\[1\].g_col\[0\].pe__2014_/X VGND VGND VPWR VPWR g_row\[1\].g_col\[0\].pe__2059_/A
+ sky130_fd_sc_hd__a21o_2
Xg_row\[0\].g_col\[1\].pe__2040_ g_row\[0\].g_col\[1\].pe__2045_/A g_row\[0\].g_col\[1\].pe__2727_/Q
+ g_row\[0\].g_col\[1\].pe__2704_/Q VGND VGND VPWR VPWR g_row\[0\].g_col\[1\].pe__2040_/X
+ sky130_fd_sc_hd__or3b_4
Xg_row\[0\].g_col\[0\].pe__2024_ g_row\[0\].g_col\[0\].pe__2024_/A g_row\[0\].g_col\[0\].pe__2024_/B
+ VGND VGND VPWR VPWR g_row\[0\].g_col\[0\].pe__2052_/A sky130_fd_sc_hd__xor2_2
Xg_row\[1\].g_col\[1\].pe__1815_ g_row\[1\].g_col\[1\].pe__1815_/A g_row\[1\].g_col\[1\].pe__1815_/B
+ VGND VGND VPWR VPWR g_row\[1\].g_col\[1\].pe__1822_/D sky130_fd_sc_hd__xnor2_2
Xplace1089 place1090/X VGND VGND VPWR VPWR place1089/X sky130_fd_sc_hd__buf_6
XFILLER_85_301 VGND VGND VPWR VPWR sky130_fd_sc_hd__fill_1
Xg_row\[1\].g_col\[1\].pe__1746_ g_row\[1\].g_col\[1\].pe__1819_/A g_row\[1\].g_col\[1\].pe__1819_/B
+ VGND VGND VPWR VPWR g_row\[1\].g_col\[1\].pe__1820_/B sky130_fd_sc_hd__nor2_2
XFILLER_58_559 VGND VGND VPWR VPWR sky130_fd_sc_hd__fill_2
Xg_row\[1\].g_col\[1\].pe__1677_ g_row\[1\].g_col\[1\].pe__1823_/A g_row\[1\].g_col\[1\].pe__1677_/B
+ VGND VGND VPWR VPWR g_row\[1\].g_col\[1\].pe__1703_/A sky130_fd_sc_hd__or2_2
XFILLER_38_250 VGND VGND VPWR VPWR sky130_fd_sc_hd__fill_2
Xg_row\[0\].g_col\[0\].pe__1808_ g_row\[0\].g_col\[0\].pe__1808_/A g_row\[0\].g_col\[0\].pe__1808_/B
+ g_row\[0\].g_col\[0\].pe__1808_/C g_row\[0\].g_col\[0\].pe__1811_/C VGND VGND VPWR
+ VPWR g_row\[0\].g_col\[0\].pe__1808_/X sky130_fd_sc_hd__or4b_4
Xg_row\[0\].g_col\[1\].pe__1824_ g_row\[0\].g_col\[1\].pe__1726_/B g_row\[0\].g_col\[1\].pe__1824_/B
+ VGND VGND VPWR VPWR g_row\[0\].g_col\[1\].pe__1824_/X sky130_fd_sc_hd__and2b_2
XFILLER_26_47 VGND VGND VPWR VPWR sky130_fd_sc_hd__fill_2
XFILLER_53_231 VGND VGND VPWR VPWR sky130_fd_sc_hd__fill_1
XFILLER_54_743 VGND VGND VPWR VPWR sky130_fd_sc_hd__fill_1
Xg_row\[0\].g_col\[1\].pe__1755_ g_row\[0\].g_col\[1\].pe__2125_/C g_row\[0\].g_col\[1\].pe__1755_/B
+ VGND VGND VPWR VPWR g_row\[0\].g_col\[1\].pe__1770_/B sky130_fd_sc_hd__xor2_2
XFILLER_53_242 VGND VGND VPWR VPWR sky130_fd_sc_hd__decap_3
Xg_row\[0\].g_col\[0\].pe__1739_ g_row\[0\].g_col\[0\].pe__1816_/A g_row\[0\].g_col\[0\].pe__1739_/B
+ VGND VGND VPWR VPWR g_row\[0\].g_col\[0\].pe__1776_/B sky130_fd_sc_hd__xor2_2
Xg_row\[0\].g_col\[1\].pe__1686_ g_row\[0\].g_col\[1\].pe__1686_/A g_row\[0\].g_col\[1\].pe__1686_/B
+ VGND VGND VPWR VPWR g_row\[0\].g_col\[1\].pe__1686_/X sky130_fd_sc_hd__and2_2
Xg_row\[1\].g_col\[1\].pe__2229_ g_row\[1\].g_col\[1\].pe__2262_/A g_row\[1\].g_col\[1\].pe__2229_/B
+ VGND VGND VPWR VPWR g_row\[1\].g_col\[1\].pe__2238_/B sky130_fd_sc_hd__and2_2
XFILLER_22_651 VGND VGND VPWR VPWR sky130_fd_sc_hd__decap_3
XTAP_TAPCELL_ROW_52_988 VGND VPWR sky130_fd_sc_hd__tapvpwrvgnd_1
XTAP_TAPCELL_ROW_62_1143 VGND VPWR sky130_fd_sc_hd__tapvpwrvgnd_1
XFILLER_10_813 VGND VGND VPWR VPWR sky130_fd_sc_hd__fill_2
XFILLER_21_172 VGND VGND VPWR VPWR sky130_fd_sc_hd__fill_1
XFILLER_42_46 VGND VGND VPWR VPWR sky130_fd_sc_hd__fill_1
XTAP_TAPCELL_ROW_32_690 VGND VPWR sky130_fd_sc_hd__tapvpwrvgnd_1
Xg_row\[0\].g_col\[1\].pe__2307_ g_row\[0\].g_col\[1\].pe__2405_/A g_row\[0\].g_col\[1\].pe__2307_/B
+ VGND VGND VPWR VPWR g_row\[0\].g_col\[1\].pe__2749_/D sky130_fd_sc_hd__nor2_2
XFILLER_5_327 VGND VGND VPWR VPWR sky130_fd_sc_hd__fill_1
Xg_row\[0\].g_col\[1\].pe__2238_ g_row\[0\].g_col\[1\].pe__2238_/A g_row\[0\].g_col\[1\].pe__2238_/B
+ VGND VGND VPWR VPWR g_row\[0\].g_col\[1\].pe__2238_/X sky130_fd_sc_hd__and2_2
Xg_row\[1\].g_col\[1\].pe_hold2212 g_row\[1\].g_col\[1\].pe_hold2885/X VGND VGND VPWR
+ VPWR g_row\[1\].g_col\[1\].pe__2721_/D sky130_fd_sc_hd__clkbuf_2
Xg_row\[1\].g_col\[1\].pe_hold2201 g_row\[1\].g_col\[1\].pe_hold2824/X VGND VGND VPWR
+ VPWR g_row\[1\].g_col\[1\].pe_hold2825/A sky130_fd_sc_hd__clkbuf_2
Xg_row\[0\].g_col\[1\].pe__2169_ g_row\[0\].g_col\[1\].pe__2167_/X g_row\[0\].g_col\[1\].pe__2169_/B
+ VGND VGND VPWR VPWR g_row\[0\].g_col\[1\].pe__2172_/A sky130_fd_sc_hd__and2b_2
XFILLER_49_526 VGND VGND VPWR VPWR sky130_fd_sc_hd__decap_3
XFILLER_49_559 VGND VGND VPWR VPWR sky130_fd_sc_hd__fill_1
XFILLER_64_529 VGND VGND VPWR VPWR sky130_fd_sc_hd__decap_3
Xhold1580 hold3534/X VGND VGND VPWR VPWR hold2729/A sky130_fd_sc_hd__clkbuf_2
XFILLER_44_220 VGND VGND VPWR VPWR sky130_fd_sc_hd__decap_3
XFILLER_83_31 VGND VGND VPWR VPWR sky130_fd_sc_hd__fill_2
XFILLER_83_53 VGND VGND VPWR VPWR sky130_fd_sc_hd__decap_3
XFILLER_91_337 VGND VGND VPWR VPWR sky130_fd_sc_hd__fill_1
Xhold1591 hold3411/X VGND VGND VPWR VPWR hold3412/A sky130_fd_sc_hd__clkbuf_2
Xg_row\[1\].g_col\[0\].pe_place930 g_row\[1\].g_col\[0\].pe__1950_/A VGND VGND VPWR
+ VPWR g_row\[1\].g_col\[0\].pe__2626_/A1 sky130_fd_sc_hd__buf_6
XFILLER_13_640 VGND VGND VPWR VPWR sky130_fd_sc_hd__decap_3
XFILLER_13_673 VGND VGND VPWR VPWR sky130_fd_sc_hd__decap_3
XFILLER_40_481 VGND VGND VPWR VPWR sky130_fd_sc_hd__fill_1
XFILLER_9_655 VGND VGND VPWR VPWR sky130_fd_sc_hd__fill_2
XTAP_TAPCELL_ROW_10_362 VGND VPWR sky130_fd_sc_hd__tapvpwrvgnd_1
XTAP_TAPCELL_ROW_93_1604 VGND VPWR sky130_fd_sc_hd__tapvpwrvgnd_1
XTAP_TAPCELL_ROW_93_1615 VGND VPWR sky130_fd_sc_hd__tapvpwrvgnd_1
XTAP_TAPCELL_ROW_93_1626 VGND VPWR sky130_fd_sc_hd__tapvpwrvgnd_1
Xg_row\[0\].g_col\[0\].pe_place1183 g_row\[0\].g_col\[0\].pe__1789_/A VGND VGND VPWR
+ VPWR g_row\[0\].g_col\[0\].pe__1733_/A sky130_fd_sc_hd__buf_6
Xg_row\[1\].g_col\[0\].pe__2702_ _306_/CLK g_row\[1\].g_col\[0\].pe__2702_/D VGND
+ VGND VPWR VPWR hold1795/A sky130_fd_sc_hd__dfxtp_2
Xg_row\[0\].g_col\[0\].pe_place1194 g_row\[0\].g_col\[1\].pe__2635_/C VGND VGND VPWR
+ VPWR g_row\[0\].g_col\[0\].pe__2632_/B sky130_fd_sc_hd__buf_6
Xg_row\[1\].g_col\[0\].pe__2633_ g_row\[1\].g_col\[0\].pe__2652_/A1 g_row\[1\].g_col\[0\].pe__2633_/A2
+ g_row\[1\].g_col\[0\].pe__2687_/C1 g_row\[1\].g_col\[0\].pe__2632_/X VGND VGND VPWR
+ VPWR g_row\[1\].g_col\[0\].pe__2633_/X sky130_fd_sc_hd__o211a_2
Xg_row\[1\].g_col\[1\].pe__2580_ g_row\[1\].g_col\[1\].pe__2479_/X g_row\[1\].g_col\[1\].pe__2579_/Y
+ g_row\[1\].g_col\[1\].pe__2590_/A VGND VGND VPWR VPWR g_row\[1\].g_col\[1\].pe__2580_/X
+ sky130_fd_sc_hd__a21o_2
Xg_row\[1\].g_col\[0\].pe__2564_ g_row\[1\].g_col\[0\].pe__2564_/A1 g_row\[1\].g_col\[0\].pe__2591_/A2
+ g_row\[1\].g_col\[0\].pe__2591_/B1 g_row\[1\].g_col\[0\].pe__2563_/X VGND VGND VPWR
+ VPWR g_row\[1\].g_col\[0\].pe__2564_/X sky130_fd_sc_hd__a22o_2
XFILLER_79_161 VGND VGND VPWR VPWR sky130_fd_sc_hd__fill_1
Xg_row\[1\].g_col\[1\].pe__1531_ g_row\[1\].g_col\[1\].pe__1676_/A g_row\[1\].g_col\[1\].pe__1531_/B
+ VGND VGND VPWR VPWR g_row\[1\].g_col\[1\].pe__1555_/B sky130_fd_sc_hd__xnor2_2
Xg_row\[1\].g_col\[0\].pe__1515_ g_row\[1\].g_col\[0\].pe__1490_/A g_row\[1\].g_col\[0\].pe__1490_/B
+ g_row\[1\].g_col\[0\].pe__1514_/X VGND VGND VPWR VPWR g_row\[1\].g_col\[0\].pe__1584_/A
+ sky130_fd_sc_hd__a21oi_2
Xg_row\[0\].g_col\[0\].pe__2711_ clkbuf_leaf_36_clk/X g_row\[0\].g_col\[0\].pe__2711_/D
+ VGND VGND VPWR VPWR hold3100/A sky130_fd_sc_hd__dfxtp_2
Xg_row\[1\].g_col\[0\].pe__2495_ g_row\[1\].g_col\[0\].pe__2495_/A VGND VGND VPWR
+ VPWR g_row\[1\].g_col\[0\].pe__2496_/A sky130_fd_sc_hd__inv_2
Xg_row\[0\].g_col\[0\].pe__2642_ g_row\[0\].g_col\[0\].pe__2656_/A1 g_row\[0\].g_col\[0\].pe__2642_/A2
+ g_row\[0\].g_col\[0\].pe__2687_/C1 g_row\[0\].g_col\[0\].pe__2641_/X VGND VGND VPWR
+ VPWR g_row\[0\].g_col\[0\].pe__2642_/X sky130_fd_sc_hd__o211a_2
Xg_row\[1\].g_col\[1\].pe__1393_ g_row\[1\].g_col\[1\].pe__1393_/A1 g_row\[1\].g_col\[1\].pe__1403_/A2
+ g_row\[1\].g_col\[1\].pe__1392_/X g_row\[1\].g_col\[1\].pe__2666_/B1 VGND VGND VPWR
+ VPWR g_row\[1\].g_col\[1\].pe__1393_/X sky130_fd_sc_hd__o211a_2
Xg_row\[1\].g_col\[0\].pe__1377_ hold1640/X VGND VGND VPWR VPWR g_row\[1\].g_col\[0\].pe__2592_/A
+ sky130_fd_sc_hd__inv_2
XFILLER_63_551 VGND VGND VPWR VPWR sky130_fd_sc_hd__fill_2
Xg_row\[0\].g_col\[0\].pe__2573_ g_row\[0\].g_col\[0\].pe__2592_/A g_row\[0\].g_col\[0\].pe__2573_/B
+ VGND VGND VPWR VPWR g_row\[0\].g_col\[0\].pe__2766_/D sky130_fd_sc_hd__and2_2
Xg_row\[0\].g_col\[1\].pe__1540_ g_row\[0\].g_col\[1\].pe__2736_/Q g_row\[0\].g_col\[1\].pe__2735_/Q
+ g_row\[0\].g_col\[1\].pe__2734_/Q VGND VGND VPWR VPWR g_row\[0\].g_col\[1\].pe__1540_/X
+ sky130_fd_sc_hd__and3b_2
XFILLER_35_275 VGND VGND VPWR VPWR sky130_fd_sc_hd__decap_3
XFILLER_35_297 VGND VGND VPWR VPWR sky130_fd_sc_hd__decap_3
XFILLER_50_223 VGND VGND VPWR VPWR sky130_fd_sc_hd__fill_1
XTAP_TAPCELL_ROW_18_473 VGND VPWR sky130_fd_sc_hd__tapvpwrvgnd_1
XTAP_TAPCELL_ROW_18_484 VGND VPWR sky130_fd_sc_hd__tapvpwrvgnd_1
Xg_row\[0\].g_col\[0\].pe__1524_ g_row\[0\].g_col\[0\].pe__1584_/A g_row\[0\].g_col\[0\].pe__1584_/B
+ VGND VGND VPWR VPWR g_row\[0\].g_col\[0\].pe__1533_/A sky130_fd_sc_hd__xor2_2
Xg_row\[0\].g_col\[1\].pe__1471_ g_row\[0\].g_col\[1\].pe__1471_/A g_row\[0\].g_col\[1\].pe__1471_/B
+ VGND VGND VPWR VPWR g_row\[0\].g_col\[1\].pe__1471_/X sky130_fd_sc_hd__and2_2
Xg_row\[1\].g_col\[1\].pe__2014_ g_row\[1\].g_col\[1\].pe__2001_/B g_row\[1\].g_col\[1\].pe__2014_/B
+ VGND VGND VPWR VPWR g_row\[1\].g_col\[1\].pe__2014_/X sky130_fd_sc_hd__and2b_2
XFILLER_31_492 VGND VGND VPWR VPWR sky130_fd_sc_hd__decap_3
Xg_row\[0\].g_col\[0\].pe__1386_ g_row\[0\].g_col\[0\].pe__1386_/A1 g_row\[0\].g_col\[0\].pe__2684_/B
+ g_row\[0\].g_col\[0\].pe__1385_/X g_row\[0\].g_col\[0\].pe__2640_/C1 VGND VGND VPWR
+ VPWR g_row\[0\].g_col\[0\].pe__1386_/X sky130_fd_sc_hd__o211a_2
Xg_row\[0\].g_col\[0\].pe__2007_ g_row\[0\].g_col\[0\].pe__2009_/C g_row\[0\].g_col\[0\].pe__2008_/A
+ g_row\[0\].g_col\[0\].pe__2151_/B VGND VGND VPWR VPWR g_row\[0\].g_col\[0\].pe__2010_/B
+ sky130_fd_sc_hd__and3b_2
Xg_row\[0\].g_col\[1\].pe__2023_ g_row\[0\].g_col\[1\].pe__2023_/A g_row\[0\].g_col\[1\].pe__2023_/B
+ VGND VGND VPWR VPWR g_row\[0\].g_col\[1\].pe__2024_/B sky130_fd_sc_hd__xor2_2
XFILLER_59_802 VGND VGND VPWR VPWR sky130_fd_sc_hd__fill_1
XFILLER_86_610 VGND VGND VPWR VPWR sky130_fd_sc_hd__decap_3
XFILLER_86_632 VGND VGND VPWR VPWR sky130_fd_sc_hd__decap_3
Xg_row\[1\].g_col\[1\].pe__1729_ g_row\[1\].g_col\[1\].pe__1782_/A2 g_row\[1\].g_col\[1\].pe__1729_/A2
+ g_row\[1\].g_col\[1\].pe__1729_/A3 g_row\[1\].g_col\[1\].pe__1729_/B1 g_row\[1\].g_col\[1\].pe__1761_/A2
+ VGND VGND VPWR VPWR g_row\[1\].g_col\[1\].pe__1730_/B sky130_fd_sc_hd__a32o_2
XFILLER_73_337 VGND VGND VPWR VPWR sky130_fd_sc_hd__fill_2
Xg_row\[0\].g_col\[1\].pe__1807_ g_row\[0\].g_col\[1\].pe__1807_/A g_row\[0\].g_col\[1\].pe__1807_/B
+ VGND VGND VPWR VPWR g_row\[0\].g_col\[1\].pe__1811_/C sky130_fd_sc_hd__nand2_2
XFILLER_26_253 VGND VGND VPWR VPWR sky130_fd_sc_hd__decap_3
XTAP_TAPCELL_ROW_37_760 VGND VPWR sky130_fd_sc_hd__tapvpwrvgnd_1
XTAP_TAPCELL_ROW_37_771 VGND VPWR sky130_fd_sc_hd__tapvpwrvgnd_1
X_340_ _340_/CLK _340_/D VGND VGND VPWR VPWR _340_/Q sky130_fd_sc_hd__dfxtp_2
Xg_row\[0\].g_col\[1\].pe__1738_ g_row\[0\].g_col\[1\].pe__1805_/A2 g_row\[0\].g_col\[1\].pe__1748_/B
+ g_row\[0\].g_col\[1\].pe__1738_/B1 g_row\[0\].g_col\[1\].pe__2690_/Q VGND VGND VPWR
+ VPWR g_row\[0\].g_col\[1\].pe__1739_/B sky130_fd_sc_hd__a22o_2
Xg_row\[0\].g_col\[1\].pe__1669_ g_row\[0\].g_col\[1\].pe__1669_/A g_row\[0\].g_col\[1\].pe__1669_/B
+ VGND VGND VPWR VPWR g_row\[0\].g_col\[1\].pe__1831_/B sky130_fd_sc_hd__xnor2_2
X_271_ _271_/A _271_/B_N VGND VGND VPWR VPWR _271_/Y sky130_fd_sc_hd__nor2b_4
XFILLER_6_658 VGND VGND VPWR VPWR sky130_fd_sc_hd__decap_3
XTAP_TAPCELL_ROW_75_1334 VGND VPWR sky130_fd_sc_hd__tapvpwrvgnd_1
XFILLER_18_710 VGND VGND VPWR VPWR sky130_fd_sc_hd__decap_3
XFILLER_49_367 VGND VGND VPWR VPWR sky130_fd_sc_hd__decap_3
XFILLER_64_326 VGND VGND VPWR VPWR sky130_fd_sc_hd__fill_1
Xg_row\[1\].g_col\[0\].pe__2280_ g_row\[1\].g_col\[0\].pe__2364_/A g_row\[1\].g_col\[0\].pe__2280_/B
+ VGND VGND VPWR VPWR g_row\[1\].g_col\[0\].pe__2311_/B sky130_fd_sc_hd__xnor2_2
XFILLER_18_732 VGND VGND VPWR VPWR sky130_fd_sc_hd__decap_3
XFILLER_76_197 VGND VGND VPWR VPWR sky130_fd_sc_hd__decap_3
XTAP_TAPCELL_ROW_86_1496 VGND VPWR sky130_fd_sc_hd__tapvpwrvgnd_1
XFILLER_32_245 VGND VGND VPWR VPWR sky130_fd_sc_hd__decap_3
XTAP_TAPCELL_ROW_15_432 VGND VPWR sky130_fd_sc_hd__tapvpwrvgnd_1
XFILLER_60_598 VGND VGND VPWR VPWR sky130_fd_sc_hd__fill_2
XFILLER_64_3 VGND VGND VPWR VPWR sky130_fd_sc_hd__fill_1
Xg_row\[1\].g_col\[0\].pe__1995_ g_row\[1\].g_col\[0\].pe__1931_/A g_row\[1\].g_col\[0\].pe__1931_/B
+ g_row\[1\].g_col\[0\].pe__1994_/Y VGND VGND VPWR VPWR g_row\[1\].g_col\[0\].pe__2055_/B
+ sky130_fd_sc_hd__a21oi_2
Xg_row\[1\].g_col\[1\].pe__2701_ clkbuf_leaf_70_clk/X g_row\[1\].g_col\[1\].pe__2701_/D
+ VGND VGND VPWR VPWR g_row\[1\].g_col\[1\].pe__2701_/Q sky130_fd_sc_hd__dfxtp_2
Xg_row\[1\].g_col\[1\].pe__2632_ place1247/X g_row\[1\].g_col\[1\].pe__2632_/B VGND
+ VGND VPWR VPWR g_row\[1\].g_col\[1\].pe__2632_/X sky130_fd_sc_hd__or2_2
Xg_row\[1\].g_col\[0\].pe__2616_ g_row\[1\].g_col\[0\].pe__2639_/A g_row\[1\].g_col\[0\].pe__2616_/B
+ VGND VGND VPWR VPWR g_row\[1\].g_col\[0\].pe__2616_/X sky130_fd_sc_hd__or2_2
XFILLER_68_621 VGND VGND VPWR VPWR sky130_fd_sc_hd__decap_3
Xg_row\[1\].g_col\[1\].pe__2563_ g_row\[1\].g_col\[1\].pe__2590_/A g_row\[1\].g_col\[1\].pe__2505_/X
+ VGND VGND VPWR VPWR g_row\[1\].g_col\[1\].pe__2563_/X sky130_fd_sc_hd__or2b_2
Xg_row\[1\].g_col\[1\].pe__1514_ g_row\[1\].g_col\[1\].pe__1514_/A g_row\[1\].g_col\[1\].pe__1514_/B
+ VGND VGND VPWR VPWR g_row\[1\].g_col\[1\].pe__1514_/X sky130_fd_sc_hd__and2_2
Xg_row\[1\].g_col\[0\].pe__2547_ g_row\[1\].g_col\[0\].pe__2559_/A g_row\[1\].g_col\[0\].pe__2547_/B
+ g_row\[1\].g_col\[0\].pe__2546_/Y VGND VGND VPWR VPWR g_row\[1\].g_col\[0\].pe__2547_/X
+ sky130_fd_sc_hd__or3b_2
XFILLER_68_698 VGND VGND VPWR VPWR sky130_fd_sc_hd__fill_2
Xg_row\[1\].g_col\[1\].pe__2494_ g_row\[1\].g_col\[1\].pe__2494_/A g_row\[1\].g_col\[1\].pe__2494_/B
+ VGND VGND VPWR VPWR g_row\[1\].g_col\[1\].pe__2585_/B sky130_fd_sc_hd__or2_4
Xg_row\[1\].g_col\[0\].pe__2478_ g_row\[1\].g_col\[0\].pe__2478_/A g_row\[1\].g_col\[0\].pe__2478_/B
+ VGND VGND VPWR VPWR g_row\[1\].g_col\[0\].pe__2579_/A sky130_fd_sc_hd__xnor2_2
Xg_row\[0\].g_col\[1\].pe__2710_ clkbuf_leaf_95_clk/X g_row\[0\].g_col\[1\].pe__2710_/D
+ VGND VGND VPWR VPWR hold2200/A sky130_fd_sc_hd__dfxtp_2
XFILLER_55_337 VGND VGND VPWR VPWR sky130_fd_sc_hd__decap_3
XFILLER_82_112 VGND VGND VPWR VPWR sky130_fd_sc_hd__fill_2
Xg_row\[1\].g_col\[0\].pe__1429_ g_row\[1\].g_col\[0\].pe__1650_/A g_row\[1\].g_col\[0\].pe__1650_/B
+ g_row\[1\].g_col\[0\].pe__1428_/X VGND VGND VPWR VPWR g_row\[1\].g_col\[0\].pe__1479_/A
+ sky130_fd_sc_hd__a21oi_2
Xg_row\[0\].g_col\[1\].pe_hold2129 g_row\[0\].g_col\[1\].pe_hold2989/X VGND VGND VPWR
+ VPWR g_row\[0\].g_col\[1\].pe__2718_/D sky130_fd_sc_hd__clkbuf_2
Xg_row\[0\].g_col\[1\].pe_hold2118 g_row\[0\].g_col\[1\].pe_hold2954/X VGND VGND VPWR
+ VPWR g_row\[0\].g_col\[1\].pe__2723_/D sky130_fd_sc_hd__clkbuf_2
XFILLER_24_713 VGND VGND VPWR VPWR sky130_fd_sc_hd__fill_2
Xg_row\[0\].g_col\[0\].pe__2625_ _273_/Q hold2229/X VGND VGND VPWR VPWR g_row\[0\].g_col\[0\].pe__2625_/X
+ sky130_fd_sc_hd__or2_2
Xg_row\[1\].g_col\[1\].pe_place1243 g_row\[1\].g_col\[1\].pe__2639_/A VGND VGND VPWR
+ VPWR g_row\[1\].g_col\[1\].pe__2404_/A1 sky130_fd_sc_hd__buf_6
Xg_row\[1\].g_col\[1\].pe__1376_ hold2200/X g_row\[1\].g_col\[1\].pe__1402_/B VGND
+ VGND VPWR VPWR g_row\[1\].g_col\[1\].pe__1376_/X sky130_fd_sc_hd__or2_2
Xg_row\[0\].g_col\[1\].pe__2641_ g_row\[0\].g_col\[1\].pe__2669_/A hold2186/X VGND
+ VGND VPWR VPWR g_row\[0\].g_col\[1\].pe__2641_/X sky130_fd_sc_hd__or2_2
Xg_row\[0\].g_col\[1\].pe__2572_ g_row\[0\].g_col\[1\].pe__2572_/A1 g_row\[0\].g_col\[1\].pe__2587_/A2
+ g_row\[0\].g_col\[1\].pe__2517_/Y g_row\[0\].g_col\[1\].pe__2571_/X VGND VGND VPWR
+ VPWR g_row\[0\].g_col\[1\].pe__2573_/B sky130_fd_sc_hd__a22o_2
Xg_row\[0\].g_col\[0\].pe__1507_ g_row\[0\].g_col\[0\].pe__1507_/A g_row\[0\].g_col\[0\].pe__1507_/B
+ VGND VGND VPWR VPWR g_row\[0\].g_col\[0\].pe__1507_/X sky130_fd_sc_hd__and2_2
Xg_row\[0\].g_col\[1\].pe__1523_ g_row\[0\].g_col\[1\].pe__1523_/A g_row\[0\].g_col\[1\].pe__1523_/B
+ VGND VGND VPWR VPWR g_row\[0\].g_col\[1\].pe__1584_/B sky130_fd_sc_hd__xnor2_2
XFILLER_23_278 VGND VGND VPWR VPWR sky130_fd_sc_hd__fill_2
XFILLER_51_587 VGND VGND VPWR VPWR sky130_fd_sc_hd__decap_3
Xg_row\[0\].g_col\[0\].pe__2487_ g_row\[0\].g_col\[0\].pe__2487_/A g_row\[0\].g_col\[0\].pe__2487_/B
+ g_row\[0\].g_col\[0\].pe__2490_/A VGND VGND VPWR VPWR g_row\[0\].g_col\[0\].pe__2488_/B
+ sky130_fd_sc_hd__or3_2
Xg_row\[0\].g_col\[0\].pe__1438_ g_row\[0\].g_col\[0\].pe__1481_/A g_row\[0\].g_col\[0\].pe__1481_/B
+ VGND VGND VPWR VPWR g_row\[0\].g_col\[0\].pe__1442_/A sky130_fd_sc_hd__xor2_2
Xg_row\[0\].g_col\[0\].pe__1369_ g_row\[0\].g_col\[0\].pe__2770_/Q VGND VGND VPWR
+ VPWR g_row\[0\].g_col\[0\].pe__2424_/A sky130_fd_sc_hd__inv_2
Xg_row\[0\].g_col\[1\].pe__1385_ g_row\[0\].g_col\[1\].pe__2674_/D g_row\[0\].g_col\[1\].pe__1402_/B
+ VGND VGND VPWR VPWR g_row\[0\].g_col\[1\].pe__1385_/X sky130_fd_sc_hd__or2_2
Xg_row\[0\].g_col\[0\].pe_place869 g_row\[0\].g_col\[0\].pe__1474_/Y VGND VGND VPWR
+ VPWR g_row\[0\].g_col\[0\].pe__2247_/B1 sky130_fd_sc_hd__buf_6
XFILLER_2_138 VGND VGND VPWR VPWR sky130_fd_sc_hd__fill_2
Xg_row\[0\].g_col\[1\].pe__2006_ g_row\[0\].g_col\[1\].pe__2006_/A g_row\[0\].g_col\[1\].pe__2009_/B
+ VGND VGND VPWR VPWR g_row\[0\].g_col\[1\].pe__2151_/B sky130_fd_sc_hd__or2b_2
XFILLER_78_407 VGND VGND VPWR VPWR sky130_fd_sc_hd__fill_1
XTAP_TAPCELL_ROW_57_1064 VGND VPWR sky130_fd_sc_hd__tapvpwrvgnd_1
XTAP_TAPCELL_ROW_70_1253 VGND VPWR sky130_fd_sc_hd__tapvpwrvgnd_1
XTAP_TAPCELL_ROW_70_1264 VGND VPWR sky130_fd_sc_hd__tapvpwrvgnd_1
XFILLER_58_164 VGND VGND VPWR VPWR sky130_fd_sc_hd__fill_1
XFILLER_59_676 VGND VGND VPWR VPWR sky130_fd_sc_hd__fill_2
XFILLER_74_602 VGND VGND VPWR VPWR sky130_fd_sc_hd__decap_3
XFILLER_86_484 VGND VGND VPWR VPWR sky130_fd_sc_hd__fill_1
Xg_row\[1\].g_col\[1\].pe_place890 g_row\[1\].g_col\[1\].pe__1982_/B VGND VGND VPWR
+ VPWR g_row\[1\].g_col\[1\].pe__1732_/A2 sky130_fd_sc_hd__buf_6
XFILLER_82_690 VGND VGND VPWR VPWR sky130_fd_sc_hd__fill_1
XFILLER_14_234 VGND VGND VPWR VPWR sky130_fd_sc_hd__fill_2
XFILLER_15_757 VGND VGND VPWR VPWR sky130_fd_sc_hd__decap_3
Xg_row\[0\].g_col\[1\].pe_hold1973 g_row\[0\].g_col\[1\].pe_hold2173/X VGND VGND VPWR
+ VPWR g_row\[0\].g_col\[1\].pe__1389_/A sky130_fd_sc_hd__clkbuf_2
XFILLER_42_587 VGND VGND VPWR VPWR sky130_fd_sc_hd__fill_1
X_323_ _323_/CLK _323_/D VGND VGND VPWR VPWR _323_/Q sky130_fd_sc_hd__dfxtp_2
XFILLER_80_54 VGND VGND VPWR VPWR sky130_fd_sc_hd__fill_2
XFILLER_80_65 VGND VGND VPWR VPWR sky130_fd_sc_hd__fill_1
XFILLER_80_98 VGND VGND VPWR VPWR sky130_fd_sc_hd__decap_3
XFILLER_13_81 VGND VGND VPWR VPWR sky130_fd_sc_hd__fill_1
X_185_ _205_/A _185_/B_N VGND VGND VPWR VPWR _185_/Y sky130_fd_sc_hd__nor2b_4
XFILLER_6_477 VGND VGND VPWR VPWR sky130_fd_sc_hd__fill_2
Xg_row\[1\].g_col\[0\].pe__1780_ g_row\[1\].g_col\[0\].pe__1780_/A g_row\[1\].g_col\[0\].pe__1794_/A
+ VGND VGND VPWR VPWR g_row\[1\].g_col\[0\].pe__1780_/Y sky130_fd_sc_hd__nor2_2
Xg_row\[1\].g_col\[0\].pe__2401_ g_row\[1\].g_col\[0\].pe__2010_/A g_row\[1\].g_col\[0\].pe__2401_/A2
+ g_row\[1\].g_col\[0\].pe__2398_/X g_row\[1\].g_col\[0\].pe__2421_/A1 g_row\[1\].g_col\[0\].pe__2663_/A
+ VGND VGND VPWR VPWR g_row\[1\].g_col\[0\].pe__2402_/B sky130_fd_sc_hd__o32a_2
XFILLER_64_101 VGND VGND VPWR VPWR sky130_fd_sc_hd__fill_2
XFILLER_65_613 VGND VGND VPWR VPWR sky130_fd_sc_hd__decap_3
XTAP_TAPCELL_ROW_88_1525 VGND VPWR sky130_fd_sc_hd__tapvpwrvgnd_1
Xg_row\[1\].g_col\[0\].pe__2332_ g_row\[1\].g_col\[0\].pe__2304_/A g_row\[1\].g_col\[0\].pe__2304_/B
+ g_row\[1\].g_col\[0\].pe__2304_/C g_row\[1\].g_col\[0\].pe__2329_/Y g_row\[1\].g_col\[0\].pe__2305_/A
+ VGND VGND VPWR VPWR g_row\[1\].g_col\[0\].pe__2358_/A sky130_fd_sc_hd__a311o_4
XFILLER_37_337 VGND VGND VPWR VPWR sky130_fd_sc_hd__decap_3
XFILLER_65_635 VGND VGND VPWR VPWR sky130_fd_sc_hd__fill_1
XFILLER_65_657 VGND VGND VPWR VPWR sky130_fd_sc_hd__decap_3
XTAP_TAPCELL_ROW_88_1536 VGND VPWR sky130_fd_sc_hd__tapvpwrvgnd_1
Xg_row\[1\].g_col\[0\].pe__2263_ g_row\[1\].g_col\[0\].pe__2261_/Y g_row\[1\].g_col\[0\].pe__2263_/B
+ VGND VGND VPWR VPWR g_row\[1\].g_col\[0\].pe__2263_/X sky130_fd_sc_hd__and2b_2
XFILLER_18_595 VGND VGND VPWR VPWR sky130_fd_sc_hd__fill_1
Xg_row\[0\].g_col\[0\].pe__2410_ g_row\[0\].g_col\[0\].pe__2775_/A g_row\[0\].g_col\[0\].pe__2410_/B
+ VGND VGND VPWR VPWR g_row\[0\].g_col\[0\].pe__2499_/A sky130_fd_sc_hd__and2_2
Xg_row\[1\].g_col\[0\].pe__2194_ g_row\[1\].g_col\[0\].pe__2202_/A g_row\[1\].g_col\[0\].pe__2202_/B
+ VGND VGND VPWR VPWR g_row\[1\].g_col\[0\].pe__2231_/B sky130_fd_sc_hd__xor2_2
XFILLER_61_841 VGND VGND VPWR VPWR sky130_fd_sc_hd__fill_1
Xg_row\[0\].g_col\[0\].pe_hold3042 g_row\[0\].g_col\[0\].pe__1389_/A VGND VGND VPWR
+ VPWR g_row\[0\].g_col\[0\].pe__2658_/A2 sky130_fd_sc_hd__clkbuf_2
Xg_row\[0\].g_col\[0\].pe_hold3053 g_row\[0\].g_col\[0\].pe__2654_/X VGND VGND VPWR
+ VPWR g_row\[0\].g_col\[0\].pe_hold3053/X sky130_fd_sc_hd__clkbuf_2
Xg_row\[0\].g_col\[0\].pe_hold3064 g_row\[0\].g_col\[0\].pe__2736_/Q VGND VGND VPWR
+ VPWR g_row\[0\].g_col\[0\].pe__1401_/A1 sky130_fd_sc_hd__clkbuf_2
XFILLER_20_204 VGND VGND VPWR VPWR sky130_fd_sc_hd__fill_1
XFILLER_21_727 VGND VGND VPWR VPWR sky130_fd_sc_hd__fill_1
XFILLER_60_362 VGND VGND VPWR VPWR sky130_fd_sc_hd__fill_2
Xg_row\[0\].g_col\[0\].pe__2341_ g_row\[0\].g_col\[0\].pe__2388_/A g_row\[0\].g_col\[0\].pe__2341_/B
+ VGND VGND VPWR VPWR g_row\[0\].g_col\[0\].pe__2341_/Y sky130_fd_sc_hd__nand2_2
Xg_row\[0\].g_col\[0\].pe__2272_ g_row\[0\].g_col\[0\].pe__2257_/A g_row\[0\].g_col\[0\].pe__2272_/B
+ VGND VGND VPWR VPWR g_row\[0\].g_col\[0\].pe__2295_/B sky130_fd_sc_hd__and2b_2
Xg_row\[0\].g_col\[1\].pe_place955 g_row\[0\].g_col\[1\].pe__1801_/B VGND VGND VPWR
+ VPWR g_row\[0\].g_col\[1\].pe__1729_/B1 sky130_fd_sc_hd__buf_6
Xg_row\[0\].g_col\[1\].pe_place944 g_row\[0\].g_col\[1\].pe__1557_/A VGND VGND VPWR
+ VPWR g_row\[0\].g_col\[1\].pe__2364_/A sky130_fd_sc_hd__buf_6
Xg_row\[0\].g_col\[1\].pe_place966 g_row\[0\].g_col\[1\].pe__1389_/B VGND VGND VPWR
+ VPWR g_row\[0\].g_col\[1\].pe__1402_/B sky130_fd_sc_hd__buf_6
Xg_row\[1\].g_col\[1\].pe__1994_ g_row\[1\].g_col\[1\].pe__1994_/A g_row\[1\].g_col\[1\].pe__1994_/B
+ VGND VGND VPWR VPWR g_row\[1\].g_col\[1\].pe__1994_/Y sky130_fd_sc_hd__nor2_2
Xg_row\[1\].g_col\[0\].pe__1978_ g_row\[1\].g_col\[0\].pe__1978_/A g_row\[1\].g_col\[0\].pe__1978_/B
+ g_row\[1\].g_col\[0\].pe__1978_/C VGND VGND VPWR VPWR g_row\[1\].g_col\[0\].pe__1991_/A
+ sky130_fd_sc_hd__or3_4
Xoutput1410 output1410/A VGND VGND VPWR VPWR results_flat[5] sky130_fd_sc_hd__buf_2
Xhold3515 a_inputs_flat[20] VGND VGND VPWR VPWR hold3515/X sky130_fd_sc_hd__clkbuf_2
Xhold3504 hold3504/A VGND VGND VPWR VPWR hold3504/X sky130_fd_sc_hd__clkbuf_2
Xhold2803 hold2803/A VGND VGND VPWR VPWR _336_/D sky130_fd_sc_hd__clkbuf_2
Xhold2814 _203_/Y VGND VGND VPWR VPWR hold2814/X sky130_fd_sc_hd__clkbuf_2
Xhold3559 a_inputs_flat[13] VGND VGND VPWR VPWR hold3559/X sky130_fd_sc_hd__clkbuf_2
Xhold3548 hold3548/A VGND VGND VPWR VPWR hold3548/X sky130_fd_sc_hd__clkbuf_2
Xhold3537 hold3537/A VGND VGND VPWR VPWR hold3537/X sky130_fd_sc_hd__clkbuf_2
Xhold3526 hold3526/A VGND VGND VPWR VPWR hold3526/X sky130_fd_sc_hd__clkbuf_2
Xg_row\[1\].g_col\[1\].pe__2615_ g_row\[1\].g_col\[1\].pe__2626_/A1 place1093/X g_row\[1\].g_col\[1\].pe__2626_/B1
+ g_row\[1\].g_col\[1\].pe__2614_/X VGND VGND VPWR VPWR g_row\[1\].g_col\[1\].pe__2696_/D
+ sky130_fd_sc_hd__o211a_2
XTAP_TAPCELL_ROW_39_800 VGND VPWR sky130_fd_sc_hd__tapvpwrvgnd_1
Xg_row\[0\].g_col\[0\].pe__1987_ g_row\[0\].g_col\[0\].pe__1988_/B g_row\[0\].g_col\[0\].pe__1988_/C
+ g_row\[0\].g_col\[0\].pe__2043_/A VGND VGND VPWR VPWR g_row\[0\].g_col\[0\].pe__1987_/Y
+ sky130_fd_sc_hd__a21boi_2
Xg_row\[1\].g_col\[1\].pe__2546_ g_row\[1\].g_col\[1\].pe__2546_/A g_row\[1\].g_col\[1\].pe__2546_/B
+ VGND VGND VPWR VPWR g_row\[1\].g_col\[1\].pe__2546_/Y sky130_fd_sc_hd__nand2_2
XFILLER_83_410 VGND VGND VPWR VPWR sky130_fd_sc_hd__fill_2
XFILLER_83_421 VGND VGND VPWR VPWR sky130_fd_sc_hd__fill_2
Xg_row\[1\].g_col\[1\].pe__2477_ g_row\[1\].g_col\[1\].pe__2487_/B g_row\[1\].g_col\[1\].pe__2490_/A
+ g_row\[1\].g_col\[1\].pe__2487_/A VGND VGND VPWR VPWR g_row\[1\].g_col\[1\].pe__2579_/C
+ sky130_fd_sc_hd__o21ai_2
XFILLER_71_605 VGND VGND VPWR VPWR sky130_fd_sc_hd__decap_3
Xg_row\[1\].g_col\[1\].pe_place1040 g_row\[1\].g_col\[1\].pe__2694_/Q VGND VGND VPWR
+ VPWR g_row\[1\].g_col\[1\].pe__2019_/B2 sky130_fd_sc_hd__buf_6
Xg_row\[1\].g_col\[1\].pe__1428_ g_row\[1\].g_col\[1\].pe__1428_/A g_row\[1\].g_col\[1\].pe__1428_/B
+ VGND VGND VPWR VPWR g_row\[1\].g_col\[1\].pe__1428_/X sky130_fd_sc_hd__and2_2
XFILLER_43_329 VGND VGND VPWR VPWR sky130_fd_sc_hd__fill_2
XFILLER_71_627 VGND VGND VPWR VPWR sky130_fd_sc_hd__decap_3
Xg_row\[0\].g_col\[0\].pe__2608_ g_row\[0\].g_col\[0\].pe__2640_/A1 g_row\[0\].g_col\[0\].pe__2608_/A2
+ g_row\[0\].g_col\[0\].pe__2640_/C1 g_row\[0\].g_col\[0\].pe__2607_/X VGND VGND VPWR
+ VPWR g_row\[0\].g_col\[0\].pe__2608_/X sky130_fd_sc_hd__o211a_2
Xg_row\[1\].g_col\[1\].pe_place1051 g_row\[1\].g_col\[1\].pe__2640_/C1 VGND VGND VPWR
+ VPWR g_row\[1\].g_col\[1\].pe__2626_/B1 sky130_fd_sc_hd__buf_6
Xg_row\[0\].g_col\[1\].pe__2624_ g_row\[0\].g_col\[1\].pe__2624_/A1 place1201/X g_row\[0\].g_col\[1\].pe__2381_/A
+ g_row\[0\].g_col\[1\].pe__2624_/C1 VGND VGND VPWR VPWR g_row\[0\].g_col\[1\].pe__2624_/X
+ sky130_fd_sc_hd__o211a_2
XFILLER_51_340 VGND VGND VPWR VPWR sky130_fd_sc_hd__decap_3
Xg_row\[1\].g_col\[1\].pe__1359_ g_row\[1\].g_col\[1\].pe__2765_/Q g_row\[1\].g_col\[1\].pe__1359_/B
+ VGND VGND VPWR VPWR output1407/A sky130_fd_sc_hd__xor2_2
XFILLER_51_373 VGND VGND VPWR VPWR sky130_fd_sc_hd__fill_1
Xg_row\[0\].g_col\[0\].pe__2539_ g_row\[0\].g_col\[0\].pe__2538_/B g_row\[0\].g_col\[0\].pe__2538_/C
+ g_row\[0\].g_col\[0\].pe__2538_/A VGND VGND VPWR VPWR g_row\[0\].g_col\[0\].pe__2539_/X
+ sky130_fd_sc_hd__a21o_2
Xg_row\[0\].g_col\[1\].pe__2555_ g_row\[0\].g_col\[1\].pe__2592_/A g_row\[0\].g_col\[1\].pe__2555_/B
+ VGND VGND VPWR VPWR g_row\[0\].g_col\[1\].pe__2762_/D sky130_fd_sc_hd__and2_2
XFILLER_12_749 VGND VGND VPWR VPWR sky130_fd_sc_hd__decap_3
XFILLER_51_384 VGND VGND VPWR VPWR sky130_fd_sc_hd__fill_1
Xg_row\[0\].g_col\[1\].pe__1506_ g_row\[0\].g_col\[1\].pe__2599_/B g_row\[0\].g_col\[1\].pe__1549_/B
+ VGND VGND VPWR VPWR g_row\[0\].g_col\[1\].pe__1535_/B sky130_fd_sc_hd__nand2_2
Xg_row\[0\].g_col\[1\].pe_place1149 g_row\[0\].g_col\[1\].pe_hold2205/X VGND VGND
+ VPWR VPWR g_row\[0\].g_col\[1\].pe__2616_/B sky130_fd_sc_hd__buf_6
Xg_row\[0\].g_col\[1\].pe_place1138 g_row\[0\].g_col\[1\].pe__2703_/Q VGND VGND VPWR
+ VPWR g_row\[0\].g_col\[1\].pe__2121_/A sky130_fd_sc_hd__buf_6
Xg_row\[0\].g_col\[1\].pe_place1127 g_row\[0\].g_col\[1\].pe__2125_/C VGND VGND VPWR
+ VPWR g_row\[0\].g_col\[1\].pe__2094_/A sky130_fd_sc_hd__buf_6
Xg_row\[0\].g_col\[1\].pe_place1116 ANTENNA_146/DIODE VGND VGND VPWR VPWR g_row\[0\].g_col\[1\].pe__1348_/A
+ sky130_fd_sc_hd__buf_6
Xg_row\[0\].g_col\[1\].pe__2486_ g_row\[0\].g_col\[1\].pe__2509_/S g_row\[0\].g_col\[1\].pe__2486_/B
+ VGND VGND VPWR VPWR g_row\[0\].g_col\[1\].pe__2516_/B sky130_fd_sc_hd__or2_2
XFILLER_20_760 VGND VGND VPWR VPWR sky130_fd_sc_hd__fill_2
XFILLER_7_208 VGND VGND VPWR VPWR sky130_fd_sc_hd__decap_3
Xclkload2 clkload2/A VGND VGND VPWR VPWR clkload2/X sky130_fd_sc_hd__clkbuf_16
Xg_row\[0\].g_col\[1\].pe__1437_ g_row\[0\].g_col\[1\].pe__1707_/A g_row\[0\].g_col\[1\].pe__1437_/B
+ VGND VGND VPWR VPWR g_row\[0\].g_col\[1\].pe__1481_/B sky130_fd_sc_hd__xor2_2
Xg_row\[0\].g_col\[1\].pe__1368_ g_row\[0\].g_col\[1\].pe__2769_/Q g_row\[0\].g_col\[1\].pe__1368_/B
+ VGND VGND VPWR VPWR output1376/A sky130_fd_sc_hd__xnor2_2
XFILLER_3_425 VGND VGND VPWR VPWR sky130_fd_sc_hd__decap_3
XFILLER_79_727 VGND VGND VPWR VPWR sky130_fd_sc_hd__fill_1
XFILLER_79_749 VGND VGND VPWR VPWR sky130_fd_sc_hd__decap_3
XFILLER_75_21 VGND VGND VPWR VPWR sky130_fd_sc_hd__decap_3
XFILLER_19_337 VGND VGND VPWR VPWR sky130_fd_sc_hd__fill_2
XTAP_TAPCELL_ROW_6_296 VGND VPWR sky130_fd_sc_hd__tapvpwrvgnd_1
XFILLER_15_521 VGND VGND VPWR VPWR sky130_fd_sc_hd__fill_1
XFILLER_43_841 VGND VGND VPWR VPWR sky130_fd_sc_hd__fill_1
XTAP_TAPCELL_ROW_83_1455 VGND VPWR sky130_fd_sc_hd__tapvpwrvgnd_1
XFILLER_15_587 VGND VGND VPWR VPWR sky130_fd_sc_hd__decap_3
XFILLER_42_362 VGND VGND VPWR VPWR sky130_fd_sc_hd__fill_2
XFILLER_70_671 VGND VGND VPWR VPWR sky130_fd_sc_hd__decap_3
XFILLER_91_64 VGND VGND VPWR VPWR sky130_fd_sc_hd__fill_2
Xg_row\[0\].g_col\[1\].pe_hold1792 g_row\[0\].g_col\[1\].pe__2739_/Q VGND VGND VPWR
+ VPWR g_row\[0\].g_col\[1\].pe__1835_/A2 sky130_fd_sc_hd__clkbuf_2
XFILLER_15_598 VGND VGND VPWR VPWR sky130_fd_sc_hd__fill_1
XFILLER_42_395 VGND VGND VPWR VPWR sky130_fd_sc_hd__decap_3
XTAP_TAPCELL_ROW_25_582 VGND VPWR sky130_fd_sc_hd__tapvpwrvgnd_1
X_306_ _306_/CLK _306_/D VGND VGND VPWR VPWR _306_/Q sky130_fd_sc_hd__dfxtp_2
XFILLER_11_771 VGND VGND VPWR VPWR sky130_fd_sc_hd__decap_3
X_237_ _237_/A _237_/B_N VGND VGND VPWR VPWR _237_/Y sky130_fd_sc_hd__nor2b_4
Xg_row\[1\].g_col\[0\].pe__1901_ place1100/X g_row\[1\].g_col\[0\].pe__1901_/A2 g_row\[1\].g_col\[0\].pe__2177_/B1
+ g_row\[1\].g_col\[0\].pe__2605_/B VGND VGND VPWR VPWR g_row\[1\].g_col\[0\].pe__1905_/A
+ sky130_fd_sc_hd__a22o_2
Xg_row\[1\].g_col\[0\].pe__1832_ g_row\[1\].g_col\[0\].pe__1840_/A g_row\[1\].g_col\[0\].pe__1832_/B
+ g_row\[1\].g_col\[0\].pe__1832_/C VGND VGND VPWR VPWR g_row\[1\].g_col\[0\].pe__1832_/Y
+ sky130_fd_sc_hd__nand3_2
Xg_row\[1\].g_col\[0\].pe__1763_ place1104/A g_row\[1\].g_col\[0\].pe__1414_/X g_row\[1\].g_col\[0\].pe__1415_/Y
+ g_row\[1\].g_col\[0\].pe__1416_/X place1102/X VGND VGND VPWR VPWR g_row\[1\].g_col\[0\].pe__1764_/B
+ sky130_fd_sc_hd__a32o_2
Xg_row\[0\].g_col\[0\].pe__1910_ g_row\[0\].g_col\[0\].pe__1910_/A g_row\[0\].g_col\[0\].pe__1910_/B
+ VGND VGND VPWR VPWR g_row\[0\].g_col\[0\].pe__1955_/A sky130_fd_sc_hd__xor2_2
Xg_row\[1\].g_col\[0\].pe__1694_ g_row\[1\].g_col\[0\].pe__1695_/A g_row\[1\].g_col\[0\].pe__1695_/B
+ VGND VGND VPWR VPWR g_row\[1\].g_col\[0\].pe__1703_/B sky130_fd_sc_hd__xor2_2
XFILLER_27_3 VGND VGND VPWR VPWR sky130_fd_sc_hd__fill_2
XFILLER_78_760 VGND VGND VPWR VPWR sky130_fd_sc_hd__decap_3
Xg_row\[0\].g_col\[0\].pe__1841_ g_row\[0\].g_col\[0\].pe__1841_/A VGND VGND VPWR
+ VPWR g_row\[0\].g_col\[0\].pe__1843_/A sky130_fd_sc_hd__inv_2
XFILLER_77_281 VGND VGND VPWR VPWR sky130_fd_sc_hd__fill_1
XFILLER_93_741 VGND VGND VPWR VPWR sky130_fd_sc_hd__fill_2
Xg_row\[0\].g_col\[0\].pe__1772_ g_row\[0\].g_col\[0\].pe__1780_/A g_row\[0\].g_col\[0\].pe__1794_/A
+ VGND VGND VPWR VPWR g_row\[0\].g_col\[0\].pe__1813_/A sky130_fd_sc_hd__and2_2
Xg_row\[1\].g_col\[1\].pe__2331_ g_row\[1\].g_col\[1\].pe__2305_/A g_row\[1\].g_col\[1\].pe__2305_/B
+ g_row\[1\].g_col\[1\].pe__2329_/Y g_row\[1\].g_col\[1\].pe__2330_/X VGND VGND VPWR
+ VPWR g_row\[1\].g_col\[1\].pe__2331_/X sky130_fd_sc_hd__o211a_2
Xg_row\[1\].g_col\[0\].pe__2315_ g_row\[1\].g_col\[0\].pe__2316_/A g_row\[1\].g_col\[0\].pe__2316_/B
+ VGND VGND VPWR VPWR g_row\[1\].g_col\[0\].pe__2347_/A sky130_fd_sc_hd__and2_2
XFILLER_53_605 VGND VGND VPWR VPWR sky130_fd_sc_hd__decap_3
Xg_row\[1\].g_col\[1\].pe__2262_ g_row\[1\].g_col\[1\].pe__2262_/A g_row\[1\].g_col\[1\].pe__2262_/B
+ VGND VGND VPWR VPWR g_row\[1\].g_col\[1\].pe__2263_/B sky130_fd_sc_hd__nand2_2
Xg_row\[1\].g_col\[0\].pe__2246_ g_row\[1\].g_col\[0\].pe__2246_/A g_row\[1\].g_col\[0\].pe__2246_/B
+ VGND VGND VPWR VPWR g_row\[1\].g_col\[0\].pe__2273_/A sky130_fd_sc_hd__xnor2_2
XFILLER_34_841 VGND VGND VPWR VPWR sky130_fd_sc_hd__fill_1
XFILLER_80_468 VGND VGND VPWR VPWR sky130_fd_sc_hd__fill_1
Xg_row\[1\].g_col\[1\].pe__2193_ g_row\[1\].g_col\[1\].pe__2147_/A g_row\[1\].g_col\[1\].pe__2147_/B
+ g_row\[1\].g_col\[1\].pe__2192_/Y VGND VGND VPWR VPWR g_row\[1\].g_col\[1\].pe__2202_/B
+ sky130_fd_sc_hd__a21oi_4
Xg_row\[1\].g_col\[0\].pe__2177_ place1090/A g_row\[1\].g_col\[0\].pe__1558_/B g_row\[1\].g_col\[0\].pe__2177_/B1
+ g_row\[1\].g_col\[0\].pe__2616_/B VGND VGND VPWR VPWR g_row\[1\].g_col\[0\].pe__2213_/A
+ sky130_fd_sc_hd__a22o_2
XFILLER_33_351 VGND VGND VPWR VPWR sky130_fd_sc_hd__fill_1
XFILLER_61_671 VGND VGND VPWR VPWR sky130_fd_sc_hd__fill_1
XFILLER_21_524 VGND VGND VPWR VPWR sky130_fd_sc_hd__decap_3
Xg_row\[0\].g_col\[0\].pe__2324_ g_row\[0\].g_col\[0\].pe__2285_/A g_row\[0\].g_col\[0\].pe__2285_/B
+ g_row\[0\].g_col\[0\].pe__2284_/B VGND VGND VPWR VPWR g_row\[0\].g_col\[0\].pe__2338_/A
+ sky130_fd_sc_hd__a21oi_2
Xg_row\[0\].g_col\[0\].pe_hold2160 g_row\[0\].g_col\[0\].pe__1392_/A VGND VGND VPWR
+ VPWR g_row\[0\].g_col\[0\].pe__2660_/A2 sky130_fd_sc_hd__clkbuf_2
Xg_row\[0\].g_col\[1\].pe__2340_ g_row\[0\].g_col\[1\].pe__2630_/B g_row\[0\].g_col\[1\].pe__1558_/B
+ g_row\[0\].g_col\[1\].pe__2388_/B g_row\[0\].g_col\[1\].pe__2627_/B VGND VGND VPWR
+ VPWR g_row\[0\].g_col\[1\].pe__2343_/A sky130_fd_sc_hd__a22o_2
Xinput1319 hold3406/X VGND VGND VPWR VPWR hold3407/A sky130_fd_sc_hd__buf_2
Xinput1308 hold3224/X VGND VGND VPWR VPWR hold3225/A sky130_fd_sc_hd__buf_2
Xg_row\[0\].g_col\[1\].pe__2271_ g_row\[0\].g_col\[1\].pe__2271_/A g_row\[0\].g_col\[1\].pe__2271_/B
+ VGND VGND VPWR VPWR g_row\[0\].g_col\[1\].pe__2295_/A sky130_fd_sc_hd__nor2_2
Xg_row\[0\].g_col\[0\].pe__2255_ g_row\[0\].g_col\[0\].pe__2271_/A g_row\[0\].g_col\[0\].pe__2271_/B
+ VGND VGND VPWR VPWR g_row\[0\].g_col\[0\].pe__2257_/A sky130_fd_sc_hd__xnor2_2
Xg_row\[0\].g_col\[0\].pe__2186_ g_row\[0\].g_col\[0\].pe__2203_/B g_row\[0\].g_col\[0\].pe__2186_/B
+ VGND VGND VPWR VPWR g_row\[0\].g_col\[0\].pe__2190_/A sky130_fd_sc_hd__xor2_2
XFILLER_20_27 VGND VGND VPWR VPWR sky130_fd_sc_hd__fill_1
Xg_row\[1\].g_col\[1\].pe__1977_ g_row\[1\].g_col\[1\].pe__2734_/Q g_row\[1\].g_col\[1\].pe__1977_/B
+ VGND VGND VPWR VPWR g_row\[1\].g_col\[1\].pe__1978_/C sky130_fd_sc_hd__xnor2_2
XTAP_TAPCELL_ROW_54_1023 VGND VPWR sky130_fd_sc_hd__tapvpwrvgnd_1
Xhold3301 hold3301/A VGND VGND VPWR VPWR hold3301/X sky130_fd_sc_hd__clkbuf_2
Xhold3312 b_inputs_flat[17] VGND VGND VPWR VPWR hold3312/X sky130_fd_sc_hd__clkbuf_2
Xhold3323 hold3323/A VGND VGND VPWR VPWR hold3323/X sky130_fd_sc_hd__clkbuf_2
Xhold3334 hold3334/A VGND VGND VPWR VPWR hold3334/X sky130_fd_sc_hd__clkbuf_2
XFILLER_88_568 VGND VGND VPWR VPWR sky130_fd_sc_hd__fill_1
Xhold2600 hold3375/X VGND VGND VPWR VPWR hold3376/A sky130_fd_sc_hd__clkbuf_2
Xhold2611 hold2611/A VGND VGND VPWR VPWR _310_/D sky130_fd_sc_hd__clkbuf_2
Xhold2622 _229_/Y VGND VGND VPWR VPWR hold2622/X sky130_fd_sc_hd__clkbuf_2
Xhold3345 hold3345/A VGND VGND VPWR VPWR hold3345/X sky130_fd_sc_hd__clkbuf_2
Xhold3356 hold3356/A VGND VGND VPWR VPWR hold3356/X sky130_fd_sc_hd__clkbuf_2
Xhold3367 hold3367/A VGND VGND VPWR VPWR hold3367/X sky130_fd_sc_hd__clkbuf_2
Xhold2633 hold3353/X VGND VGND VPWR VPWR _155_/B_N sky130_fd_sc_hd__clkbuf_2
Xhold2644 hold3449/X VGND VGND VPWR VPWR hold3450/A sky130_fd_sc_hd__clkbuf_2
Xhold2655 hold3384/X VGND VGND VPWR VPWR hold3385/A sky130_fd_sc_hd__clkbuf_2
Xhold3378 hold3378/A VGND VGND VPWR VPWR hold3378/X sky130_fd_sc_hd__clkbuf_2
Xhold3389 b_inputs_flat[12] VGND VGND VPWR VPWR hold3389/X sky130_fd_sc_hd__clkbuf_2
XFILLER_56_410 VGND VGND VPWR VPWR sky130_fd_sc_hd__fill_2
XFILLER_56_421 VGND VGND VPWR VPWR sky130_fd_sc_hd__fill_1
XFILLER_84_741 VGND VGND VPWR VPWR sky130_fd_sc_hd__decap_3
Xhold2666 hold3424/X VGND VGND VPWR VPWR hold3425/A sky130_fd_sc_hd__clkbuf_2
Xhold2677 hold2677/A VGND VGND VPWR VPWR _313_/D sky130_fd_sc_hd__clkbuf_2
Xhold2688 _179_/Y VGND VGND VPWR VPWR hold2688/X sky130_fd_sc_hd__clkbuf_2
Xhold2699 hold3479/X VGND VGND VPWR VPWR _177_/B_N sky130_fd_sc_hd__clkbuf_2
Xg_row\[1\].g_col\[1\].pe__2529_ g_row\[1\].g_col\[1\].pe__2569_/A g_row\[1\].g_col\[1\].pe__2529_/B
+ VGND VGND VPWR VPWR g_row\[1\].g_col\[1\].pe__2758_/D sky130_fd_sc_hd__and2_2
Xg_row\[0\].g_col\[1\].pe__1986_ g_row\[0\].g_col\[1\].pe__1985_/B g_row\[0\].g_col\[1\].pe__1985_/C
+ g_row\[0\].g_col\[1\].pe__2094_/A VGND VGND VPWR VPWR g_row\[0\].g_col\[1\].pe__1988_/C
+ sky130_fd_sc_hd__a21bo_2
XFILLER_17_808 VGND VGND VPWR VPWR sky130_fd_sc_hd__fill_1
XFILLER_28_145 VGND VGND VPWR VPWR sky130_fd_sc_hd__fill_1
XFILLER_29_679 VGND VGND VPWR VPWR sky130_fd_sc_hd__fill_2
XTAP_TAPCELL_ROW_3_255 VGND VPWR sky130_fd_sc_hd__tapvpwrvgnd_1
Xhold1976 hold1976/A VGND VGND VPWR VPWR hold1976/X sky130_fd_sc_hd__clkbuf_2
XFILLER_56_498 VGND VGND VPWR VPWR sky130_fd_sc_hd__decap_3
XFILLER_25_841 VGND VGND VPWR VPWR sky130_fd_sc_hd__fill_1
XFILLER_43_126 VGND VGND VPWR VPWR sky130_fd_sc_hd__fill_1
XFILLER_43_148 VGND VGND VPWR VPWR sky130_fd_sc_hd__fill_1
XFILLER_45_57 VGND VGND VPWR VPWR sky130_fd_sc_hd__fill_1
XFILLER_71_457 VGND VGND VPWR VPWR sky130_fd_sc_hd__fill_2
Xg_row\[0\].g_col\[1\].pe__2607_ place1248/X g_row\[0\].g_col\[1\].pe__2607_/B VGND
+ VGND VPWR VPWR g_row\[0\].g_col\[1\].pe__2607_/X sky130_fd_sc_hd__or2_2
XTAP_TAPCELL_ROW_42_839 VGND VPWR sky130_fd_sc_hd__tapvpwrvgnd_1
XTAP_TAPCELL_ROW_65_1185 VGND VPWR sky130_fd_sc_hd__tapvpwrvgnd_1
Xg_row\[0\].g_col\[1\].pe__2538_ g_row\[0\].g_col\[1\].pe__2538_/A g_row\[0\].g_col\[1\].pe__2538_/B
+ g_row\[0\].g_col\[1\].pe__2538_/C VGND VGND VPWR VPWR g_row\[0\].g_col\[1\].pe__2544_/B
+ sky130_fd_sc_hd__nand3_2
XTAP_TAPCELL_ROW_22_541 VGND VPWR sky130_fd_sc_hd__tapvpwrvgnd_1
Xg_row\[0\].g_col\[1\].pe__2469_ g_row\[0\].g_col\[1\].pe__2439_/Y g_row\[0\].g_col\[1\].pe__2763_/Q
+ VGND VGND VPWR VPWR g_row\[0\].g_col\[1\].pe__2496_/B sky130_fd_sc_hd__and2b_2
XFILLER_4_701 VGND VGND VPWR VPWR sky130_fd_sc_hd__decap_3
XFILLER_6_29 VGND VGND VPWR VPWR sky130_fd_sc_hd__fill_1
Xg_row\[1\].g_col\[0\].pe_hold3009 hold2019/X VGND VGND VPWR VPWR g_row\[1\].g_col\[0\].pe__2662_/A2
+ sky130_fd_sc_hd__clkbuf_2
XFILLER_86_75 VGND VGND VPWR VPWR sky130_fd_sc_hd__fill_1
XFILLER_47_465 VGND VGND VPWR VPWR sky130_fd_sc_hd__decap_3
XFILLER_47_487 VGND VGND VPWR VPWR sky130_fd_sc_hd__decap_3
XFILLER_47_498 VGND VGND VPWR VPWR sky130_fd_sc_hd__decap_3
XFILLER_75_785 VGND VGND VPWR VPWR sky130_fd_sc_hd__fill_2
Xg_row\[1\].g_col\[0\].pe__2100_ g_row\[1\].g_col\[0\].pe__2099_/A g_row\[1\].g_col\[0\].pe__2184_/B
+ g_row\[1\].g_col\[0\].pe__2099_/C VGND VGND VPWR VPWR g_row\[1\].g_col\[0\].pe__2101_/C
+ sky130_fd_sc_hd__a21oi_2
XFILLER_16_841 VGND VGND VPWR VPWR sky130_fd_sc_hd__fill_1
Xg_row\[1\].g_col\[0\].pe__2031_ g_row\[1\].g_col\[0\].pe__1461_/A g_row\[1\].g_col\[0\].pe__1461_/B
+ place1086/A VGND VGND VPWR VPWR g_row\[1\].g_col\[0\].pe__2032_/C sky130_fd_sc_hd__a21bo_2
XFILLER_34_159 VGND VGND VPWR VPWR sky130_fd_sc_hd__decap_3
XFILLER_35_90 VGND VGND VPWR VPWR sky130_fd_sc_hd__fill_2
XFILLER_30_365 VGND VGND VPWR VPWR sky130_fd_sc_hd__fill_1
Xg_row\[0\].g_col\[0\].pe__2040_ g_row\[0\].g_col\[0\].pe__2045_/A g_row\[0\].g_col\[0\].pe__2727_/Q
+ g_row\[0\].g_col\[1\].pe__2635_/C VGND VGND VPWR VPWR g_row\[0\].g_col\[0\].pe__2040_/X
+ sky130_fd_sc_hd__or3b_4
Xg_row\[1\].g_col\[1\].pe__1900_ g_row\[1\].g_col\[1\].pe__1868_/A g_row\[1\].g_col\[1\].pe__1868_/B
+ g_row\[1\].g_col\[1\].pe__1899_/X VGND VGND VPWR VPWR g_row\[1\].g_col\[1\].pe__1907_/A
+ sky130_fd_sc_hd__a21o_2
Xplace1205 place1205/A VGND VGND VPWR VPWR place1205/X sky130_fd_sc_hd__buf_6
Xplace1216 hold3118/X VGND VGND VPWR VPWR place1216/X sky130_fd_sc_hd__buf_6
Xg_row\[1\].g_col\[1\].pe__1831_ g_row\[1\].g_col\[1\].pe__1831_/A g_row\[1\].g_col\[1\].pe__1831_/B
+ VGND VGND VPWR VPWR g_row\[1\].g_col\[1\].pe__1832_/C sky130_fd_sc_hd__nand2_2
Xplace1249 place1250/X VGND VGND VPWR VPWR place1249/X sky130_fd_sc_hd__buf_6
Xg_row\[1\].g_col\[0\].pe__1815_ g_row\[1\].g_col\[0\].pe__1815_/A g_row\[1\].g_col\[0\].pe__1815_/B
+ VGND VGND VPWR VPWR g_row\[1\].g_col\[0\].pe__1822_/D sky130_fd_sc_hd__xnor2_2
Xg_row\[1\].g_col\[1\].pe__1762_ g_row\[1\].g_col\[1\].pe__1808_/A g_row\[1\].g_col\[1\].pe__1762_/B
+ VGND VGND VPWR VPWR g_row\[1\].g_col\[1\].pe__1766_/A sky130_fd_sc_hd__xnor2_2
Xg_row\[1\].g_col\[0\].pe__1746_ g_row\[1\].g_col\[0\].pe__1819_/A g_row\[1\].g_col\[0\].pe__1819_/B
+ VGND VGND VPWR VPWR g_row\[1\].g_col\[0\].pe__1820_/B sky130_fd_sc_hd__nor2_2
Xg_row\[1\].g_col\[1\].pe__1693_ g_row\[1\].g_col\[1\].pe__1693_/A g_row\[1\].g_col\[1\].pe__1693_/B
+ VGND VGND VPWR VPWR g_row\[1\].g_col\[1\].pe__1695_/B sky130_fd_sc_hd__xor2_2
Xg_row\[1\].g_col\[0\].pe_hold2831 g_row\[1\].g_col\[0\].pe__2649_/X VGND VGND VPWR
+ VPWR g_row\[1\].g_col\[0\].pe__2650_/C1 sky130_fd_sc_hd__clkbuf_2
Xg_row\[1\].g_col\[0\].pe_hold2820 g_row\[1\].g_col\[0\].pe__2647_/X VGND VGND VPWR
+ VPWR g_row\[1\].g_col\[0\].pe__2648_/C1 sky130_fd_sc_hd__clkbuf_2
Xg_row\[1\].g_col\[0\].pe__1677_ g_row\[1\].g_col\[0\].pe__1823_/A g_row\[1\].g_col\[0\].pe__1677_/B
+ VGND VGND VPWR VPWR g_row\[1\].g_col\[0\].pe__1703_/A sky130_fd_sc_hd__or2_2
XFILLER_38_421 VGND VGND VPWR VPWR sky130_fd_sc_hd__decap_3
Xg_row\[0\].g_col\[0\].pe__1824_ g_row\[0\].g_col\[0\].pe__1726_/B g_row\[0\].g_col\[0\].pe__1824_/B
+ VGND VGND VPWR VPWR g_row\[0\].g_col\[0\].pe__1824_/X sky130_fd_sc_hd__and2b_2
Xg_row\[1\].g_col\[0\].pe_hold2853 g_row\[1\].g_col\[0\].pe_hold2853/A VGND VGND VPWR
+ VPWR g_row\[1\].g_col\[0\].pe__2706_/D sky130_fd_sc_hd__clkbuf_2
Xg_row\[0\].g_col\[1\].pe__1840_ g_row\[0\].g_col\[1\].pe__1840_/A g_row\[0\].g_col\[1\].pe__1840_/B
+ VGND VGND VPWR VPWR g_row\[0\].g_col\[1\].pe__1841_/A sky130_fd_sc_hd__nor2_2
XTAP_TAPCELL_ROW_0_203 VGND VPWR sky130_fd_sc_hd__tapvpwrvgnd_1
XTAP_TAPCELL_ROW_49_950 VGND VPWR sky130_fd_sc_hd__tapvpwrvgnd_1
XTAP_TAPCELL_ROW_0_214 VGND VPWR sky130_fd_sc_hd__tapvpwrvgnd_1
Xg_row\[0\].g_col\[0\].pe__1755_ g_row\[0\].g_col\[0\].pe__1768_/A g_row\[0\].g_col\[0\].pe__1755_/B
+ VGND VGND VPWR VPWR g_row\[0\].g_col\[0\].pe__1770_/B sky130_fd_sc_hd__xor2_2
Xg_row\[1\].g_col\[1\].pe__2314_ g_row\[1\].g_col\[1\].pe__2364_/A g_row\[1\].g_col\[1\].pe__2314_/B
+ VGND VGND VPWR VPWR g_row\[1\].g_col\[1\].pe__2316_/B sky130_fd_sc_hd__xnor2_2
Xg_row\[0\].g_col\[1\].pe__1771_ g_row\[0\].g_col\[1\].pe__1793_/B g_row\[0\].g_col\[1\].pe__1793_/C
+ g_row\[0\].g_col\[1\].pe__1793_/A VGND VGND VPWR VPWR g_row\[0\].g_col\[1\].pe__1794_/A
+ sky130_fd_sc_hd__a21oi_2
XFILLER_81_744 VGND VGND VPWR VPWR sky130_fd_sc_hd__fill_1
Xg_row\[0\].g_col\[0\].pe__1686_ g_row\[0\].g_col\[0\].pe__1686_/A g_row\[0\].g_col\[0\].pe__1686_/B
+ VGND VGND VPWR VPWR g_row\[0\].g_col\[0\].pe__1686_/X sky130_fd_sc_hd__and2_2
Xg_row\[1\].g_col\[1\].pe__2245_ g_row\[1\].g_col\[1\].pe__2288_/A g_row\[1\].g_col\[1\].pe__2288_/B
+ VGND VGND VPWR VPWR g_row\[1\].g_col\[1\].pe__2246_/B sky130_fd_sc_hd__xnor2_2
Xg_row\[1\].g_col\[0\].pe__2229_ g_row\[1\].g_col\[0\].pe__2262_/A g_row\[1\].g_col\[0\].pe__2229_/B
+ VGND VGND VPWR VPWR g_row\[1\].g_col\[0\].pe__2238_/B sky130_fd_sc_hd__and2_2
XFILLER_22_811 VGND VGND VPWR VPWR sky130_fd_sc_hd__fill_1
XFILLER_40_129 VGND VGND VPWR VPWR sky130_fd_sc_hd__fill_1
Xg_row\[1\].g_col\[1\].pe__2176_ g_row\[1\].g_col\[1\].pe__2175_/X g_row\[1\].g_col\[1\].pe__2132_/B
+ g_row\[1\].g_col\[1\].pe__2129_/B VGND VGND VPWR VPWR g_row\[1\].g_col\[1\].pe__2181_/A
+ sky130_fd_sc_hd__a21o_2
XFILLER_33_192 VGND VGND VPWR VPWR sky130_fd_sc_hd__decap_3
Xclkbuf_leaf_60_clk clkload7/A VGND VGND VPWR VPWR clkbuf_leaf_60_clk/X sky130_fd_sc_hd__clkbuf_16
Xg_row\[0\].g_col\[1\].pe__2323_ g_row\[0\].g_col\[1\].pe__2337_/A g_row\[0\].g_col\[1\].pe__2323_/B
+ VGND VGND VPWR VPWR g_row\[0\].g_col\[1\].pe__2325_/A sky130_fd_sc_hd__xnor2_2
Xg_row\[0\].g_col\[0\].pe__2307_ g_row\[0\].g_col\[0\].pe__2335_/A g_row\[0\].g_col\[0\].pe__2307_/B
+ VGND VGND VPWR VPWR g_row\[0\].g_col\[0\].pe__2749_/D sky130_fd_sc_hd__nor2_2
Xg_row\[0\].g_col\[0\].pe__2238_ g_row\[0\].g_col\[0\].pe__2238_/A g_row\[0\].g_col\[0\].pe__2238_/B
+ VGND VGND VPWR VPWR g_row\[0\].g_col\[0\].pe__2238_/X sky130_fd_sc_hd__and2_2
Xg_row\[0\].g_col\[1\].pe__2254_ g_row\[0\].g_col\[1\].pe__2221_/A g_row\[0\].g_col\[1\].pe__2221_/B
+ g_row\[0\].g_col\[1\].pe__2253_/Y VGND VGND VPWR VPWR g_row\[0\].g_col\[1\].pe__2271_/B
+ sky130_fd_sc_hd__o21a_2
Xg_row\[0\].g_col\[1\].pe__2185_ g_row\[0\].g_col\[1\].pe__2184_/X g_row\[0\].g_col\[1\].pe__2144_/B
+ g_row\[0\].g_col\[1\].pe__2135_/A VGND VGND VPWR VPWR g_row\[0\].g_col\[1\].pe__2186_/B
+ sky130_fd_sc_hd__o21a_2
XPHY_EDGE_ROW_1_Right_1 VGND VGND VPWR VPWR sky130_fd_sc_hd__decap_3
Xg_row\[0\].g_col\[0\].pe__2169_ g_row\[0\].g_col\[0\].pe__2167_/X g_row\[0\].g_col\[0\].pe__2169_/B
+ VGND VGND VPWR VPWR g_row\[0\].g_col\[0\].pe__2172_/A sky130_fd_sc_hd__and2b_2
XTAP_TAPCELL_ROW_8_325 VGND VPWR sky130_fd_sc_hd__tapvpwrvgnd_1
XTAP_TAPCELL_ROW_8_336 VGND VPWR sky130_fd_sc_hd__tapvpwrvgnd_1
Xg_row\[1\].g_col\[1\].pe_hold1737 g_row\[1\].g_col\[1\].pe__2587_/X VGND VGND VPWR
+ VPWR g_row\[1\].g_col\[1\].pe__2588_/B sky130_fd_sc_hd__clkbuf_2
Xg_row\[1\].g_col\[1\].pe_hold1715 g_row\[1\].g_col\[1\].pe__2360_/X VGND VGND VPWR
+ VPWR g_row\[1\].g_col\[1\].pe__2361_/B sky130_fd_sc_hd__clkbuf_2
Xhold3131 hold3131/A VGND VGND VPWR VPWR hold3131/X sky130_fd_sc_hd__clkbuf_2
Xhold3142 hold3142/A VGND VGND VPWR VPWR hold3142/X sky130_fd_sc_hd__clkbuf_2
Xhold2430 _205_/Y VGND VGND VPWR VPWR hold2430/X sky130_fd_sc_hd__clkbuf_2
Xhold3153 hold3153/A VGND VGND VPWR VPWR hold3153/X sky130_fd_sc_hd__clkbuf_2
Xhold3164 hold3164/A VGND VGND VPWR VPWR hold3164/X sky130_fd_sc_hd__clkbuf_2
Xhold3175 hold3175/A VGND VGND VPWR VPWR hold3175/X sky130_fd_sc_hd__clkbuf_2
XFILLER_29_410 VGND VGND VPWR VPWR sky130_fd_sc_hd__fill_1
Xhold2441 hold3185/X VGND VGND VPWR VPWR _245_/B_N sky130_fd_sc_hd__clkbuf_2
Xhold2452 hold3211/X VGND VGND VPWR VPWR hold3212/A sky130_fd_sc_hd__clkbuf_2
Xhold2463 hold3160/X VGND VGND VPWR VPWR hold3161/A sky130_fd_sc_hd__clkbuf_2
Xhold3186 b_inputs_flat[18] VGND VGND VPWR VPWR hold3186/X sky130_fd_sc_hd__clkbuf_2
Xhold3197 hold3197/A VGND VGND VPWR VPWR hold3197/X sky130_fd_sc_hd__clkbuf_2
XTAP_TAPCELL_ROW_47_909 VGND VPWR sky130_fd_sc_hd__tapvpwrvgnd_1
Xhold2474 hold3214/X VGND VGND VPWR VPWR hold3215/A sky130_fd_sc_hd__clkbuf_2
Xhold2485 hold2485/A VGND VGND VPWR VPWR _317_/D sky130_fd_sc_hd__clkbuf_2
Xhold2496 _225_/Y VGND VGND VPWR VPWR hold2496/X sky130_fd_sc_hd__clkbuf_2
XFILLER_17_638 VGND VGND VPWR VPWR sky130_fd_sc_hd__fill_2
XFILLER_44_402 VGND VGND VPWR VPWR sky130_fd_sc_hd__decap_3
XTAP_TAPCELL_ROW_27_611 VGND VPWR sky130_fd_sc_hd__tapvpwrvgnd_1
XTAP_TAPCELL_ROW_67_1214 VGND VPWR sky130_fd_sc_hd__tapvpwrvgnd_1
Xhold1795 hold1795/A VGND VGND VPWR VPWR hold1795/X sky130_fd_sc_hd__clkbuf_2
Xg_row\[0\].g_col\[1\].pe__1969_ g_row\[0\].g_col\[1\].pe__1968_/B g_row\[0\].g_col\[1\].pe__1968_/C
+ g_row\[0\].g_col\[1\].pe__2167_/A VGND VGND VPWR VPWR g_row\[0\].g_col\[1\].pe__1974_/B
+ sky130_fd_sc_hd__a21bo_2
XFILLER_71_221 VGND VGND VPWR VPWR sky130_fd_sc_hd__decap_3
XFILLER_72_766 VGND VGND VPWR VPWR sky130_fd_sc_hd__decap_3
XTAP_TAPCELL_ROW_27_622 VGND VPWR sky130_fd_sc_hd__tapvpwrvgnd_1
XTAP_TAPCELL_ROW_80_1403 VGND VPWR sky130_fd_sc_hd__tapvpwrvgnd_1
XTAP_TAPCELL_ROW_80_1414 VGND VPWR sky130_fd_sc_hd__tapvpwrvgnd_1
Xclkbuf_leaf_51_clk clkload8/A VGND VGND VPWR VPWR clkbuf_leaf_51_clk/X sky130_fd_sc_hd__clkbuf_16
XFILLER_8_336 VGND VGND VPWR VPWR sky130_fd_sc_hd__decap_3
XFILLER_4_531 VGND VGND VPWR VPWR sky130_fd_sc_hd__fill_1
XTAP_TAPCELL_ROW_78_1376 VGND VPWR sky130_fd_sc_hd__tapvpwrvgnd_1
XTAP_TAPCELL_ROW_78_1387 VGND VPWR sky130_fd_sc_hd__tapvpwrvgnd_1
Xg_row\[1\].g_col\[0\].pe__2580_ g_row\[1\].g_col\[0\].pe__2479_/X g_row\[1\].g_col\[0\].pe__2579_/Y
+ g_row\[1\].g_col\[0\].pe__2590_/A VGND VGND VPWR VPWR g_row\[1\].g_col\[0\].pe__2580_/X
+ sky130_fd_sc_hd__a21o_2
Xg_row\[1\].g_col\[0\].pe__1531_ g_row\[1\].g_col\[0\].pe__1676_/A g_row\[1\].g_col\[0\].pe__1531_/B
+ VGND VGND VPWR VPWR g_row\[1\].g_col\[0\].pe__1555_/B sky130_fd_sc_hd__xnor2_2
XFILLER_67_505 VGND VGND VPWR VPWR sky130_fd_sc_hd__fill_1
XTAP_TAPCELL_ROW_91_1576 VGND VPWR sky130_fd_sc_hd__tapvpwrvgnd_1
XFILLER_47_240 VGND VGND VPWR VPWR sky130_fd_sc_hd__fill_1
Xg_row\[1\].g_col\[0\].pe__1393_ g_row\[1\].g_col\[0\].pe__2250_/A g_row\[1\].g_col\[0\].pe__2679_/A2
+ g_row\[1\].g_col\[0\].pe__1393_/B1 g_row\[1\].g_col\[0\].pe__1403_/C1 VGND VGND
+ VPWR VPWR g_row\[1\].g_col\[0\].pe__1393_/X sky130_fd_sc_hd__o211a_2
XFILLER_47_273 VGND VGND VPWR VPWR sky130_fd_sc_hd__decap_3
XFILLER_47_284 VGND VGND VPWR VPWR sky130_fd_sc_hd__decap_3
XFILLER_75_593 VGND VGND VPWR VPWR sky130_fd_sc_hd__fill_2
Xg_row\[0\].g_col\[0\].pe__1540_ g_row\[0\].g_col\[0\].pe__2736_/Q g_row\[0\].g_col\[0\].pe__2735_/Q
+ g_row\[0\].g_col\[0\].pe__2734_/Q VGND VGND VPWR VPWR g_row\[0\].g_col\[0\].pe__1540_/X
+ sky130_fd_sc_hd__and3b_2
Xg_row\[1\].g_col\[1\].pe__2030_ g_row\[1\].g_col\[1\].pe__2030_/A g_row\[1\].g_col\[1\].pe__2163_/B
+ VGND VGND VPWR VPWR g_row\[1\].g_col\[1\].pe__2032_/B sky130_fd_sc_hd__nand2_2
XFILLER_22_129 VGND VGND VPWR VPWR sky130_fd_sc_hd__fill_1
Xg_row\[0\].g_col\[0\].pe__1471_ g_row\[0\].g_col\[0\].pe__1471_/A g_row\[0\].g_col\[0\].pe__1471_/B
+ VGND VGND VPWR VPWR g_row\[0\].g_col\[0\].pe__1471_/X sky130_fd_sc_hd__and2_2
Xg_row\[1\].g_col\[0\].pe__2014_ g_row\[1\].g_col\[0\].pe__2001_/B g_row\[1\].g_col\[0\].pe__2014_/B
+ VGND VGND VPWR VPWR g_row\[1\].g_col\[0\].pe__2014_/X sky130_fd_sc_hd__and2b_2
Xclkbuf_leaf_42_clk clkbuf_4_12_0_clk/X VGND VGND VPWR VPWR _306_/CLK sky130_fd_sc_hd__clkbuf_16
XFILLER_30_173 VGND VGND VPWR VPWR sky130_fd_sc_hd__fill_1
Xg_row\[0\].g_col\[0\].pe__2023_ g_row\[0\].g_col\[0\].pe__2023_/A g_row\[0\].g_col\[0\].pe__2023_/B
+ VGND VGND VPWR VPWR g_row\[0\].g_col\[0\].pe__2024_/B sky130_fd_sc_hd__xor2_2
Xg_row\[1\].g_col\[1\].pe__1814_ g_row\[1\].g_col\[1\].pe__1779_/Y g_row\[1\].g_col\[1\].pe__1812_/X
+ g_row\[1\].g_col\[1\].pe__1813_/Y VGND VGND VPWR VPWR g_row\[1\].g_col\[1\].pe__1821_/B
+ sky130_fd_sc_hd__o21ai_2
Xg_row\[1\].g_col\[1\].pe__1745_ g_row\[1\].g_col\[1\].pe__1745_/A g_row\[1\].g_col\[1\].pe__1745_/B
+ VGND VGND VPWR VPWR g_row\[1\].g_col\[1\].pe__1819_/B sky130_fd_sc_hd__xnor2_2
Xg_row\[1\].g_col\[0\].pe__1729_ place1100/A g_row\[1\].g_col\[0\].pe__1729_/A2 g_row\[1\].g_col\[0\].pe__1729_/A3
+ g_row\[1\].g_col\[0\].pe__1729_/B1 place1098/X VGND VGND VPWR VPWR g_row\[1\].g_col\[0\].pe__1730_/B
+ sky130_fd_sc_hd__a32o_2
XFILLER_58_527 VGND VGND VPWR VPWR sky130_fd_sc_hd__decap_3
Xg_row\[1\].g_col\[1\].pe__1676_ g_row\[1\].g_col\[1\].pe__1676_/A g_row\[1\].g_col\[1\].pe__1676_/B
+ VGND VGND VPWR VPWR g_row\[1\].g_col\[1\].pe__1677_/B sky130_fd_sc_hd__and2_2
XFILLER_39_785 VGND VGND VPWR VPWR sky130_fd_sc_hd__fill_1
XFILLER_54_711 VGND VGND VPWR VPWR sky130_fd_sc_hd__fill_2
XFILLER_66_560 VGND VGND VPWR VPWR sky130_fd_sc_hd__decap_3
XFILLER_66_582 VGND VGND VPWR VPWR sky130_fd_sc_hd__decap_3
Xg_row\[0\].g_col\[0\].pe__1807_ g_row\[0\].g_col\[0\].pe__1807_/A g_row\[0\].g_col\[0\].pe__1807_/B
+ VGND VGND VPWR VPWR g_row\[0\].g_col\[0\].pe__1811_/C sky130_fd_sc_hd__nand2_2
Xg_row\[0\].g_col\[1\].pe__1823_ g_row\[0\].g_col\[1\].pe__1823_/A g_row\[0\].g_col\[1\].pe__1823_/B
+ VGND VGND VPWR VPWR g_row\[0\].g_col\[1\].pe__1828_/A sky130_fd_sc_hd__xnor2_2
XFILLER_26_37 VGND VGND VPWR VPWR sky130_fd_sc_hd__fill_1
Xg_row\[0\].g_col\[0\].pe__1738_ place1220/X g_row\[0\].g_col\[0\].pe__1748_/B g_row\[0\].g_col\[0\].pe__1738_/B1
+ place1221/X VGND VGND VPWR VPWR g_row\[0\].g_col\[0\].pe__1739_/B sky130_fd_sc_hd__a22o_2
Xg_row\[0\].g_col\[1\].pe__1754_ g_row\[0\].g_col\[1\].pe__1805_/A2 g_row\[0\].g_col\[1\].pe__1982_/B
+ g_row\[0\].g_col\[1\].pe__1424_/Y g_row\[0\].g_col\[1\].pe__1801_/A VGND VGND VPWR
+ VPWR g_row\[0\].g_col\[1\].pe__1755_/B sky130_fd_sc_hd__a22o_2
XFILLER_53_265 VGND VGND VPWR VPWR sky130_fd_sc_hd__fill_2
XFILLER_53_287 VGND VGND VPWR VPWR sky130_fd_sc_hd__decap_3
Xg_row\[0\].g_col\[0\].pe__1669_ g_row\[0\].g_col\[0\].pe__1669_/A g_row\[0\].g_col\[0\].pe__1669_/B
+ VGND VGND VPWR VPWR g_row\[0\].g_col\[0\].pe__1831_/B sky130_fd_sc_hd__xnor2_2
Xg_row\[0\].g_col\[1\].pe__1685_ g_row\[0\].g_col\[1\].pe__1789_/A g_row\[0\].g_col\[1\].pe__1685_/B
+ VGND VGND VPWR VPWR g_row\[0\].g_col\[1\].pe__1713_/B sky130_fd_sc_hd__xor2_2
Xg_row\[1\].g_col\[1\].pe__2228_ g_row\[1\].g_col\[1\].pe__2228_/A g_row\[1\].g_col\[1\].pe__2228_/B
+ g_row\[1\].g_col\[1\].pe__2228_/C VGND VGND VPWR VPWR g_row\[1\].g_col\[1\].pe__2229_/B
+ sky130_fd_sc_hd__or3_2
XTAP_TAPCELL_ROW_62_1133 VGND VPWR sky130_fd_sc_hd__tapvpwrvgnd_1
XTAP_TAPCELL_ROW_62_1144 VGND VPWR sky130_fd_sc_hd__tapvpwrvgnd_1
Xclkbuf_leaf_33_clk clkbuf_4_6_0_clk/X VGND VGND VPWR VPWR _319_/CLK sky130_fd_sc_hd__clkbuf_16
Xg_row\[1\].g_col\[1\].pe__2159_ g_row\[1\].g_col\[1\].pe__2396_/A g_row\[1\].g_col\[1\].pe__2159_/B
+ VGND VGND VPWR VPWR g_row\[1\].g_col\[1\].pe__2745_/D sky130_fd_sc_hd__nor2_2
XFILLER_21_140 VGND VGND VPWR VPWR sky130_fd_sc_hd__decap_3
XTAP_TAPCELL_ROW_52_989 VGND VPWR sky130_fd_sc_hd__tapvpwrvgnd_1
XFILLER_6_807 VGND VGND VPWR VPWR sky130_fd_sc_hd__decap_3
XTAP_TAPCELL_ROW_32_691 VGND VPWR sky130_fd_sc_hd__tapvpwrvgnd_1
Xg_row\[0\].g_col\[1\].pe__2306_ g_row\[0\].g_col\[1\].pe__2406_/B1 g_row\[0\].g_col\[1\].pe__2306_/A2
+ g_row\[0\].g_col\[1\].pe__2404_/B2 g_row\[0\].g_col\[1\].pe__2305_/Y VGND VGND VPWR
+ VPWR g_row\[0\].g_col\[1\].pe__2306_/X sky130_fd_sc_hd__o22a_2
XFILLER_5_306 VGND VGND VPWR VPWR sky130_fd_sc_hd__fill_2
Xg_row\[0\].g_col\[1\].pe__2237_ g_row\[0\].g_col\[1\].pe__2405_/A g_row\[0\].g_col\[1\].pe__2237_/B
+ VGND VGND VPWR VPWR g_row\[0\].g_col\[1\].pe__2747_/D sky130_fd_sc_hd__nor2_2
Xg_row\[1\].g_col\[1\].pe_hold2246 g_row\[1\].g_col\[1\].pe_hold3119/X VGND VGND VPWR
+ VPWR g_row\[1\].g_col\[1\].pe__2643_/B sky130_fd_sc_hd__clkbuf_2
Xg_row\[0\].g_col\[1\].pe__2168_ g_row\[0\].g_col\[1\].pe__2167_/B g_row\[0\].g_col\[1\].pe__2167_/C
+ g_row\[0\].g_col\[1\].pe__2167_/A VGND VGND VPWR VPWR g_row\[0\].g_col\[1\].pe__2169_/B
+ sky130_fd_sc_hd__a21o_2
Xg_row\[0\].g_col\[1\].pe__2099_ g_row\[0\].g_col\[1\].pe__2099_/A g_row\[0\].g_col\[1\].pe__2184_/B
+ g_row\[0\].g_col\[1\].pe__2099_/C VGND VGND VPWR VPWR g_row\[0\].g_col\[1\].pe__2145_/A
+ sky130_fd_sc_hd__and3_4
XFILLER_67_22 VGND VGND VPWR VPWR sky130_fd_sc_hd__decap_3
XFILLER_89_663 VGND VGND VPWR VPWR sky130_fd_sc_hd__fill_2
XFILLER_29_240 VGND VGND VPWR VPWR sky130_fd_sc_hd__decap_3
Xhold1570 hold3474/X VGND VGND VPWR VPWR hold3475/A sky130_fd_sc_hd__clkbuf_2
XFILLER_45_733 VGND VGND VPWR VPWR sky130_fd_sc_hd__fill_1
Xhold1581 hold2730/X VGND VGND VPWR VPWR hold2731/A sky130_fd_sc_hd__clkbuf_2
Xhold1592 hold3415/X VGND VGND VPWR VPWR hold3416/A sky130_fd_sc_hd__clkbuf_2
Xg_row\[1\].g_col\[0\].pe_place931 g_row\[1\].g_col\[0\].pe__1838_/A VGND VGND VPWR
+ VPWR g_row\[1\].g_col\[0\].pe__1950_/A sky130_fd_sc_hd__buf_6
Xg_row\[1\].g_col\[0\].pe_place920 g_row\[1\].g_col\[0\].pe__2079_/B VGND VGND VPWR
+ VPWR g_row\[1\].g_col\[0\].pe__2026_/B sky130_fd_sc_hd__buf_6
XFILLER_32_438 VGND VGND VPWR VPWR sky130_fd_sc_hd__decap_3
XFILLER_13_630 VGND VGND VPWR VPWR sky130_fd_sc_hd__fill_2
XFILLER_13_652 VGND VGND VPWR VPWR sky130_fd_sc_hd__decap_3
Xclkbuf_leaf_24_clk clkload3/A VGND VGND VPWR VPWR clkbuf_leaf_24_clk/X sky130_fd_sc_hd__clkbuf_16
XFILLER_13_685 VGND VGND VPWR VPWR sky130_fd_sc_hd__decap_3
XFILLER_8_100 VGND VGND VPWR VPWR sky130_fd_sc_hd__decap_3
XFILLER_9_623 VGND VGND VPWR VPWR sky130_fd_sc_hd__fill_2
XFILLER_8_122 VGND VGND VPWR VPWR sky130_fd_sc_hd__fill_2
XTAP_TAPCELL_ROW_10_363 VGND VPWR sky130_fd_sc_hd__tapvpwrvgnd_1
XTAP_TAPCELL_ROW_93_1605 VGND VPWR sky130_fd_sc_hd__tapvpwrvgnd_1
XTAP_TAPCELL_ROW_93_1616 VGND VPWR sky130_fd_sc_hd__tapvpwrvgnd_1
Xg_row\[1\].g_col\[0\].pe__2701_ clkbuf_leaf_74_clk/X g_row\[1\].g_col\[0\].pe__2701_/D
+ VGND VGND VPWR VPWR hold1938/A sky130_fd_sc_hd__dfxtp_2
XFILLER_4_361 VGND VGND VPWR VPWR sky130_fd_sc_hd__decap_3
XTAP_TAPCELL_ROW_93_1627 VGND VPWR sky130_fd_sc_hd__tapvpwrvgnd_1
Xg_row\[0\].g_col\[0\].pe_place1184 g_row\[0\].g_col\[0\].pe__1768_/A VGND VGND VPWR
+ VPWR g_row\[0\].g_col\[0\].pe__1789_/A sky130_fd_sc_hd__buf_6
Xg_row\[1\].g_col\[0\].pe__2632_ place1257/X hold1989/X VGND VGND VPWR VPWR g_row\[1\].g_col\[0\].pe__2632_/X
+ sky130_fd_sc_hd__or2_2
Xg_row\[1\].g_col\[0\].pe__2563_ g_row\[1\].g_col\[0\].pe__2590_/A g_row\[1\].g_col\[0\].pe__2505_/X
+ VGND VGND VPWR VPWR g_row\[1\].g_col\[0\].pe__2563_/X sky130_fd_sc_hd__or2b_2
Xg_row\[1\].g_col\[1\].pe__1530_ g_row\[1\].g_col\[1\].pe__1957_/B2 g_row\[1\].g_col\[1\].pe__1657_/B
+ g_row\[1\].g_col\[1\].pe__1613_/B1 g_row\[1\].g_col\[1\].pe__1901_/B2 VGND VGND
+ VPWR VPWR g_row\[1\].g_col\[1\].pe__1531_/B sky130_fd_sc_hd__a22o_2
Xg_row\[1\].g_col\[0\].pe__2494_ g_row\[1\].g_col\[0\].pe__2494_/A g_row\[1\].g_col\[0\].pe__2494_/B
+ VGND VGND VPWR VPWR g_row\[1\].g_col\[0\].pe__2585_/B sky130_fd_sc_hd__or2_4
Xg_row\[1\].g_col\[0\].pe__1514_ g_row\[1\].g_col\[0\].pe__1514_/A g_row\[1\].g_col\[0\].pe__1514_/B
+ VGND VGND VPWR VPWR g_row\[1\].g_col\[0\].pe__1514_/X sky130_fd_sc_hd__and2_2
Xg_row\[0\].g_col\[0\].pe__2710_ clkbuf_leaf_40_clk/X g_row\[0\].g_col\[0\].pe__2710_/D
+ VGND VGND VPWR VPWR hold1894/A sky130_fd_sc_hd__dfxtp_2
Xg_row\[1\].g_col\[1\].pe__1461_ g_row\[1\].g_col\[1\].pe__1461_/A g_row\[1\].g_col\[1\].pe__1461_/B
+ VGND VGND VPWR VPWR g_row\[1\].g_col\[1\].pe__1461_/Y sky130_fd_sc_hd__nand2_2
Xg_row\[0\].g_col\[0\].pe__2641_ place1257/X hold1887/X VGND VGND VPWR VPWR g_row\[0\].g_col\[0\].pe__2641_/X
+ sky130_fd_sc_hd__or2_2
XFILLER_36_755 VGND VGND VPWR VPWR sky130_fd_sc_hd__fill_1
Xg_row\[1\].g_col\[1\].pe__1392_ hold2099/X g_row\[1\].g_col\[1\].pe__1402_/B VGND
+ VGND VPWR VPWR g_row\[1\].g_col\[1\].pe__1392_/X sky130_fd_sc_hd__or2_2
Xg_row\[1\].g_col\[0\].pe__1376_ hold1894/X g_row\[1\].g_col\[0\].pe__2680_/B VGND
+ VGND VPWR VPWR g_row\[1\].g_col\[0\].pe__1376_/X sky130_fd_sc_hd__or2_2
Xg_row\[0\].g_col\[0\].pe__2572_ g_row\[0\].g_col\[0\].pe__2572_/A1 g_row\[0\].g_col\[0\].pe__2591_/A2
+ g_row\[0\].g_col\[0\].pe__2591_/B1 g_row\[0\].g_col\[0\].pe__2571_/X VGND VGND VPWR
+ VPWR g_row\[0\].g_col\[0\].pe__2573_/B sky130_fd_sc_hd__a22o_2
XFILLER_51_725 VGND VGND VPWR VPWR sky130_fd_sc_hd__decap_3
XTAP_TAPCELL_ROW_18_474 VGND VPWR sky130_fd_sc_hd__tapvpwrvgnd_1
XTAP_TAPCELL_ROW_18_485 VGND VPWR sky130_fd_sc_hd__tapvpwrvgnd_1
Xg_row\[0\].g_col\[0\].pe__1523_ g_row\[0\].g_col\[0\].pe__1523_/A g_row\[0\].g_col\[0\].pe__1523_/B
+ VGND VGND VPWR VPWR g_row\[0\].g_col\[0\].pe__1584_/B sky130_fd_sc_hd__xnor2_2
XFILLER_50_235 VGND VGND VPWR VPWR sky130_fd_sc_hd__decap_3
Xclkbuf_leaf_15_clk clkbuf_4_4_0_clk/X VGND VGND VPWR VPWR _278_/CLK sky130_fd_sc_hd__clkbuf_16
Xg_row\[0\].g_col\[1\].pe__1470_ g_row\[0\].g_col\[1\].pe__2733_/Q g_row\[0\].g_col\[1\].pe__2250_/A
+ VGND VGND VPWR VPWR g_row\[0\].g_col\[1\].pe__1471_/B sky130_fd_sc_hd__or2_2
Xg_row\[1\].g_col\[1\].pe__2013_ g_row\[1\].g_col\[1\].pe__2013_/A g_row\[1\].g_col\[1\].pe__2013_/B
+ VGND VGND VPWR VPWR g_row\[1\].g_col\[1\].pe__2153_/A sky130_fd_sc_hd__nor2_2
Xg_row\[0\].g_col\[0\].pe__1385_ g_row\[0\].g_col\[0\].pe__2674_/D g_row\[0\].g_col\[0\].pe__1385_/B
+ VGND VGND VPWR VPWR g_row\[0\].g_col\[0\].pe__1385_/X sky130_fd_sc_hd__or2_2
Xg_row\[0\].g_col\[0\].pe__2006_ g_row\[0\].g_col\[0\].pe__2006_/A g_row\[0\].g_col\[0\].pe__2009_/B
+ VGND VGND VPWR VPWR g_row\[0\].g_col\[0\].pe__2151_/B sky130_fd_sc_hd__or2b_2
Xg_row\[0\].g_col\[1\].pe__2022_ g_row\[0\].g_col\[1\].pe__2071_/A g_row\[0\].g_col\[1\].pe__2071_/B
+ VGND VGND VPWR VPWR g_row\[0\].g_col\[1\].pe__2023_/B sky130_fd_sc_hd__xor2_2
XFILLER_58_324 VGND VGND VPWR VPWR sky130_fd_sc_hd__fill_1
Xg_row\[1\].g_col\[1\].pe__1728_ g_row\[1\].g_col\[1\].pe__1728_/A g_row\[1\].g_col\[1\].pe__1728_/B
+ VGND VGND VPWR VPWR g_row\[1\].g_col\[1\].pe__1734_/A sky130_fd_sc_hd__xnor2_2
Xg_row\[1\].g_col\[1\].pe__1659_ g_row\[1\].g_col\[1\].pe__1659_/A g_row\[1\].g_col\[1\].pe__1664_/A
+ VGND VGND VPWR VPWR g_row\[1\].g_col\[1\].pe__1693_/B sky130_fd_sc_hd__xnor2_2
XFILLER_27_700 VGND VGND VPWR VPWR sky130_fd_sc_hd__fill_1
XFILLER_85_154 VGND VGND VPWR VPWR sky130_fd_sc_hd__fill_2
XFILLER_85_165 VGND VGND VPWR VPWR sky130_fd_sc_hd__decap_3
XFILLER_26_221 VGND VGND VPWR VPWR sky130_fd_sc_hd__decap_3
XFILLER_66_390 VGND VGND VPWR VPWR sky130_fd_sc_hd__fill_1
Xg_row\[1\].g_col\[0\].pe_hold1790 g_row\[1\].g_col\[0\].pe_hold2973/X VGND VGND VPWR
+ VPWR g_row\[1\].g_col\[0\].pe__2637_/B sky130_fd_sc_hd__clkbuf_2
Xg_row\[0\].g_col\[1\].pe__1806_ g_row\[0\].g_col\[1\].pe__1801_/C g_row\[0\].g_col\[1\].pe__1806_/B
+ VGND VGND VPWR VPWR g_row\[0\].g_col\[1\].pe__1808_/C sky130_fd_sc_hd__and2b_2
XTAP_TAPCELL_ROW_37_761 VGND VPWR sky130_fd_sc_hd__tapvpwrvgnd_1
XFILLER_26_287 VGND VGND VPWR VPWR sky130_fd_sc_hd__fill_1
XFILLER_54_585 VGND VGND VPWR VPWR sky130_fd_sc_hd__decap_3
XTAP_TAPCELL_ROW_37_772 VGND VPWR sky130_fd_sc_hd__tapvpwrvgnd_1
Xg_row\[0\].g_col\[1\].pe__1737_ g_row\[0\].g_col\[1\].pe__1740_/A g_row\[0\].g_col\[1\].pe__1740_/B
+ VGND VGND VPWR VPWR g_row\[0\].g_col\[1\].pe__1776_/A sky130_fd_sc_hd__xor2_2
Xg_row\[0\].g_col\[1\].pe__1668_ g_row\[0\].g_col\[1\].pe__1701_/A g_row\[0\].g_col\[1\].pe__1701_/B
+ VGND VGND VPWR VPWR g_row\[0\].g_col\[1\].pe__1831_/A sky130_fd_sc_hd__or2_2
XFILLER_10_666 VGND VGND VPWR VPWR sky130_fd_sc_hd__decap_3
XTAP_TAPCELL_ROW_75_1335 VGND VPWR sky130_fd_sc_hd__tapvpwrvgnd_1
Xg_row\[1\].g_col\[1\].pe_hold2098 g_row\[1\].g_col\[1\].pe_hold2864/X VGND VGND VPWR
+ VPWR g_row\[1\].g_col\[1\].pe__2714_/D sky130_fd_sc_hd__clkbuf_2
XFILLER_49_302 VGND VGND VPWR VPWR sky130_fd_sc_hd__decap_3
XFILLER_77_633 VGND VGND VPWR VPWR sky130_fd_sc_hd__decap_3
XFILLER_49_335 VGND VGND VPWR VPWR sky130_fd_sc_hd__fill_1
XFILLER_76_110 VGND VGND VPWR VPWR sky130_fd_sc_hd__fill_1
XFILLER_77_655 VGND VGND VPWR VPWR sky130_fd_sc_hd__decap_3
XFILLER_64_305 VGND VGND VPWR VPWR sky130_fd_sc_hd__fill_1
XFILLER_65_839 VGND VGND VPWR VPWR sky130_fd_sc_hd__fill_1
Xhold2090 hold2090/A VGND VGND VPWR VPWR hold2090/X sky130_fd_sc_hd__clkbuf_2
XFILLER_91_113 VGND VGND VPWR VPWR sky130_fd_sc_hd__fill_1
XFILLER_92_636 VGND VGND VPWR VPWR sky130_fd_sc_hd__fill_2
XFILLER_33_703 VGND VGND VPWR VPWR sky130_fd_sc_hd__decap_3
XFILLER_45_552 VGND VGND VPWR VPWR sky130_fd_sc_hd__fill_1
XFILLER_60_500 VGND VGND VPWR VPWR sky130_fd_sc_hd__decap_3
XTAP_TAPCELL_ROW_86_1497 VGND VPWR sky130_fd_sc_hd__tapvpwrvgnd_1
XFILLER_33_758 VGND VGND VPWR VPWR sky130_fd_sc_hd__fill_2
XTAP_TAPCELL_ROW_15_433 VGND VPWR sky130_fd_sc_hd__tapvpwrvgnd_1
Xg_row\[0\].g_col\[0\].pe_hold1800 g_row\[0\].g_col\[0\].pe__1400_/X VGND VGND VPWR
+ VPWR g_row\[0\].g_col\[0\].pe__1401_/B1 sky130_fd_sc_hd__clkbuf_2
XFILLER_13_460 VGND VGND VPWR VPWR sky130_fd_sc_hd__fill_2
XFILLER_20_419 VGND VGND VPWR VPWR sky130_fd_sc_hd__fill_1
Xg_row\[1\].g_col\[0\].pe__1994_ g_row\[1\].g_col\[0\].pe__1994_/A g_row\[1\].g_col\[0\].pe__1994_/B
+ VGND VGND VPWR VPWR g_row\[1\].g_col\[0\].pe__1994_/Y sky130_fd_sc_hd__nor2_2
Xg_row\[1\].g_col\[1\].pe__2700_ clkbuf_leaf_69_clk/X g_row\[1\].g_col\[1\].pe__2700_/D
+ VGND VGND VPWR VPWR g_row\[1\].g_col\[1\].pe__2700_/Q sky130_fd_sc_hd__dfxtp_2
Xg_row\[1\].g_col\[1\].pe__2631_ g_row\[1\].g_col\[1\].pe__1950_/A g_row\[1\].g_col\[1\].pe__2631_/A2
+ g_row\[1\].g_col\[1\].pe__2679_/C1 g_row\[1\].g_col\[1\].pe__2630_/X VGND VGND VPWR
+ VPWR g_row\[1\].g_col\[1\].pe__2631_/X sky130_fd_sc_hd__o211a_2
Xg_row\[1\].g_col\[0\].pe__2615_ g_row\[1\].g_col\[0\].pe__2640_/A1 g_row\[1\].g_col\[0\].pe__2615_/A2
+ g_row\[1\].g_col\[0\].pe__2640_/C1 g_row\[1\].g_col\[0\].pe__2614_/X VGND VGND VPWR
+ VPWR g_row\[1\].g_col\[0\].pe__2615_/X sky130_fd_sc_hd__o211a_2
XFILLER_68_600 VGND VGND VPWR VPWR sky130_fd_sc_hd__fill_2
Xclkbuf_leaf_4_clk clkload0/A VGND VGND VPWR VPWR clkbuf_leaf_4_clk/X sky130_fd_sc_hd__clkbuf_16
Xg_row\[1\].g_col\[0\].pe__2546_ g_row\[1\].g_col\[0\].pe__2546_/A g_row\[1\].g_col\[0\].pe__2546_/B
+ VGND VGND VPWR VPWR g_row\[1\].g_col\[0\].pe__2546_/Y sky130_fd_sc_hd__nand2_2
XFILLER_67_110 VGND VGND VPWR VPWR sky130_fd_sc_hd__fill_2
Xg_row\[1\].g_col\[1\].pe__1513_ g_row\[1\].g_col\[1\].pe__1500_/A g_row\[1\].g_col\[1\].pe__1500_/B
+ g_row\[1\].g_col\[1\].pe__1512_/Y VGND VGND VPWR VPWR g_row\[1\].g_col\[1\].pe__1588_/A
+ sky130_fd_sc_hd__a21oi_2
Xg_row\[1\].g_col\[1\].pe__2493_ g_row\[1\].g_col\[1\].pe__2422_/A g_row\[1\].g_col\[1\].pe__2484_/Y
+ g_row\[1\].g_col\[1\].pe__1348_/A g_row\[1\].g_col\[1\].pe__2754_/Q VGND VGND VPWR
+ VPWR g_row\[1\].g_col\[1\].pe__2503_/B sky130_fd_sc_hd__a211oi_2
Xg_row\[1\].g_col\[0\].pe__2477_ g_row\[1\].g_col\[0\].pe__2487_/B g_row\[1\].g_col\[0\].pe__2490_/A
+ g_row\[1\].g_col\[0\].pe__2487_/A VGND VGND VPWR VPWR g_row\[1\].g_col\[0\].pe__2579_/C
+ sky130_fd_sc_hd__o21ai_2
Xg_row\[1\].g_col\[1\].pe__1444_ g_row\[1\].g_col\[1\].pe__2729_/Q g_row\[1\].g_col\[1\].pe__2125_/C
+ VGND VGND VPWR VPWR g_row\[1\].g_col\[1\].pe__2079_/B sky130_fd_sc_hd__xor2_2
Xg_row\[1\].g_col\[0\].pe__1428_ g_row\[1\].g_col\[0\].pe__1428_/A g_row\[1\].g_col\[0\].pe__1428_/B
+ VGND VGND VPWR VPWR g_row\[1\].g_col\[0\].pe__1428_/X sky130_fd_sc_hd__and2_2
Xg_row\[0\].g_col\[1\].pe__2640_ g_row\[0\].g_col\[1\].pe__1838_/A g_row\[0\].g_col\[1\].pe__2638_/X
+ g_row\[0\].g_col\[1\].pe__2640_/B1 g_row\[0\].g_col\[1\].pe__2381_/A VGND VGND VPWR
+ VPWR g_row\[0\].g_col\[1\].pe__2640_/X sky130_fd_sc_hd__o211a_2
Xg_row\[0\].g_col\[0\].pe__2624_ g_row\[0\].g_col\[0\].pe__2628_/A1 g_row\[0\].g_col\[0\].pe__2624_/A2
+ g_row\[0\].g_col\[0\].pe__2628_/B1 g_row\[0\].g_col\[0\].pe__2623_/X VGND VGND VPWR
+ VPWR g_row\[0\].g_col\[0\].pe__2624_/X sky130_fd_sc_hd__o211a_2
Xg_row\[1\].g_col\[1\].pe_place1244 place1246/X VGND VGND VPWR VPWR g_row\[1\].g_col\[1\].pe__2639_/A
+ sky130_fd_sc_hd__buf_6
Xg_row\[1\].g_col\[0\].pe__1359_ g_row\[1\].g_col\[0\].pe__2765_/Q g_row\[1\].g_col\[0\].pe__1359_/B
+ VGND VGND VPWR VPWR output1390/A sky130_fd_sc_hd__xor2_2
XFILLER_36_596 VGND VGND VPWR VPWR sky130_fd_sc_hd__decap_3
Xg_row\[0\].g_col\[0\].pe__2555_ g_row\[0\].g_col\[0\].pe__2555_/A g_row\[0\].g_col\[0\].pe__2555_/B
+ VGND VGND VPWR VPWR g_row\[0\].g_col\[0\].pe__2762_/D sky130_fd_sc_hd__and2_2
Xg_row\[0\].g_col\[1\].pe__2571_ g_row\[0\].g_col\[1\].pe__2571_/A g_row\[0\].g_col\[1\].pe__2586_/A
+ VGND VGND VPWR VPWR g_row\[0\].g_col\[1\].pe__2571_/X sky130_fd_sc_hd__or2_2
XTAP_TAPCELL_ROW_34_720 VGND VPWR sky130_fd_sc_hd__tapvpwrvgnd_1
Xg_row\[0\].g_col\[0\].pe__1506_ place1221/X g_row\[0\].g_col\[0\].pe__1549_/B VGND
+ VGND VPWR VPWR g_row\[0\].g_col\[0\].pe__1535_/B sky130_fd_sc_hd__nand2_2
Xg_row\[0\].g_col\[1\].pe__1522_ g_row\[0\].g_col\[1\].pe__1624_/A g_row\[0\].g_col\[1\].pe__1522_/B
+ VGND VGND VPWR VPWR g_row\[0\].g_col\[1\].pe__1523_/B sky130_fd_sc_hd__xor2_2
XFILLER_51_577 VGND VGND VPWR VPWR sky130_fd_sc_hd__fill_2
Xg_row\[0\].g_col\[0\].pe__2486_ g_row\[0\].g_col\[0\].pe__2509_/S g_row\[0\].g_col\[0\].pe__2486_/B
+ VGND VGND VPWR VPWR g_row\[0\].g_col\[0\].pe__2516_/B sky130_fd_sc_hd__or2_2
Xg_row\[0\].g_col\[1\].pe__1453_ g_row\[0\].g_col\[1\].pe__2250_/A VGND VGND VPWR
+ VPWR g_row\[0\].g_col\[1\].pe__2165_/A sky130_fd_sc_hd__inv_2
XFILLER_23_49 VGND VGND VPWR VPWR sky130_fd_sc_hd__decap_3
Xg_row\[0\].g_col\[0\].pe__1437_ g_row\[0\].g_col\[0\].pe__2686_/A g_row\[0\].g_col\[0\].pe__1437_/B
+ VGND VGND VPWR VPWR g_row\[0\].g_col\[0\].pe__1481_/B sky130_fd_sc_hd__xor2_2
Xg_row\[0\].g_col\[0\].pe__1368_ g_row\[0\].g_col\[0\].pe__2769_/Q g_row\[0\].g_col\[0\].pe__1368_/B
+ VGND VGND VPWR VPWR output1359/A sky130_fd_sc_hd__xnor2_2
Xg_row\[0\].g_col\[1\].pe__1384_ g_row\[0\].g_col\[1\].pe__1624_/A g_row\[0\].g_col\[1\].pe__2686_/B
+ g_row\[0\].g_col\[1\].pe__1384_/B1 g_row\[0\].g_col\[1\].pe__2687_/C1 VGND VGND
+ VPWR VPWR g_row\[0\].g_col\[1\].pe__1384_/X sky130_fd_sc_hd__o211a_2
Xg_row\[0\].g_col\[0\].pe_place826 g_row\[0\].g_col\[0\].pe__2590_/A VGND VGND VPWR
+ VPWR g_row\[0\].g_col\[0\].pe__2559_/A sky130_fd_sc_hd__buf_6
Xg_row\[0\].g_col\[1\].pe__2005_ g_row\[0\].g_col\[1\].pe__2005_/A g_row\[0\].g_col\[1\].pe__2005_/B
+ VGND VGND VPWR VPWR g_row\[0\].g_col\[1\].pe__2009_/B sky130_fd_sc_hd__or2_2
XTAP_TAPCELL_ROW_57_1065 VGND VPWR sky130_fd_sc_hd__tapvpwrvgnd_1
XFILLER_59_655 VGND VGND VPWR VPWR sky130_fd_sc_hd__fill_1
XTAP_TAPCELL_ROW_70_1254 VGND VPWR sky130_fd_sc_hd__tapvpwrvgnd_1
XTAP_TAPCELL_ROW_70_1265 VGND VPWR sky130_fd_sc_hd__tapvpwrvgnd_1
XFILLER_74_625 VGND VGND VPWR VPWR sky130_fd_sc_hd__decap_3
XFILLER_64_45 VGND VGND VPWR VPWR sky130_fd_sc_hd__fill_2
Xg_row\[1\].g_col\[1\].pe_place880 g_row\[1\].g_col\[1\].pe__2075_/A VGND VGND VPWR
+ VPWR g_row\[1\].g_col\[1\].pe__2364_/A sky130_fd_sc_hd__buf_6
Xg_row\[1\].g_col\[1\].pe_place891 g_row\[1\].g_col\[1\].pe__1920_/A2 VGND VGND VPWR
+ VPWR g_row\[1\].g_col\[1\].pe__1729_/B1 sky130_fd_sc_hd__buf_6
XFILLER_15_725 VGND VGND VPWR VPWR sky130_fd_sc_hd__decap_3
XFILLER_27_574 VGND VGND VPWR VPWR sky130_fd_sc_hd__decap_3
XFILLER_54_371 VGND VGND VPWR VPWR sky130_fd_sc_hd__decap_3
Xg_row\[0\].g_col\[1\].pe__2769_ _274_/CLK g_row\[0\].g_col\[1\].pe__2769_/D VGND
+ VGND VPWR VPWR g_row\[0\].g_col\[1\].pe__2769_/Q sky130_fd_sc_hd__dfxtp_2
Xg_row\[0\].g_col\[1\].pe_hold1974 g_row\[0\].g_col\[1\].pe__1389_/X VGND VGND VPWR
+ VPWR g_row\[0\].g_col\[1\].pe__1391_/B1 sky130_fd_sc_hd__clkbuf_2
XFILLER_80_11 VGND VGND VPWR VPWR sky130_fd_sc_hd__fill_1
X_322_ _322_/CLK _322_/D VGND VGND VPWR VPWR _322_/Q sky130_fd_sc_hd__dfxtp_2
X_253_ _271_/A _253_/B_N VGND VGND VPWR VPWR _253_/Y sky130_fd_sc_hd__nor2b_4
XFILLER_2_662 VGND VGND VPWR VPWR sky130_fd_sc_hd__decap_3
XFILLER_49_110 VGND VGND VPWR VPWR sky130_fd_sc_hd__fill_2
Xg_row\[1\].g_col\[0\].pe__2331_ g_row\[1\].g_col\[0\].pe__2305_/A g_row\[1\].g_col\[0\].pe__2305_/B
+ g_row\[1\].g_col\[0\].pe__2329_/Y g_row\[1\].g_col\[0\].pe__2330_/X VGND VGND VPWR
+ VPWR g_row\[1\].g_col\[0\].pe__2331_/X sky130_fd_sc_hd__o211a_2
XTAP_TAPCELL_ROW_88_1526 VGND VPWR sky130_fd_sc_hd__tapvpwrvgnd_1
XTAP_TAPCELL_ROW_88_1537 VGND VPWR sky130_fd_sc_hd__tapvpwrvgnd_1
Xg_row\[1\].g_col\[0\].pe__2262_ g_row\[1\].g_col\[0\].pe__2262_/A g_row\[1\].g_col\[0\].pe__2262_/B
+ VGND VGND VPWR VPWR g_row\[1\].g_col\[0\].pe__2263_/B sky130_fd_sc_hd__nand2_2
XFILLER_33_500 VGND VGND VPWR VPWR sky130_fd_sc_hd__decap_3
Xg_row\[1\].g_col\[0\].pe_place1107 g_row\[1\].g_col\[0\].pe__2626_/B1 VGND VGND VPWR
+ VPWR g_row\[1\].g_col\[0\].pe__2640_/C1 sky130_fd_sc_hd__buf_6
Xg_row\[1\].g_col\[0\].pe__2193_ g_row\[1\].g_col\[0\].pe__2147_/A g_row\[1\].g_col\[0\].pe__2147_/B
+ g_row\[1\].g_col\[0\].pe__2192_/Y VGND VGND VPWR VPWR g_row\[1\].g_col\[0\].pe__2202_/B
+ sky130_fd_sc_hd__a21oi_4
Xg_row\[0\].g_col\[0\].pe__2340_ g_row\[0\].g_col\[0\].pe__2121_/A g_row\[0\].g_col\[0\].pe__2363_/A2
+ g_row\[0\].g_col\[0\].pe__2388_/B g_row\[0\].g_col\[0\].pe__2083_/A VGND VGND VPWR
+ VPWR g_row\[0\].g_col\[0\].pe__2343_/A sky130_fd_sc_hd__a22o_2
Xg_row\[0\].g_col\[0\].pe_hold3032 _313_/Q VGND VGND VPWR VPWR g_row\[0\].g_col\[0\].pe_hold3032/X
+ sky130_fd_sc_hd__clkbuf_2
Xg_row\[0\].g_col\[0\].pe_hold3043 g_row\[0\].g_col\[0\].pe__2735_/Q VGND VGND VPWR
+ VPWR g_row\[0\].g_col\[0\].pe_hold3043/X sky130_fd_sc_hd__clkbuf_2
XFILLER_21_706 VGND VGND VPWR VPWR sky130_fd_sc_hd__decap_3
Xg_row\[0\].g_col\[0\].pe_hold2320 g_row\[0\].g_col\[0\].pe_hold2951/X VGND VGND VPWR
+ VPWR g_row\[0\].g_col\[0\].pe__2700_/D sky130_fd_sc_hd__clkbuf_2
Xg_row\[0\].g_col\[0\].pe_hold3087 g_row\[0\].g_col\[0\].pe__2743_/Q VGND VGND VPWR
+ VPWR g_row\[0\].g_col\[0\].pe_hold3087/X sky130_fd_sc_hd__clkbuf_2
XFILLER_60_385 VGND VGND VPWR VPWR sky130_fd_sc_hd__decap_3
Xg_row\[0\].g_col\[0\].pe__2271_ g_row\[0\].g_col\[0\].pe__2271_/A g_row\[0\].g_col\[0\].pe__2271_/B
+ VGND VGND VPWR VPWR g_row\[0\].g_col\[0\].pe__2295_/A sky130_fd_sc_hd__nor2_2
Xg_row\[0\].g_col\[1\].pe_place956 g_row\[0\].g_col\[1\].pe__1416_/X VGND VGND VPWR
+ VPWR g_row\[0\].g_col\[1\].pe__1801_/B sky130_fd_sc_hd__buf_6
Xg_row\[0\].g_col\[1\].pe_place945 g_row\[0\].g_col\[1\].pe__2348_/A VGND VGND VPWR
+ VPWR g_row\[0\].g_col\[1\].pe__1676_/A sky130_fd_sc_hd__buf_6
Xg_row\[0\].g_col\[1\].pe_place967 g_row\[0\].g_col\[1\].pe__1389_/B VGND VGND VPWR
+ VPWR g_row\[0\].g_col\[1\].pe__2680_/B sky130_fd_sc_hd__buf_6
XFILLER_9_294 VGND VGND VPWR VPWR sky130_fd_sc_hd__fill_2
Xg_row\[1\].g_col\[1\].pe__1993_ g_row\[1\].g_col\[1\].pe__1991_/X g_row\[1\].g_col\[1\].pe__1993_/B
+ VGND VGND VPWR VPWR g_row\[1\].g_col\[1\].pe__2055_/A sky130_fd_sc_hd__nand2b_4
Xg_row\[1\].g_col\[0\].pe__1977_ g_row\[1\].g_col\[0\].pe__2321_/A g_row\[1\].g_col\[0\].pe__1977_/B
+ VGND VGND VPWR VPWR g_row\[1\].g_col\[0\].pe__1978_/C sky130_fd_sc_hd__xnor2_2
Xoutput1400 output1400/A VGND VGND VPWR VPWR results_flat[50] sky130_fd_sc_hd__buf_2
Xoutput1411 output1411/A VGND VGND VPWR VPWR results_flat[60] sky130_fd_sc_hd__buf_2
Xhold3516 hold3516/A VGND VGND VPWR VPWR hold3516/X sky130_fd_sc_hd__clkbuf_2
Xhold3505 hold3505/A VGND VGND VPWR VPWR hold3505/X sky130_fd_sc_hd__clkbuf_2
XFILLER_87_205 VGND VGND VPWR VPWR sky130_fd_sc_hd__fill_1
Xhold2804 hold3583/X VGND VGND VPWR VPWR hold3584/A sky130_fd_sc_hd__clkbuf_2
Xhold3549 hold3549/A VGND VGND VPWR VPWR hold3549/X sky130_fd_sc_hd__clkbuf_2
Xhold3538 hold3538/A VGND VGND VPWR VPWR hold3538/X sky130_fd_sc_hd__clkbuf_2
Xhold3527 hold3527/A VGND VGND VPWR VPWR hold3527/X sky130_fd_sc_hd__clkbuf_2
Xg_row\[1\].g_col\[1\].pe__2614_ g_row\[1\].g_col\[1\].pe__2639_/A g_row\[1\].g_col\[1\].pe__2614_/B
+ VGND VGND VPWR VPWR g_row\[1\].g_col\[1\].pe__2614_/X sky130_fd_sc_hd__or2_2
XFILLER_87_238 VGND VGND VPWR VPWR sky130_fd_sc_hd__fill_1
Xhold2815 hold2815/A VGND VGND VPWR VPWR _307_/D sky130_fd_sc_hd__clkbuf_2
XTAP_TAPCELL_ROW_39_801 VGND VPWR sky130_fd_sc_hd__tapvpwrvgnd_1
Xg_row\[0\].g_col\[0\].pe__1986_ g_row\[0\].g_col\[0\].pe__1985_/B g_row\[0\].g_col\[0\].pe__1985_/C
+ g_row\[0\].g_col\[0\].pe__2094_/A VGND VGND VPWR VPWR g_row\[0\].g_col\[0\].pe__1988_/C
+ sky130_fd_sc_hd__a21bo_2
Xg_row\[1\].g_col\[1\].pe__2545_ g_row\[1\].g_col\[1\].pe__2546_/A g_row\[1\].g_col\[1\].pe__2546_/B
+ VGND VGND VPWR VPWR g_row\[1\].g_col\[1\].pe__2547_/B sky130_fd_sc_hd__nor2_2
Xg_row\[1\].g_col\[0\].pe__2529_ g_row\[1\].g_col\[0\].pe__2561_/A g_row\[1\].g_col\[0\].pe__2529_/B
+ VGND VGND VPWR VPWR g_row\[1\].g_col\[0\].pe__2758_/D sky130_fd_sc_hd__and2_2
Xg_row\[1\].g_col\[1\].pe__2476_ g_row\[1\].g_col\[1\].pe__2767_/Q g_row\[1\].g_col\[1\].pe__2476_/B
+ VGND VGND VPWR VPWR g_row\[1\].g_col\[1\].pe__2487_/A sky130_fd_sc_hd__xnor2_2
XFILLER_56_658 VGND VGND VPWR VPWR sky130_fd_sc_hd__fill_2
Xg_row\[1\].g_col\[1\].pe_place1030 g_row\[1\].g_col\[1\].pe__2699_/Q VGND VGND VPWR
+ VPWR g_row\[1\].g_col\[1\].pe__1608_/A1 sky130_fd_sc_hd__buf_6
Xg_row\[1\].g_col\[1\].pe__1427_ g_row\[1\].g_col\[1\].pe__1733_/A g_row\[1\].g_col\[1\].pe__1427_/B
+ VGND VGND VPWR VPWR g_row\[1\].g_col\[1\].pe__1650_/B sky130_fd_sc_hd__xor2_2
Xg_row\[0\].g_col\[0\].pe__2607_ g_row\[0\].g_col\[0\].pe__2639_/A g_row\[0\].g_col\[0\].pe__2607_/B
+ VGND VGND VPWR VPWR g_row\[0\].g_col\[0\].pe__2607_/X sky130_fd_sc_hd__or2_2
Xg_row\[1\].g_col\[1\].pe_place1041 g_row\[1\].g_col\[1\].pe__1782_/A2 VGND VGND VPWR
+ VPWR g_row\[1\].g_col\[1\].pe__1957_/B2 sky130_fd_sc_hd__buf_6
Xg_row\[1\].g_col\[1\].pe_place1052 g_row\[1\].g_col\[1\].pe__2679_/C1 VGND VGND VPWR
+ VPWR g_row\[1\].g_col\[1\].pe__2683_/C1 sky130_fd_sc_hd__buf_6
Xg_row\[0\].g_col\[1\].pe__2623_ place1249/X g_row\[0\].g_col\[1\].pe__2623_/B VGND
+ VGND VPWR VPWR g_row\[0\].g_col\[1\].pe__2623_/X sky130_fd_sc_hd__or2_2
XFILLER_24_533 VGND VGND VPWR VPWR sky130_fd_sc_hd__decap_3
XFILLER_34_26 VGND VGND VPWR VPWR sky130_fd_sc_hd__fill_2
XFILLER_51_330 VGND VGND VPWR VPWR sky130_fd_sc_hd__decap_3
Xg_row\[1\].g_col\[1\].pe__1358_ g_row\[1\].g_col\[1\].pe__2764_/Q g_row\[1\].g_col\[1\].pe__1357_/B
+ g_row\[1\].g_col\[1\].pe__2776_/A VGND VGND VPWR VPWR g_row\[1\].g_col\[1\].pe__1359_/B
+ sky130_fd_sc_hd__o21a_2
Xg_row\[0\].g_col\[1\].pe__2554_ g_row\[0\].g_col\[1\].pe__2554_/A1 g_row\[0\].g_col\[1\].pe__2406_/Y
+ g_row\[0\].g_col\[1\].pe__2591_/B1 g_row\[0\].g_col\[1\].pe__2553_/X VGND VGND VPWR
+ VPWR g_row\[0\].g_col\[1\].pe__2554_/X sky130_fd_sc_hd__a22o_2
XFILLER_24_566 VGND VGND VPWR VPWR sky130_fd_sc_hd__decap_3
Xg_row\[0\].g_col\[0\].pe__2538_ g_row\[0\].g_col\[0\].pe__2538_/A g_row\[0\].g_col\[0\].pe__2538_/B
+ g_row\[0\].g_col\[0\].pe__2538_/C VGND VGND VPWR VPWR g_row\[0\].g_col\[0\].pe__2544_/B
+ sky130_fd_sc_hd__nand3_2
Xg_row\[0\].g_col\[0\].pe__2469_ g_row\[0\].g_col\[0\].pe__2439_/Y g_row\[0\].g_col\[0\].pe__2763_/Q
+ VGND VGND VPWR VPWR g_row\[0\].g_col\[0\].pe__2496_/B sky130_fd_sc_hd__and2b_2
Xg_row\[0\].g_col\[1\].pe_place1139 g_row\[0\].g_col\[1\].pe__2627_/B VGND VGND VPWR
+ VPWR g_row\[0\].g_col\[1\].pe__1965_/A sky130_fd_sc_hd__buf_6
Xg_row\[0\].g_col\[1\].pe_place1128 g_row\[0\].g_col\[1\].pe__2728_/Q VGND VGND VPWR
+ VPWR g_row\[0\].g_col\[1\].pe__2125_/C sky130_fd_sc_hd__buf_6
Xg_row\[0\].g_col\[1\].pe_place1117 g_row\[0\].g_col\[1\].pe__2771_/Q VGND VGND VPWR
+ VPWR ANTENNA_146/DIODE sky130_fd_sc_hd__buf_6
Xg_row\[0\].g_col\[1\].pe__2485_ g_row\[0\].g_col\[1\].pe__2754_/Q g_row\[0\].g_col\[1\].pe__2422_/A
+ g_row\[0\].g_col\[1\].pe__2484_/Y g_row\[0\].g_col\[1\].pe__1348_/A VGND VGND VPWR
+ VPWR g_row\[0\].g_col\[1\].pe__2486_/B sky130_fd_sc_hd__o211a_2
Xclkload3 clkload3/A VGND VGND VPWR VPWR clkload3/X sky130_fd_sc_hd__clkbuf_16
Xg_row\[0\].g_col\[1\].pe__1436_ g_row\[0\].g_col\[1\].pe__2036_/B2 g_row\[0\].g_col\[1\].pe__1729_/A2
+ g_row\[0\].g_col\[1\].pe__1729_/A3 g_row\[0\].g_col\[1\].pe__1729_/B1 g_row\[0\].g_col\[1\].pe__1911_/A1
+ VGND VGND VPWR VPWR g_row\[0\].g_col\[1\].pe__1437_/B sky130_fd_sc_hd__a32o_2
Xg_row\[0\].g_col\[1\].pe__1367_ g_row\[0\].g_col\[1\].pe__2768_/Q g_row\[0\].g_col\[1\].pe__1366_/B
+ ANTENNA_146/DIODE VGND VGND VPWR VPWR g_row\[0\].g_col\[1\].pe__1368_/B sky130_fd_sc_hd__o21ai_2
XFILLER_59_34 VGND VGND VPWR VPWR sky130_fd_sc_hd__fill_2
XFILLER_79_739 VGND VGND VPWR VPWR sky130_fd_sc_hd__decap_3
XFILLER_47_603 VGND VGND VPWR VPWR sky130_fd_sc_hd__fill_1
XFILLER_59_474 VGND VGND VPWR VPWR sky130_fd_sc_hd__fill_1
XFILLER_87_772 VGND VGND VPWR VPWR sky130_fd_sc_hd__decap_3
XTAP_TAPCELL_ROW_6_297 VGND VPWR sky130_fd_sc_hd__tapvpwrvgnd_1
XFILLER_34_319 VGND VGND VPWR VPWR sky130_fd_sc_hd__fill_1
XFILLER_27_393 VGND VGND VPWR VPWR sky130_fd_sc_hd__fill_1
XTAP_TAPCELL_ROW_83_1456 VGND VPWR sky130_fd_sc_hd__tapvpwrvgnd_1
Xg_row\[0\].g_col\[1\].pe_hold1793 g_row\[0\].g_col\[1\].pe__1835_/X VGND VGND VPWR
+ VPWR g_row\[0\].g_col\[1\].pe__1836_/B sky130_fd_sc_hd__clkbuf_2
XTAP_TAPCELL_ROW_25_583 VGND VPWR sky130_fd_sc_hd__tapvpwrvgnd_1
X_305_ _306_/CLK _305_/D VGND VGND VPWR VPWR _305_/Q sky130_fd_sc_hd__dfxtp_2
XFILLER_11_783 VGND VGND VPWR VPWR sky130_fd_sc_hd__fill_1
Xg_row\[1\].g_col\[0\].pe__1900_ g_row\[1\].g_col\[0\].pe__1868_/A g_row\[1\].g_col\[0\].pe__1868_/B
+ g_row\[1\].g_col\[0\].pe__1899_/X VGND VGND VPWR VPWR g_row\[1\].g_col\[0\].pe__1907_/A
+ sky130_fd_sc_hd__a21o_2
XFILLER_6_253 VGND VGND VPWR VPWR sky130_fd_sc_hd__decap_3
XFILLER_7_776 VGND VGND VPWR VPWR sky130_fd_sc_hd__decap_3
X_167_ _171_/A _167_/B_N VGND VGND VPWR VPWR _167_/Y sky130_fd_sc_hd__nor2b_4
Xg_row\[1\].g_col\[0\].pe__1831_ g_row\[1\].g_col\[0\].pe__1831_/A g_row\[1\].g_col\[0\].pe__1831_/B
+ VGND VGND VPWR VPWR g_row\[1\].g_col\[0\].pe__1832_/C sky130_fd_sc_hd__nand2_2
Xg_row\[1\].g_col\[0\].pe__1762_ g_row\[1\].g_col\[0\].pe__1808_/A g_row\[1\].g_col\[0\].pe__1762_/B
+ VGND VGND VPWR VPWR g_row\[1\].g_col\[0\].pe__1766_/A sky130_fd_sc_hd__xnor2_2
Xg_row\[1\].g_col\[0\].pe__1693_ g_row\[1\].g_col\[0\].pe__1693_/A g_row\[1\].g_col\[0\].pe__1693_/B
+ VGND VGND VPWR VPWR g_row\[1\].g_col\[0\].pe__1695_/B sky130_fd_sc_hd__xor2_2
Xg_row\[0\].g_col\[0\].pe__1840_ g_row\[0\].g_col\[0\].pe__1840_/A g_row\[0\].g_col\[0\].pe__1840_/B
+ VGND VGND VPWR VPWR g_row\[0\].g_col\[0\].pe__1841_/A sky130_fd_sc_hd__nor2_2
Xg_row\[0\].g_col\[0\].pe__1771_ g_row\[0\].g_col\[0\].pe__1793_/B g_row\[0\].g_col\[0\].pe__1793_/C
+ g_row\[0\].g_col\[0\].pe__1793_/A VGND VGND VPWR VPWR g_row\[0\].g_col\[0\].pe__1794_/A
+ sky130_fd_sc_hd__a21oi_2
Xg_row\[1\].g_col\[1\].pe__2330_ g_row\[1\].g_col\[1\].pe__2330_/A g_row\[1\].g_col\[1\].pe__2330_/B
+ g_row\[1\].g_col\[1\].pe__2330_/C VGND VGND VPWR VPWR g_row\[1\].g_col\[1\].pe__2330_/X
+ sky130_fd_sc_hd__or3_2
Xg_row\[1\].g_col\[0\].pe__2314_ g_row\[1\].g_col\[0\].pe__2364_/A g_row\[1\].g_col\[0\].pe__2314_/B
+ VGND VGND VPWR VPWR g_row\[1\].g_col\[0\].pe__2316_/B sky130_fd_sc_hd__xnor2_2
XFILLER_1_63 VGND VGND VPWR VPWR sky130_fd_sc_hd__fill_1
Xg_row\[1\].g_col\[1\].pe__2261_ g_row\[1\].g_col\[1\].pe__2262_/A g_row\[1\].g_col\[1\].pe__2262_/B
+ VGND VGND VPWR VPWR g_row\[1\].g_col\[1\].pe__2261_/Y sky130_fd_sc_hd__nor2_2
XFILLER_46_680 VGND VGND VPWR VPWR sky130_fd_sc_hd__fill_1
XFILLER_53_617 VGND VGND VPWR VPWR sky130_fd_sc_hd__fill_1
XFILLER_92_274 VGND VGND VPWR VPWR sky130_fd_sc_hd__fill_1
Xg_row\[1\].g_col\[0\].pe__2245_ g_row\[1\].g_col\[0\].pe__2288_/A g_row\[1\].g_col\[0\].pe__2288_/B
+ VGND VGND VPWR VPWR g_row\[1\].g_col\[0\].pe__2246_/B sky130_fd_sc_hd__xnor2_2
XFILLER_80_447 VGND VGND VPWR VPWR sky130_fd_sc_hd__fill_2
Xg_row\[1\].g_col\[1\].pe__2192_ g_row\[1\].g_col\[1\].pe__2192_/A g_row\[1\].g_col\[1\].pe__2192_/B
+ VGND VGND VPWR VPWR g_row\[1\].g_col\[1\].pe__2192_/Y sky130_fd_sc_hd__nor2_2
Xg_row\[1\].g_col\[0\].pe__2176_ g_row\[1\].g_col\[0\].pe__2175_/X g_row\[1\].g_col\[0\].pe__2132_/B
+ g_row\[1\].g_col\[0\].pe__2129_/B VGND VGND VPWR VPWR g_row\[1\].g_col\[0\].pe__2181_/A
+ sky130_fd_sc_hd__a21o_2
XTAP_TAPCELL_ROW_44_870 VGND VPWR sky130_fd_sc_hd__tapvpwrvgnd_1
Xg_row\[0\].g_col\[0\].pe__2323_ g_row\[0\].g_col\[0\].pe__2337_/A g_row\[0\].g_col\[0\].pe__2323_/B
+ VGND VGND VPWR VPWR g_row\[0\].g_col\[0\].pe__2325_/A sky130_fd_sc_hd__xnor2_2
Xg_row\[0\].g_col\[0\].pe_hold2161 g_row\[0\].g_col\[0\].pe__2660_/X VGND VGND VPWR
+ VPWR g_row\[0\].g_col\[0\].pe__2715_/D sky130_fd_sc_hd__clkbuf_2
Xg_row\[0\].g_col\[0\].pe__2254_ g_row\[0\].g_col\[0\].pe__2221_/A g_row\[0\].g_col\[0\].pe__2221_/B
+ g_row\[0\].g_col\[0\].pe__2253_/Y VGND VGND VPWR VPWR g_row\[0\].g_col\[0\].pe__2271_/B
+ sky130_fd_sc_hd__o21a_2
Xinput1309 hold3574/X VGND VGND VPWR VPWR hold3575/A sky130_fd_sc_hd__buf_2
Xg_row\[0\].g_col\[1\].pe__2270_ g_row\[0\].g_col\[1\].pe__2330_/A g_row\[0\].g_col\[1\].pe__2330_/B
+ VGND VGND VPWR VPWR g_row\[0\].g_col\[1\].pe__2297_/A sky130_fd_sc_hd__nor2_2
Xg_row\[0\].g_col\[0\].pe__2185_ g_row\[0\].g_col\[0\].pe__2184_/X g_row\[0\].g_col\[0\].pe__2144_/B
+ g_row\[0\].g_col\[0\].pe__2135_/A VGND VGND VPWR VPWR g_row\[0\].g_col\[0\].pe__2186_/B
+ sky130_fd_sc_hd__o21a_2
Xg_row\[1\].g_col\[1\].pe__1976_ g_row\[1\].g_col\[1\].pe__2036_/B2 g_row\[1\].g_col\[1\].pe__1471_/X
+ g_row\[1\].g_col\[1\].pe__2247_/B1 g_row\[1\].g_col\[1\].pe__2177_/B2 VGND VGND
+ VPWR VPWR g_row\[1\].g_col\[1\].pe__1977_/B sky130_fd_sc_hd__a22o_2
XTAP_TAPCELL_ROW_54_1013 VGND VPWR sky130_fd_sc_hd__tapvpwrvgnd_1
XTAP_TAPCELL_ROW_54_1024 VGND VPWR sky130_fd_sc_hd__tapvpwrvgnd_1
Xhold3302 hold3302/A VGND VGND VPWR VPWR hold3302/X sky130_fd_sc_hd__clkbuf_2
Xhold3313 hold3313/A VGND VGND VPWR VPWR hold3313/X sky130_fd_sc_hd__clkbuf_2
Xhold3324 hold3324/A VGND VGND VPWR VPWR hold3324/X sky130_fd_sc_hd__clkbuf_2
Xhold2601 hold3377/X VGND VGND VPWR VPWR hold3378/A sky130_fd_sc_hd__clkbuf_2
Xhold2612 hold3333/X VGND VGND VPWR VPWR hold3334/A sky130_fd_sc_hd__clkbuf_2
Xhold3335 hold3335/A VGND VGND VPWR VPWR hold3335/X sky130_fd_sc_hd__clkbuf_2
Xhold3346 hold3346/A VGND VGND VPWR VPWR hold3346/X sky130_fd_sc_hd__clkbuf_2
Xhold3357 hold3357/A VGND VGND VPWR VPWR hold3357/X sky130_fd_sc_hd__clkbuf_2
Xhold2623 hold2623/A VGND VGND VPWR VPWR _320_/D sky130_fd_sc_hd__clkbuf_2
Xhold2634 _155_/Y VGND VGND VPWR VPWR hold2634/X sky130_fd_sc_hd__clkbuf_2
Xhold2645 hold3451/X VGND VGND VPWR VPWR _189_/B_N sky130_fd_sc_hd__clkbuf_2
Xhold2656 hold3386/X VGND VGND VPWR VPWR hold3387/A sky130_fd_sc_hd__clkbuf_2
Xhold3368 b_inputs_flat[23] VGND VGND VPWR VPWR hold3368/X sky130_fd_sc_hd__clkbuf_2
Xhold3379 hold3379/A VGND VGND VPWR VPWR hold3379/X sky130_fd_sc_hd__clkbuf_2
Xhold2667 hold3426/X VGND VGND VPWR VPWR hold3427/A sky130_fd_sc_hd__clkbuf_2
Xhold2678 hold3431/X VGND VGND VPWR VPWR hold3432/A sky130_fd_sc_hd__clkbuf_2
Xhold2689 hold2689/A VGND VGND VPWR VPWR _295_/D sky130_fd_sc_hd__clkbuf_2
Xg_row\[1\].g_col\[1\].pe__2528_ g_row\[1\].g_col\[1\].pe__2528_/A1 g_row\[1\].g_col\[1\].pe__2568_/A2
+ g_row\[1\].g_col\[1\].pe__2568_/B1 g_row\[1\].g_col\[1\].pe__2527_/X VGND VGND VPWR
+ VPWR g_row\[1\].g_col\[1\].pe__2528_/X sky130_fd_sc_hd__a22o_2
Xg_row\[0\].g_col\[1\].pe__1985_ g_row\[0\].g_col\[1\].pe__2094_/A g_row\[0\].g_col\[1\].pe__1985_/B
+ g_row\[0\].g_col\[1\].pe__1985_/C VGND VGND VPWR VPWR g_row\[0\].g_col\[1\].pe__1988_/B
+ sky130_fd_sc_hd__nand3b_2
XFILLER_84_753 VGND VGND VPWR VPWR sky130_fd_sc_hd__decap_3
XTAP_TAPCELL_ROW_3_256 VGND VPWR sky130_fd_sc_hd__tapvpwrvgnd_1
Xg_row\[0\].g_col\[0\].pe__1969_ g_row\[0\].g_col\[0\].pe__1968_/B g_row\[0\].g_col\[0\].pe__1968_/C
+ g_row\[0\].g_col\[0\].pe__2167_/A VGND VGND VPWR VPWR g_row\[0\].g_col\[0\].pe__1974_/B
+ sky130_fd_sc_hd__a21bo_2
Xg_row\[1\].g_col\[1\].pe__2459_ g_row\[1\].g_col\[1\].pe__2754_/Q g_row\[1\].g_col\[1\].pe__2739_/Q
+ VGND VGND VPWR VPWR g_row\[1\].g_col\[1\].pe__2460_/B sky130_fd_sc_hd__and2b_2
Xg_row\[0\].g_col\[1\].pe__2606_ g_row\[0\].g_col\[1\].pe__2670_/A1 place1217/X g_row\[0\].g_col\[1\].pe__2679_/C1
+ g_row\[0\].g_col\[1\].pe__2605_/X VGND VGND VPWR VPWR g_row\[0\].g_col\[1\].pe__2692_/D
+ sky130_fd_sc_hd__o211a_2
XFILLER_52_661 VGND VGND VPWR VPWR sky130_fd_sc_hd__decap_3
XTAP_TAPCELL_ROW_65_1186 VGND VPWR sky130_fd_sc_hd__tapvpwrvgnd_1
XFILLER_12_558 VGND VGND VPWR VPWR sky130_fd_sc_hd__decap_3
XTAP_TAPCELL_ROW_22_542 VGND VPWR sky130_fd_sc_hd__tapvpwrvgnd_1
Xg_row\[0\].g_col\[1\].pe__2468_ g_row\[0\].g_col\[1\].pe__2538_/A g_row\[0\].g_col\[1\].pe__2538_/B
+ g_row\[0\].g_col\[1\].pe__2538_/C g_row\[0\].g_col\[1\].pe__2466_/X g_row\[0\].g_col\[1\].pe__2497_/A
+ VGND VGND VPWR VPWR g_row\[0\].g_col\[1\].pe__2551_/C sky130_fd_sc_hd__a311o_2
Xg_row\[0\].g_col\[1\].pe__1419_ g_row\[0\].g_col\[1\].pe__1707_/A g_row\[0\].g_col\[1\].pe__1419_/B
+ VGND VGND VPWR VPWR g_row\[0\].g_col\[1\].pe__1428_/B sky130_fd_sc_hd__xor2_2
Xg_row\[0\].g_col\[1\].pe__2399_ g_row\[0\].g_col\[1\].pe__2754_/Q VGND VGND VPWR
+ VPWR g_row\[0\].g_col\[1\].pe__2399_/Y sky130_fd_sc_hd__inv_2
XFILLER_4_724 VGND VGND VPWR VPWR sky130_fd_sc_hd__decap_3
XFILLER_4_757 VGND VGND VPWR VPWR sky130_fd_sc_hd__decap_3
XFILLER_79_503 VGND VGND VPWR VPWR sky130_fd_sc_hd__fill_1
XFILLER_79_547 VGND VGND VPWR VPWR sky130_fd_sc_hd__decap_3
XFILLER_19_113 VGND VGND VPWR VPWR sky130_fd_sc_hd__fill_2
XFILLER_87_591 VGND VGND VPWR VPWR sky130_fd_sc_hd__fill_2
Xg_row\[1\].g_col\[0\].pe__2030_ g_row\[1\].g_col\[0\].pe__2030_/A g_row\[1\].g_col\[0\].pe__2163_/B
+ VGND VGND VPWR VPWR g_row\[1\].g_col\[0\].pe__2032_/B sky130_fd_sc_hd__nand2_2
X_219_ _219_/A _219_/B_N VGND VGND VPWR VPWR _219_/Y sky130_fd_sc_hd__nor2b_4
Xg_row\[1\].g_col\[1\].pe__1830_ g_row\[1\].g_col\[1\].pe__1830_/A g_row\[1\].g_col\[1\].pe__1830_/B
+ g_row\[1\].g_col\[1\].pe__1830_/C VGND VGND VPWR VPWR g_row\[1\].g_col\[1\].pe__1832_/B
+ sky130_fd_sc_hd__or3_2
XFILLER_7_595 VGND VGND VPWR VPWR sky130_fd_sc_hd__decap_3
Xplace1217 place1218/X VGND VGND VPWR VPWR place1217/X sky130_fd_sc_hd__buf_6
Xplace1239 place1241/X VGND VGND VPWR VPWR place1239/X sky130_fd_sc_hd__buf_6
Xg_row\[1\].g_col\[0\].pe__1814_ g_row\[1\].g_col\[0\].pe__1779_/Y g_row\[1\].g_col\[0\].pe__1812_/X
+ g_row\[1\].g_col\[0\].pe__1813_/Y VGND VGND VPWR VPWR g_row\[1\].g_col\[0\].pe__1821_/B
+ sky130_fd_sc_hd__o21ai_2
Xg_row\[1\].g_col\[1\].pe__1761_ g_row\[1\].g_col\[1\].pe__1804_/A g_row\[1\].g_col\[1\].pe__1761_/A2
+ g_row\[1\].g_col\[1\].pe__1782_/A2 g_row\[1\].g_col\[1\].pe__1761_/B2 VGND VGND
+ VPWR VPWR g_row\[1\].g_col\[1\].pe__1762_/B sky130_fd_sc_hd__a22o_2
Xg_row\[1\].g_col\[0\].pe__1745_ g_row\[1\].g_col\[0\].pe__1745_/A g_row\[1\].g_col\[0\].pe__1745_/B
+ VGND VGND VPWR VPWR g_row\[1\].g_col\[0\].pe__1819_/B sky130_fd_sc_hd__xnor2_2
Xg_row\[1\].g_col\[1\].pe__1692_ g_row\[1\].g_col\[1\].pe__1689_/Y g_row\[1\].g_col\[1\].pe__1722_/B
+ g_row\[1\].g_col\[1\].pe__1691_/Y VGND VGND VPWR VPWR g_row\[1\].g_col\[1\].pe__1695_/A
+ sky130_fd_sc_hd__a21o_2
Xg_row\[1\].g_col\[0\].pe__1676_ g_row\[1\].g_col\[0\].pe__1676_/A g_row\[1\].g_col\[0\].pe__1676_/B
+ VGND VGND VPWR VPWR g_row\[1\].g_col\[0\].pe__1677_/B sky130_fd_sc_hd__and2_2
Xg_row\[1\].g_col\[0\].pe_hold2832 g_row\[1\].g_col\[0\].pe__2650_/X VGND VGND VPWR
+ VPWR g_row\[1\].g_col\[0\].pe_hold2832/X sky130_fd_sc_hd__clkbuf_2
Xg_row\[1\].g_col\[0\].pe_hold2821 g_row\[1\].g_col\[0\].pe__2648_/X VGND VGND VPWR
+ VPWR g_row\[1\].g_col\[0\].pe_hold2821/X sky130_fd_sc_hd__clkbuf_2
Xg_row\[0\].g_col\[0\].pe__1823_ g_row\[0\].g_col\[0\].pe__1823_/A g_row\[0\].g_col\[0\].pe__1823_/B
+ VGND VGND VPWR VPWR g_row\[0\].g_col\[0\].pe__1828_/A sky130_fd_sc_hd__xnor2_2
Xg_row\[1\].g_col\[0\].pe_hold2854 g_row\[1\].g_col\[0\].pe__2718_/Q VGND VGND VPWR
+ VPWR g_row\[1\].g_col\[0\].pe__2665_/B sky130_fd_sc_hd__clkbuf_2
XTAP_TAPCELL_ROW_49_940 VGND VPWR sky130_fd_sc_hd__tapvpwrvgnd_1
XTAP_TAPCELL_ROW_49_951 VGND VPWR sky130_fd_sc_hd__tapvpwrvgnd_1
Xg_row\[1\].g_col\[1\].pe__2313_ g_row\[1\].g_col\[1\].pe__2388_/A g_row\[1\].g_col\[1\].pe__2313_/A2
+ g_row\[1\].g_col\[1\].pe__2313_/B1 g_row\[1\].g_col\[1\].pe__2121_/A VGND VGND VPWR
+ VPWR g_row\[1\].g_col\[1\].pe__2314_/B sky130_fd_sc_hd__a22o_2
Xg_row\[0\].g_col\[1\].pe__1770_ g_row\[0\].g_col\[1\].pe__1770_/A g_row\[0\].g_col\[1\].pe__1770_/B
+ VGND VGND VPWR VPWR g_row\[0\].g_col\[1\].pe__1793_/A sky130_fd_sc_hd__xnor2_2
XFILLER_26_639 VGND VGND VPWR VPWR sky130_fd_sc_hd__decap_3
XFILLER_65_274 VGND VGND VPWR VPWR sky130_fd_sc_hd__fill_2
XPHY_EDGE_ROW_69_Left_163 VGND VGND VPWR VPWR sky130_fd_sc_hd__decap_3
XTAP_TAPCELL_ROW_0_204 VGND VPWR sky130_fd_sc_hd__tapvpwrvgnd_1
XTAP_TAPCELL_ROW_0_215 VGND VPWR sky130_fd_sc_hd__tapvpwrvgnd_1
Xg_row\[0\].g_col\[0\].pe__1754_ hold2363/A g_row\[0\].g_col\[0\].pe__1982_/B g_row\[0\].g_col\[0\].pe__1424_/Y
+ place1223/A VGND VGND VPWR VPWR g_row\[0\].g_col\[0\].pe__1755_/B sky130_fd_sc_hd__a22o_2
Xg_row\[0\].g_col\[0\].pe__1685_ g_row\[0\].g_col\[0\].pe__1733_/A g_row\[0\].g_col\[0\].pe__1685_/B
+ VGND VGND VPWR VPWR g_row\[0\].g_col\[0\].pe__1713_/B sky130_fd_sc_hd__xor2_2
Xg_row\[1\].g_col\[1\].pe__2244_ g_row\[1\].g_col\[1\].pe__2277_/A g_row\[1\].g_col\[1\].pe__2277_/B
+ VGND VGND VPWR VPWR g_row\[1\].g_col\[1\].pe__2288_/B sky130_fd_sc_hd__xor2_2
Xg_row\[1\].g_col\[0\].pe__2228_ g_row\[1\].g_col\[0\].pe__2228_/A g_row\[1\].g_col\[0\].pe__2228_/B
+ g_row\[1\].g_col\[0\].pe__2228_/C VGND VGND VPWR VPWR g_row\[1\].g_col\[0\].pe__2229_/B
+ sky130_fd_sc_hd__or3_2
Xg_row\[1\].g_col\[1\].pe__2175_ g_row\[1\].g_col\[1\].pe__2128_/B g_row\[1\].g_col\[1\].pe__2128_/C
+ g_row\[1\].g_col\[1\].pe__2128_/A VGND VGND VPWR VPWR g_row\[1\].g_col\[1\].pe__2175_/X
+ sky130_fd_sc_hd__a21o_2
XFILLER_22_834 VGND VGND VPWR VPWR sky130_fd_sc_hd__fill_2
Xg_row\[1\].g_col\[0\].pe__2159_ g_row\[1\].g_col\[0\].pe__2514_/A g_row\[1\].g_col\[0\].pe__2159_/B
+ VGND VGND VPWR VPWR g_row\[1\].g_col\[0\].pe__2745_/D sky130_fd_sc_hd__nor2_2
Xg_row\[0\].g_col\[1\].pe__2322_ g_row\[0\].g_col\[1\].pe__2337_/B g_row\[0\].g_col\[1\].pe__2337_/C
+ VGND VGND VPWR VPWR g_row\[0\].g_col\[1\].pe__2323_/B sky130_fd_sc_hd__nor2_2
Xg_row\[0\].g_col\[0\].pe__2306_ g_row\[0\].g_col\[0\].pe__2395_/A1 g_row\[0\].g_col\[0\].pe__2306_/A2
+ g_row\[0\].g_col\[0\].pe__2394_/B1 g_row\[0\].g_col\[0\].pe__2305_/Y VGND VGND VPWR
+ VPWR g_row\[0\].g_col\[0\].pe__2306_/X sky130_fd_sc_hd__o22a_2
XPHY_EDGE_ROW_78_Left_172 VGND VGND VPWR VPWR sky130_fd_sc_hd__decap_3
Xg_row\[0\].g_col\[0\].pe__2237_ g_row\[0\].g_col\[0\].pe__2335_/A g_row\[0\].g_col\[0\].pe__2237_/B
+ VGND VGND VPWR VPWR g_row\[0\].g_col\[0\].pe__2747_/D sky130_fd_sc_hd__nor2_2
Xg_row\[0\].g_col\[1\].pe__2253_ g_row\[0\].g_col\[1\].pe__2253_/A g_row\[0\].g_col\[1\].pe__2253_/B
+ VGND VGND VPWR VPWR g_row\[0\].g_col\[1\].pe__2253_/Y sky130_fd_sc_hd__nand2_2
Xg_row\[0\].g_col\[0\].pe__2168_ g_row\[0\].g_col\[0\].pe__2167_/B g_row\[0\].g_col\[0\].pe__2167_/C
+ g_row\[0\].g_col\[0\].pe__2167_/A VGND VGND VPWR VPWR g_row\[0\].g_col\[0\].pe__2169_/B
+ sky130_fd_sc_hd__a21o_2
Xg_row\[0\].g_col\[1\].pe__2184_ g_row\[0\].g_col\[1\].pe__2222_/A g_row\[0\].g_col\[1\].pe__2184_/B
+ g_row\[0\].g_col\[1\].pe__2184_/C VGND VGND VPWR VPWR g_row\[0\].g_col\[1\].pe__2184_/X
+ sky130_fd_sc_hd__and3b_2
XTAP_TAPCELL_ROW_8_326 VGND VPWR sky130_fd_sc_hd__tapvpwrvgnd_1
Xg_row\[0\].g_col\[0\].pe__2099_ g_row\[0\].g_col\[0\].pe__2099_/A g_row\[0\].g_col\[0\].pe__2184_/B
+ g_row\[0\].g_col\[0\].pe__2099_/C VGND VGND VPWR VPWR g_row\[0\].g_col\[0\].pe__2145_/A
+ sky130_fd_sc_hd__and3_4
Xg_row\[1\].g_col\[1\].pe_hold1705 g_row\[1\].g_col\[1\].pe__2753_/Q VGND VGND VPWR
+ VPWR g_row\[1\].g_col\[1\].pe__2383_/A sky130_fd_sc_hd__clkbuf_2
Xg_row\[1\].g_col\[1\].pe__1959_ g_row\[1\].g_col\[1\].pe__2075_/A g_row\[1\].g_col\[1\].pe__1959_/B
+ VGND VGND VPWR VPWR g_row\[1\].g_col\[1\].pe__1961_/B sky130_fd_sc_hd__xnor2_2
XFILLER_1_738 VGND VGND VPWR VPWR sky130_fd_sc_hd__decap_3
XTAP_TAPCELL_ROW_8_337 VGND VPWR sky130_fd_sc_hd__tapvpwrvgnd_1
Xhold3132 hold3132/A VGND VGND VPWR VPWR hold3132/X sky130_fd_sc_hd__clkbuf_2
Xg_row\[1\].g_col\[1\].pe_hold1738 g_row\[1\].g_col\[1\].pe__2750_/Q VGND VGND VPWR
+ VPWR g_row\[1\].g_col\[1\].pe__2308_/A sky130_fd_sc_hd__clkbuf_2
XFILLER_88_377 VGND VGND VPWR VPWR sky130_fd_sc_hd__fill_1
Xhold2420 hold3144/X VGND VGND VPWR VPWR hold3145/A sky130_fd_sc_hd__clkbuf_2
Xhold2431 hold2431/A VGND VGND VPWR VPWR _308_/D sky130_fd_sc_hd__clkbuf_2
Xhold3143 hold3143/A VGND VGND VPWR VPWR hold3143/X sky130_fd_sc_hd__clkbuf_2
Xhold3154 hold3154/A VGND VGND VPWR VPWR hold3154/X sky130_fd_sc_hd__clkbuf_2
Xhold3165 b_inputs_flat[21] VGND VGND VPWR VPWR hold3165/X sky130_fd_sc_hd__clkbuf_2
Xhold3176 hold3176/A VGND VGND VPWR VPWR hold3176/X sky130_fd_sc_hd__clkbuf_2
Xhold2442 _245_/Y VGND VGND VPWR VPWR hold2442/X sky130_fd_sc_hd__clkbuf_2
Xhold2453 hold3213/X VGND VGND VPWR VPWR _247_/B_N sky130_fd_sc_hd__clkbuf_2
Xhold2464 hold3162/X VGND VGND VPWR VPWR hold3163/A sky130_fd_sc_hd__clkbuf_2
Xhold3187 hold3187/A VGND VGND VPWR VPWR hold3187/X sky130_fd_sc_hd__clkbuf_2
Xhold3198 hold3198/A VGND VGND VPWR VPWR hold3198/X sky130_fd_sc_hd__clkbuf_2
XFILLER_29_455 VGND VGND VPWR VPWR sky130_fd_sc_hd__decap_3
XFILLER_56_46 VGND VGND VPWR VPWR sky130_fd_sc_hd__fill_2
XFILLER_91_509 VGND VGND VPWR VPWR sky130_fd_sc_hd__decap_3
XPHY_EDGE_ROW_87_Left_181 VGND VGND VPWR VPWR sky130_fd_sc_hd__decap_3
Xhold2475 hold3216/X VGND VGND VPWR VPWR hold3217/A sky130_fd_sc_hd__clkbuf_2
Xhold2486 hold3193/X VGND VGND VPWR VPWR hold3194/A sky130_fd_sc_hd__clkbuf_2
Xhold2497 hold2497/A VGND VGND VPWR VPWR _318_/D sky130_fd_sc_hd__clkbuf_2
XFILLER_17_617 VGND VGND VPWR VPWR sky130_fd_sc_hd__decap_3
XFILLER_29_477 VGND VGND VPWR VPWR sky130_fd_sc_hd__decap_3
XFILLER_44_414 VGND VGND VPWR VPWR sky130_fd_sc_hd__fill_1
XFILLER_56_79 VGND VGND VPWR VPWR sky130_fd_sc_hd__fill_1
XFILLER_72_701 VGND VGND VPWR VPWR sky130_fd_sc_hd__decap_3
XTAP_TAPCELL_ROW_67_1215 VGND VPWR sky130_fd_sc_hd__tapvpwrvgnd_1
Xhold1763 hold3000/X VGND VGND VPWR VPWR hold1763/X sky130_fd_sc_hd__clkbuf_2
Xg_row\[0\].g_col\[1\].pe__1968_ g_row\[0\].g_col\[1\].pe__1459_/C g_row\[0\].g_col\[1\].pe__1968_/B
+ g_row\[0\].g_col\[1\].pe__1968_/C VGND VGND VPWR VPWR g_row\[0\].g_col\[1\].pe__1974_/A
+ sky130_fd_sc_hd__nand3b_2
XFILLER_44_436 VGND VGND VPWR VPWR sky130_fd_sc_hd__fill_1
XTAP_TAPCELL_ROW_27_612 VGND VPWR sky130_fd_sc_hd__tapvpwrvgnd_1
Xg_row\[0\].g_col\[1\].pe__1899_ g_row\[0\].g_col\[1\].pe__1899_/A g_row\[0\].g_col\[1\].pe__1899_/B
+ VGND VGND VPWR VPWR g_row\[0\].g_col\[1\].pe__1899_/X sky130_fd_sc_hd__and2_2
XFILLER_44_458 VGND VGND VPWR VPWR sky130_fd_sc_hd__decap_3
XTAP_TAPCELL_ROW_80_1404 VGND VPWR sky130_fd_sc_hd__tapvpwrvgnd_1
XTAP_TAPCELL_ROW_80_1415 VGND VPWR sky130_fd_sc_hd__tapvpwrvgnd_1
XTAP_TAPCELL_ROW_78_1377 VGND VPWR sky130_fd_sc_hd__tapvpwrvgnd_1
Xg_row\[1\].g_col\[0\].pe__1530_ place1099/X g_row\[1\].g_col\[0\].pe__1657_/B g_row\[1\].g_col\[0\].pe__2036_/B1
+ g_row\[1\].g_col\[0\].pe__2605_/B VGND VGND VPWR VPWR g_row\[1\].g_col\[0\].pe__1531_/B
+ sky130_fd_sc_hd__a22o_2
XTAP_TAPCELL_ROW_91_1577 VGND VPWR sky130_fd_sc_hd__tapvpwrvgnd_1
XFILLER_0_760 VGND VGND VPWR VPWR sky130_fd_sc_hd__decap_3
XFILLER_0_782 VGND VGND VPWR VPWR sky130_fd_sc_hd__fill_2
XFILLER_67_528 VGND VGND VPWR VPWR sky130_fd_sc_hd__decap_3
Xg_row\[1\].g_col\[0\].pe__1461_ g_row\[1\].g_col\[0\].pe__1461_/A g_row\[1\].g_col\[0\].pe__1461_/B
+ VGND VGND VPWR VPWR g_row\[1\].g_col\[0\].pe__1461_/Y sky130_fd_sc_hd__nand2_2
XFILLER_48_753 VGND VGND VPWR VPWR sky130_fd_sc_hd__decap_3
Xg_row\[1\].g_col\[0\].pe__1392_ hold1898/X g_row\[1\].g_col\[0\].pe__1402_/B VGND
+ VGND VPWR VPWR g_row\[1\].g_col\[0\].pe__1392_/X sky130_fd_sc_hd__or2_2
XFILLER_63_712 VGND VGND VPWR VPWR sky130_fd_sc_hd__fill_2
XFILLER_75_561 VGND VGND VPWR VPWR sky130_fd_sc_hd__decap_3
XFILLER_50_406 VGND VGND VPWR VPWR sky130_fd_sc_hd__fill_2
Xg_row\[0\].g_col\[0\].pe__1470_ g_row\[0\].g_col\[0\].pe__2733_/Q g_row\[0\].g_col\[0\].pe__2732_/Q
+ VGND VGND VPWR VPWR g_row\[0\].g_col\[0\].pe__1471_/B sky130_fd_sc_hd__or2_2
Xg_row\[1\].g_col\[0\].pe__2013_ g_row\[1\].g_col\[0\].pe__2013_/A g_row\[1\].g_col\[0\].pe__2013_/B
+ VGND VGND VPWR VPWR g_row\[1\].g_col\[0\].pe__2153_/A sky130_fd_sc_hd__nor2_2
XFILLER_43_491 VGND VGND VPWR VPWR sky130_fd_sc_hd__fill_1
Xclkbuf_0_clk clk VGND VGND VPWR VPWR clkbuf_0_clk/X sky130_fd_sc_hd__clkbuf_16
XFILLER_30_141 VGND VGND VPWR VPWR sky130_fd_sc_hd__decap_3
XFILLER_31_686 VGND VGND VPWR VPWR sky130_fd_sc_hd__decap_3
Xg_row\[0\].g_col\[0\].pe__2022_ g_row\[0\].g_col\[0\].pe__2071_/A g_row\[0\].g_col\[0\].pe__2071_/B
+ VGND VGND VPWR VPWR g_row\[0\].g_col\[0\].pe__2023_/B sky130_fd_sc_hd__xor2_2
Xg_row\[1\].g_col\[1\].pe__1813_ g_row\[1\].g_col\[1\].pe__1813_/A g_row\[1\].g_col\[1\].pe__1813_/B
+ VGND VGND VPWR VPWR g_row\[1\].g_col\[1\].pe__1813_/Y sky130_fd_sc_hd__nand2_2
XPHY_EDGE_ROW_15_Right_15 VGND VGND VPWR VPWR sky130_fd_sc_hd__decap_3
Xg_row\[1\].g_col\[1\].pe__1744_ g_row\[1\].g_col\[1\].pe__1815_/B g_row\[1\].g_col\[1\].pe__1815_/A
+ VGND VGND VPWR VPWR g_row\[1\].g_col\[1\].pe__1819_/A sky130_fd_sc_hd__nand2b_2
Xg_row\[1\].g_col\[0\].pe__1728_ g_row\[1\].g_col\[0\].pe__1808_/A g_row\[1\].g_col\[0\].pe__1728_/B
+ VGND VGND VPWR VPWR g_row\[1\].g_col\[0\].pe__1734_/A sky130_fd_sc_hd__xnor2_2
Xg_row\[1\].g_col\[1\].pe__1675_ g_row\[1\].g_col\[1\].pe__1676_/A g_row\[1\].g_col\[1\].pe__1676_/B
+ VGND VGND VPWR VPWR g_row\[1\].g_col\[1\].pe__1823_/A sky130_fd_sc_hd__nor2_2
Xg_row\[1\].g_col\[0\].pe__1659_ g_row\[1\].g_col\[0\].pe__1659_/A g_row\[1\].g_col\[0\].pe__1664_/A
+ VGND VGND VPWR VPWR g_row\[1\].g_col\[0\].pe__1693_/B sky130_fd_sc_hd__xnor2_2
Xg_row\[0\].g_col\[1\].pe__1822_ g_row\[0\].g_col\[1\].pe__1818_/B g_row\[0\].g_col\[1\].pe__1819_/B
+ g_row\[0\].g_col\[1\].pe__1822_/C g_row\[0\].g_col\[1\].pe__1822_/D VGND VGND VPWR
+ VPWR g_row\[0\].g_col\[1\].pe__1822_/X sky130_fd_sc_hd__and4bb_2
XFILLER_54_701 VGND VGND VPWR VPWR sky130_fd_sc_hd__decap_3
Xg_row\[0\].g_col\[0\].pe__1806_ g_row\[0\].g_col\[0\].pe__1801_/C g_row\[0\].g_col\[0\].pe__1806_/B
+ VGND VGND VPWR VPWR g_row\[0\].g_col\[0\].pe__1808_/C sky130_fd_sc_hd__and2b_2
XFILLER_26_27 VGND VGND VPWR VPWR sky130_fd_sc_hd__fill_1
XFILLER_26_447 VGND VGND VPWR VPWR sky130_fd_sc_hd__decap_3
XFILLER_38_274 VGND VGND VPWR VPWR sky130_fd_sc_hd__fill_1
XFILLER_53_222 VGND VGND VPWR VPWR sky130_fd_sc_hd__fill_2
Xg_row\[0\].g_col\[0\].pe__1737_ g_row\[0\].g_col\[0\].pe__1740_/A g_row\[0\].g_col\[0\].pe__1740_/B
+ VGND VGND VPWR VPWR g_row\[0\].g_col\[0\].pe__1776_/A sky130_fd_sc_hd__xor2_2
Xg_row\[0\].g_col\[1\].pe__1753_ g_row\[0\].g_col\[1\].pe__1756_/A g_row\[0\].g_col\[1\].pe__1756_/B
+ VGND VGND VPWR VPWR g_row\[0\].g_col\[1\].pe__1770_/A sky130_fd_sc_hd__xor2_2
XFILLER_26_458 VGND VGND VPWR VPWR sky130_fd_sc_hd__decap_3
XFILLER_81_564 VGND VGND VPWR VPWR sky130_fd_sc_hd__decap_3
XPHY_EDGE_ROW_24_Right_24 VGND VGND VPWR VPWR sky130_fd_sc_hd__decap_3
Xg_row\[0\].g_col\[1\].pe__1684_ g_row\[0\].g_col\[1\].pe__1761_/A2 g_row\[0\].g_col\[1\].pe__1732_/A2
+ g_row\[0\].g_col\[1\].pe__1732_/B1 g_row\[0\].g_col\[1\].pe__1782_/A2 VGND VGND
+ VPWR VPWR g_row\[0\].g_col\[1\].pe__1685_/B sky130_fd_sc_hd__a22o_2
Xg_row\[1\].g_col\[1\].pe__2227_ g_row\[1\].g_col\[1\].pe__2228_/A g_row\[1\].g_col\[1\].pe__2228_/B
+ g_row\[1\].g_col\[1\].pe__2228_/C VGND VGND VPWR VPWR g_row\[1\].g_col\[1\].pe__2262_/A
+ sky130_fd_sc_hd__o21ai_2
Xg_row\[0\].g_col\[0\].pe__1668_ g_row\[0\].g_col\[0\].pe__1701_/A g_row\[0\].g_col\[0\].pe__1701_/B
+ VGND VGND VPWR VPWR g_row\[0\].g_col\[0\].pe__1831_/A sky130_fd_sc_hd__or2_2
XFILLER_34_480 VGND VGND VPWR VPWR sky130_fd_sc_hd__decap_3
XTAP_TAPCELL_ROW_62_1134 VGND VPWR sky130_fd_sc_hd__tapvpwrvgnd_1
XTAP_TAPCELL_ROW_62_1145 VGND VPWR sky130_fd_sc_hd__tapvpwrvgnd_1
Xg_row\[1\].g_col\[1\].pe__2158_ g_row\[1\].g_col\[1\].pe__2334_/A1 g_row\[1\].g_col\[1\].pe__2158_/A2
+ g_row\[1\].g_col\[1\].pe__2155_/X g_row\[1\].g_col\[1\].pe__2157_/Y VGND VGND VPWR
+ VPWR g_row\[1\].g_col\[1\].pe__2158_/X sky130_fd_sc_hd__o22a_2
XFILLER_10_804 VGND VGND VPWR VPWR sky130_fd_sc_hd__fill_1
Xg_row\[1\].g_col\[1\].pe__2089_ g_row\[1\].g_col\[1\].pe__2278_/B2 g_row\[1\].g_col\[1\].pe__1471_/X
+ g_row\[1\].g_col\[1\].pe__1474_/Y g_row\[1\].g_col\[1\].pe__2241_/B2 VGND VGND VPWR
+ VPWR g_row\[1\].g_col\[1\].pe__2090_/B sky130_fd_sc_hd__a22o_2
XFILLER_21_196 VGND VGND VPWR VPWR sky130_fd_sc_hd__fill_2
XTAP_TAPCELL_ROW_32_692 VGND VPWR sky130_fd_sc_hd__tapvpwrvgnd_1
Xg_row\[0\].g_col\[1\].pe__2305_ g_row\[0\].g_col\[1\].pe__2305_/A g_row\[0\].g_col\[1\].pe__2305_/B
+ VGND VGND VPWR VPWR g_row\[0\].g_col\[1\].pe__2305_/Y sky130_fd_sc_hd__xnor2_2
Xg_row\[0\].g_col\[1\].pe__2236_ g_row\[0\].g_col\[1\].pe__2010_/A g_row\[0\].g_col\[1\].pe__2233_/X
+ g_row\[0\].g_col\[1\].pe__2234_/Y g_row\[0\].g_col\[1\].pe__2236_/B1 place1250/X
+ VGND VGND VPWR VPWR g_row\[0\].g_col\[1\].pe__2236_/X sky130_fd_sc_hd__o32a_2
XFILLER_1_502 VGND VGND VPWR VPWR sky130_fd_sc_hd__fill_2
XPHY_EDGE_ROW_33_Right_33 VGND VGND VPWR VPWR sky130_fd_sc_hd__decap_3
Xg_row\[1\].g_col\[1\].pe_hold2247 g_row\[1\].g_col\[1\].pe__2643_/X VGND VGND VPWR
+ VPWR g_row\[1\].g_col\[1\].pe__2644_/C1 sky130_fd_sc_hd__clkbuf_2
Xg_row\[0\].g_col\[1\].pe__2167_ g_row\[0\].g_col\[1\].pe__2167_/A g_row\[0\].g_col\[1\].pe__2167_/B
+ g_row\[0\].g_col\[1\].pe__2167_/C VGND VGND VPWR VPWR g_row\[0\].g_col\[1\].pe__2167_/X
+ sky130_fd_sc_hd__and3_2
Xg_row\[0\].g_col\[1\].pe__2098_ g_row\[0\].g_col\[1\].pe__2048_/A g_row\[0\].g_col\[1\].pe__2048_/B
+ g_row\[0\].g_col\[1\].pe__2048_/C g_row\[0\].g_col\[1\].pe__2047_/B g_row\[0\].g_col\[1\].pe__2047_/A
+ VGND VGND VPWR VPWR g_row\[0\].g_col\[1\].pe__2099_/C sky130_fd_sc_hd__a32o_2
XFILLER_88_141 VGND VGND VPWR VPWR sky130_fd_sc_hd__fill_1
XFILLER_1_579 VGND VGND VPWR VPWR sky130_fd_sc_hd__decap_3
XFILLER_57_550 VGND VGND VPWR VPWR sky130_fd_sc_hd__decap_3
XFILLER_57_561 VGND VGND VPWR VPWR sky130_fd_sc_hd__fill_1
Xhold1560 hold2706/X VGND VGND VPWR VPWR hold2707/A sky130_fd_sc_hd__clkbuf_2
Xhold1571 hold3478/X VGND VGND VPWR VPWR hold3479/A sky130_fd_sc_hd__clkbuf_2
XPHY_EDGE_ROW_42_Right_42 VGND VGND VPWR VPWR sky130_fd_sc_hd__decap_3
Xhold1582 hold3516/X VGND VGND VPWR VPWR hold3517/A sky130_fd_sc_hd__clkbuf_2
Xhold1593 hold2712/X VGND VGND VPWR VPWR hold2713/A sky130_fd_sc_hd__clkbuf_2
Xg_row\[1\].g_col\[0\].pe_place932 g_row\[1\].g_col\[0\].pe__1387_/B VGND VGND VPWR
+ VPWR g_row\[1\].g_col\[0\].pe__1402_/B sky130_fd_sc_hd__buf_6
Xg_row\[1\].g_col\[0\].pe_place921 g_row\[1\].g_col\[0\].pe__1982_/B VGND VGND VPWR
+ VPWR g_row\[1\].g_col\[0\].pe__1732_/A2 sky130_fd_sc_hd__buf_6
Xg_row\[1\].g_col\[0\].pe_place910 g_row\[1\].g_col\[0\].pe__2399_/Y VGND VGND VPWR
+ VPWR g_row\[1\].g_col\[0\].pe__2421_/A1 sky130_fd_sc_hd__buf_6
XFILLER_32_428 VGND VGND VPWR VPWR sky130_fd_sc_hd__decap_3
XFILLER_44_266 VGND VGND VPWR VPWR sky130_fd_sc_hd__fill_2
XFILLER_12_141 VGND VGND VPWR VPWR sky130_fd_sc_hd__decap_3
XFILLER_13_697 VGND VGND VPWR VPWR sky130_fd_sc_hd__decap_3
XFILLER_9_646 VGND VGND VPWR VPWR sky130_fd_sc_hd__decap_3
XPHY_EDGE_ROW_51_Right_51 VGND VGND VPWR VPWR sky130_fd_sc_hd__decap_3
XFILLER_5_841 VGND VGND VPWR VPWR sky130_fd_sc_hd__fill_1
XTAP_TAPCELL_ROW_10_353 VGND VPWR sky130_fd_sc_hd__tapvpwrvgnd_1
XTAP_TAPCELL_ROW_10_364 VGND VPWR sky130_fd_sc_hd__tapvpwrvgnd_1
XTAP_TAPCELL_ROW_93_1606 VGND VPWR sky130_fd_sc_hd__tapvpwrvgnd_1
XTAP_TAPCELL_ROW_93_1617 VGND VPWR sky130_fd_sc_hd__tapvpwrvgnd_1
Xg_row\[0\].g_col\[0\].pe_place1174 g_row\[0\].g_col\[0\].pe__1348_/A VGND VGND VPWR
+ VPWR g_row\[0\].g_col\[0\].pe__2776_/A sky130_fd_sc_hd__buf_6
Xg_row\[1\].g_col\[0\].pe__2700_ _302_/CLK g_row\[1\].g_col\[0\].pe__2700_/D VGND
+ VGND VPWR VPWR place1086/A sky130_fd_sc_hd__dfxtp_2
Xg_row\[0\].g_col\[0\].pe_place1185 g_row\[0\].g_col\[0\].pe__2728_/Q VGND VGND VPWR
+ VPWR g_row\[0\].g_col\[0\].pe__1768_/A sky130_fd_sc_hd__buf_6
Xg_row\[0\].g_col\[0\].pe_place1196 hold2340/A VGND VGND VPWR VPWR g_row\[0\].g_col\[0\].pe__2121_/A
+ sky130_fd_sc_hd__buf_6
Xg_row\[1\].g_col\[0\].pe__2631_ g_row\[1\].g_col\[0\].pe__2652_/A1 g_row\[1\].g_col\[0\].pe__2631_/A2
+ g_row\[1\].g_col\[0\].pe__2687_/C1 g_row\[1\].g_col\[0\].pe__2630_/X VGND VGND VPWR
+ VPWR g_row\[1\].g_col\[0\].pe__2631_/X sky130_fd_sc_hd__o211a_2
XFILLER_67_325 VGND VGND VPWR VPWR sky130_fd_sc_hd__fill_1
Xg_row\[1\].g_col\[0\].pe__2493_ g_row\[1\].g_col\[0\].pe__2422_/A g_row\[1\].g_col\[0\].pe__2484_/Y
+ g_row\[1\].g_col\[0\].pe__2594_/B2 g_row\[1\].g_col\[0\].pe__2754_/Q VGND VGND VPWR
+ VPWR g_row\[1\].g_col\[0\].pe__2503_/B sky130_fd_sc_hd__a211oi_2
Xg_row\[1\].g_col\[0\].pe__1513_ g_row\[1\].g_col\[0\].pe__1500_/A g_row\[1\].g_col\[0\].pe__1500_/B
+ g_row\[1\].g_col\[0\].pe__1512_/Y VGND VGND VPWR VPWR g_row\[1\].g_col\[0\].pe__1588_/A
+ sky130_fd_sc_hd__a21oi_2
Xg_row\[1\].g_col\[1\].pe__1460_ g_row\[1\].g_col\[1\].pe__2731_/Q g_row\[1\].g_col\[1\].pe__1816_/A
+ g_row\[1\].g_col\[1\].pe__2732_/Q VGND VGND VPWR VPWR g_row\[1\].g_col\[1\].pe__1461_/B
+ sky130_fd_sc_hd__or3b_4
Xg_row\[1\].g_col\[0\].pe__1444_ g_row\[1\].g_col\[0\].pe__2729_/Q g_row\[1\].g_col\[0\].pe__2125_/C
+ VGND VGND VPWR VPWR g_row\[1\].g_col\[0\].pe__2079_/B sky130_fd_sc_hd__xor2_2
XPHY_EDGE_ROW_60_Right_60 VGND VGND VPWR VPWR sky130_fd_sc_hd__decap_3
Xg_row\[0\].g_col\[0\].pe__2640_ g_row\[0\].g_col\[0\].pe__2640_/A1 g_row\[0\].g_col\[0\].pe__2640_/A2
+ g_row\[0\].g_col\[0\].pe__2639_/X g_row\[0\].g_col\[0\].pe__2640_/C1 VGND VGND VPWR
+ VPWR g_row\[0\].g_col\[0\].pe__2640_/X sky130_fd_sc_hd__o211a_2
Xg_row\[1\].g_col\[1\].pe__1391_ g_row\[1\].g_col\[1\].pe__1391_/A1 g_row\[1\].g_col\[1\].pe__1403_/A2
+ g_row\[1\].g_col\[1\].pe__1389_/X g_row\[1\].g_col\[1\].pe__2666_/B1 VGND VGND VPWR
+ VPWR g_row\[1\].g_col\[1\].pe__1391_/X sky130_fd_sc_hd__o211a_2
XFILLER_63_531 VGND VGND VPWR VPWR sky130_fd_sc_hd__decap_3
Xg_row\[0\].g_col\[0\].pe__2571_ g_row\[0\].g_col\[0\].pe__2571_/A g_row\[0\].g_col\[0\].pe__2590_/A
+ VGND VGND VPWR VPWR g_row\[0\].g_col\[0\].pe__2571_/X sky130_fd_sc_hd__or2_2
XFILLER_23_428 VGND VGND VPWR VPWR sky130_fd_sc_hd__fill_2
XFILLER_51_737 VGND VGND VPWR VPWR sky130_fd_sc_hd__decap_3
XFILLER_51_748 VGND VGND VPWR VPWR sky130_fd_sc_hd__fill_2
XFILLER_90_383 VGND VGND VPWR VPWR sky130_fd_sc_hd__fill_1
XTAP_TAPCELL_ROW_18_475 VGND VPWR sky130_fd_sc_hd__tapvpwrvgnd_1
XTAP_TAPCELL_ROW_18_486 VGND VPWR sky130_fd_sc_hd__tapvpwrvgnd_1
Xg_row\[0\].g_col\[0\].pe__1522_ g_row\[0\].g_col\[0\].pe__1768_/A g_row\[0\].g_col\[0\].pe__1522_/B
+ VGND VGND VPWR VPWR g_row\[0\].g_col\[0\].pe__1523_/B sky130_fd_sc_hd__xor2_2
Xg_row\[0\].g_col\[0\].pe__1453_ g_row\[0\].g_col\[0\].pe__2732_/Q VGND VGND VPWR
+ VPWR g_row\[0\].g_col\[0\].pe__2123_/A sky130_fd_sc_hd__inv_2
Xg_row\[1\].g_col\[1\].pe__2012_ g_row\[1\].g_col\[1\].pe__1951_/A g_row\[1\].g_col\[1\].pe__1951_/B
+ g_row\[1\].g_col\[1\].pe__2009_/B g_row\[1\].g_col\[1\].pe__2006_/A VGND VGND VPWR
+ VPWR g_row\[1\].g_col\[1\].pe__2062_/C sky130_fd_sc_hd__a31o_2
XFILLER_50_269 VGND VGND VPWR VPWR sky130_fd_sc_hd__decap_3
Xg_row\[0\].g_col\[0\].pe__1384_ g_row\[0\].g_col\[0\].pe__1789_/A g_row\[0\].g_col\[0\].pe__1399_/A2
+ g_row\[0\].g_col\[0\].pe__1384_/B1 g_row\[0\].g_col\[0\].pe__2685_/C1 VGND VGND
+ VPWR VPWR g_row\[0\].g_col\[0\].pe__1384_/X sky130_fd_sc_hd__o211a_2
Xg_row\[0\].g_col\[1\].pe__2021_ g_row\[0\].g_col\[1\].pe__2179_/A g_row\[0\].g_col\[1\].pe__2021_/B
+ VGND VGND VPWR VPWR g_row\[0\].g_col\[1\].pe__2071_/B sky130_fd_sc_hd__xnor2_2
Xg_row\[0\].g_col\[0\].pe__2005_ g_row\[0\].g_col\[0\].pe__2005_/A g_row\[0\].g_col\[0\].pe__2005_/B
+ VGND VGND VPWR VPWR g_row\[0\].g_col\[0\].pe__2009_/B sky130_fd_sc_hd__or2_2
Xg_row\[1\].g_col\[1\].pe__2776_ g_row\[1\].g_col\[1\].pe__2776_/A VGND VGND VPWR
+ VPWR output1414/A sky130_fd_sc_hd__buf_2
Xg_row\[1\].g_col\[1\].pe__1727_ g_row\[1\].g_col\[1\].pe__1727_/A1 g_row\[1\].g_col\[1\].pe__2614_/B
+ g_row\[1\].g_col\[1\].pe__2612_/B g_row\[1\].g_col\[1\].pe__1727_/B2 VGND VGND VPWR
+ VPWR g_row\[1\].g_col\[1\].pe__1728_/B sky130_fd_sc_hd__a22o_2
XFILLER_86_645 VGND VGND VPWR VPWR sky130_fd_sc_hd__fill_1
XFILLER_86_667 VGND VGND VPWR VPWR sky130_fd_sc_hd__fill_1
Xg_row\[1\].g_col\[1\].pe__1658_ g_row\[1\].g_col\[1\].pe__1676_/A g_row\[1\].g_col\[1\].pe__1658_/B
+ VGND VGND VPWR VPWR g_row\[1\].g_col\[1\].pe__1664_/A sky130_fd_sc_hd__xnor2_2
XFILLER_39_561 VGND VGND VPWR VPWR sky130_fd_sc_hd__fill_2
XFILLER_39_583 VGND VGND VPWR VPWR sky130_fd_sc_hd__decap_3
XFILLER_54_520 VGND VGND VPWR VPWR sky130_fd_sc_hd__decap_3
Xg_row\[1\].g_col\[1\].pe__1589_ g_row\[1\].g_col\[1\].pe__1547_/A g_row\[1\].g_col\[1\].pe__1547_/B
+ g_row\[1\].g_col\[1\].pe__1588_/Y VGND VGND VPWR VPWR g_row\[1\].g_col\[1\].pe__1594_/B
+ sky130_fd_sc_hd__a21o_2
Xg_row\[0\].g_col\[1\].pe__1805_ g_row\[0\].g_col\[1\].pe__1804_/A g_row\[0\].g_col\[1\].pe__1805_/A2
+ g_row\[0\].g_col\[1\].pe__1801_/A g_row\[0\].g_col\[1\].pe__1804_/X g_row\[0\].g_col\[1\].pe__1801_/X
+ VGND VGND VPWR VPWR g_row\[0\].g_col\[1\].pe__1808_/B sky130_fd_sc_hd__a221o_2
XFILLER_54_542 VGND VGND VPWR VPWR sky130_fd_sc_hd__fill_2
Xg_row\[0\].g_col\[0\].pe__2769_ clkbuf_leaf_51_clk/X g_row\[0\].g_col\[0\].pe__2769_/D
+ VGND VGND VPWR VPWR g_row\[0\].g_col\[0\].pe__2769_/Q sky130_fd_sc_hd__dfxtp_2
Xg_row\[1\].g_col\[0\].pe_hold1791 g_row\[1\].g_col\[0\].pe__2611_/X VGND VGND VPWR
+ VPWR g_row\[1\].g_col\[0\].pe__2694_/D sky130_fd_sc_hd__clkbuf_2
XFILLER_26_277 VGND VGND VPWR VPWR sky130_fd_sc_hd__fill_1
XFILLER_54_597 VGND VGND VPWR VPWR sky130_fd_sc_hd__fill_1
XTAP_TAPCELL_ROW_37_762 VGND VPWR sky130_fd_sc_hd__tapvpwrvgnd_1
Xg_row\[0\].g_col\[1\].pe__1736_ g_row\[0\].g_col\[1\].pe__1736_/A g_row\[0\].g_col\[1\].pe__1736_/B
+ VGND VGND VPWR VPWR g_row\[0\].g_col\[1\].pe__1740_/B sky130_fd_sc_hd__xnor2_2
Xg_row\[0\].g_col\[1\].pe__1667_ g_row\[0\].g_col\[1\].pe__1663_/A g_row\[0\].g_col\[1\].pe__1663_/B
+ g_row\[0\].g_col\[1\].pe__1666_/Y VGND VGND VPWR VPWR g_row\[0\].g_col\[1\].pe__1701_/B
+ sky130_fd_sc_hd__a21boi_2
Xg_row\[0\].g_col\[1\].pe__1598_ g_row\[0\].g_col\[1\].pe__2603_/B g_row\[0\].g_col\[1\].pe__2177_/A2
+ g_row\[0\].g_col\[1\].pe__1901_/B1 g_row\[0\].g_col\[1\].pe__2690_/Q VGND VGND VPWR
+ VPWR g_row\[0\].g_col\[1\].pe__1604_/A sky130_fd_sc_hd__a22o_2
XFILLER_10_623 VGND VGND VPWR VPWR sky130_fd_sc_hd__decap_3
XFILLER_10_634 VGND VGND VPWR VPWR sky130_fd_sc_hd__fill_2
XFILLER_5_126 VGND VGND VPWR VPWR sky130_fd_sc_hd__decap_3
XTAP_TAPCELL_ROW_75_1336 VGND VPWR sky130_fd_sc_hd__tapvpwrvgnd_1
Xg_row\[0\].g_col\[1\].pe__2219_ g_row\[0\].g_col\[1\].pe__2219_/A g_row\[0\].g_col\[1\].pe__2219_/B
+ VGND VGND VPWR VPWR g_row\[0\].g_col\[1\].pe__2220_/B sky130_fd_sc_hd__xor2_2
XFILLER_1_376 VGND VGND VPWR VPWR sky130_fd_sc_hd__fill_1
XFILLER_18_701 VGND VGND VPWR VPWR sky130_fd_sc_hd__decap_3
Xg_row\[1\].g_col\[1\].pe_max_cap1419 g_row\[1\].g_col\[1\].pe__2517_/Y VGND VGND
+ VPWR VPWR g_row\[1\].g_col\[1\].pe__2591_/B1 sky130_fd_sc_hd__buf_6
XFILLER_18_778 VGND VGND VPWR VPWR sky130_fd_sc_hd__fill_2
XFILLER_91_169 VGND VGND VPWR VPWR sky130_fd_sc_hd__fill_1
XTAP_TAPCELL_ROW_86_1498 VGND VPWR sky130_fd_sc_hd__tapvpwrvgnd_1
XTAP_TAPCELL_ROW_15_434 VGND VPWR sky130_fd_sc_hd__tapvpwrvgnd_1
XFILLER_60_589 VGND VGND VPWR VPWR sky130_fd_sc_hd__decap_3
Xg_row\[0\].g_col\[0\].pe_hold1801 g_row\[0\].g_col\[0\].pe__1401_/X VGND VGND VPWR
+ VPWR g_row\[0\].g_col\[0\].pe__2736_/D sky130_fd_sc_hd__clkbuf_2
Xg_row\[1\].g_col\[0\].pe__1993_ g_row\[1\].g_col\[0\].pe__1991_/X g_row\[1\].g_col\[0\].pe__1993_/B
+ VGND VGND VPWR VPWR g_row\[1\].g_col\[0\].pe__2055_/A sky130_fd_sc_hd__nand2b_4
XFILLER_5_671 VGND VGND VPWR VPWR sky130_fd_sc_hd__fill_1
Xg_row\[1\].g_col\[1\].pe__2630_ place1247/X g_row\[1\].g_col\[1\].pe__2630_/B VGND
+ VGND VPWR VPWR g_row\[1\].g_col\[1\].pe__2630_/X sky130_fd_sc_hd__or2_2
Xg_row\[1\].g_col\[0\].pe__2614_ g_row\[1\].g_col\[0\].pe__2639_/A place1094/A VGND
+ VGND VPWR VPWR g_row\[1\].g_col\[0\].pe__2614_/X sky130_fd_sc_hd__or2_2
Xg_row\[1\].g_col\[1\].pe__2561_ g_row\[1\].g_col\[1\].pe__2569_/A g_row\[1\].g_col\[1\].pe__2561_/B
+ VGND VGND VPWR VPWR g_row\[1\].g_col\[1\].pe__2763_/D sky130_fd_sc_hd__and2_4
Xg_row\[1\].g_col\[0\].pe__2545_ g_row\[1\].g_col\[0\].pe__2546_/A g_row\[1\].g_col\[0\].pe__2546_/B
+ VGND VGND VPWR VPWR g_row\[1\].g_col\[0\].pe__2547_/B sky130_fd_sc_hd__nor2_2
Xg_row\[1\].g_col\[1\].pe__2492_ g_row\[1\].g_col\[1\].pe__2492_/A g_row\[1\].g_col\[1\].pe__2492_/B
+ VGND VGND VPWR VPWR g_row\[1\].g_col\[1\].pe__2567_/A sky130_fd_sc_hd__and2_2
Xg_row\[1\].g_col\[1\].pe__1512_ g_row\[1\].g_col\[1\].pe__1512_/A g_row\[1\].g_col\[1\].pe__1512_/B
+ VGND VGND VPWR VPWR g_row\[1\].g_col\[1\].pe__1512_/Y sky130_fd_sc_hd__nor2_2
Xg_row\[1\].g_col\[1\].pe__1443_ g_row\[1\].g_col\[1\].pe__1479_/A g_row\[1\].g_col\[1\].pe__1479_/B
+ VGND VGND VPWR VPWR g_row\[1\].g_col\[1\].pe__1662_/A sky130_fd_sc_hd__xor2_2
Xg_row\[1\].g_col\[0\].pe__2476_ g_row\[1\].g_col\[0\].pe__2767_/Q g_row\[1\].g_col\[0\].pe__2476_/B
+ VGND VGND VPWR VPWR g_row\[1\].g_col\[0\].pe__2487_/A sky130_fd_sc_hd__xnor2_2
XFILLER_48_380 VGND VGND VPWR VPWR sky130_fd_sc_hd__decap_3
Xg_row\[1\].g_col\[0\].pe__1427_ g_row\[1\].g_col\[0\].pe__1733_/A g_row\[1\].g_col\[0\].pe__1427_/B
+ VGND VGND VPWR VPWR g_row\[1\].g_col\[0\].pe__1650_/B sky130_fd_sc_hd__xor2_2
XFILLER_24_704 VGND VGND VPWR VPWR sky130_fd_sc_hd__decap_3
XFILLER_64_840 VGND VGND VPWR VPWR sky130_fd_sc_hd__fill_2
XFILLER_70_309 VGND VGND VPWR VPWR sky130_fd_sc_hd__fill_2
Xg_row\[0\].g_col\[0\].pe__2623_ g_row\[0\].g_col\[0\].pe__2623_/A place1201/A VGND
+ VGND VPWR VPWR g_row\[0\].g_col\[0\].pe__2623_/X sky130_fd_sc_hd__or2_2
Xg_row\[1\].g_col\[1\].pe__1374_ place1241/X _276_/Q VGND VGND VPWR VPWR g_row\[1\].g_col\[1\].pe__1398_/B
+ sky130_fd_sc_hd__nand2_2
Xg_row\[1\].g_col\[0\].pe__1358_ g_row\[1\].g_col\[0\].pe__2764_/Q g_row\[1\].g_col\[0\].pe__1357_/B
+ g_row\[1\].g_col\[0\].pe__2776_/A VGND VGND VPWR VPWR g_row\[1\].g_col\[0\].pe__1359_/B
+ sky130_fd_sc_hd__o21a_2
XFILLER_36_586 VGND VGND VPWR VPWR sky130_fd_sc_hd__fill_2
XFILLER_51_501 VGND VGND VPWR VPWR sky130_fd_sc_hd__decap_3
Xg_row\[0\].g_col\[0\].pe__2554_ g_row\[0\].g_col\[0\].pe__2554_/A1 g_row\[0\].g_col\[0\].pe__2554_/A2
+ g_row\[0\].g_col\[0\].pe__2517_/Y g_row\[0\].g_col\[0\].pe__2553_/X VGND VGND VPWR
+ VPWR g_row\[0\].g_col\[0\].pe__2554_/X sky130_fd_sc_hd__a22o_2
XFILLER_23_225 VGND VGND VPWR VPWR sky130_fd_sc_hd__fill_2
XTAP_TAPCELL_ROW_34_721 VGND VPWR sky130_fd_sc_hd__tapvpwrvgnd_1
Xg_row\[0\].g_col\[1\].pe__1521_ g_row\[0\].g_col\[1\].pe__2699_/Q g_row\[0\].g_col\[1\].pe__1732_/A2
+ g_row\[0\].g_col\[1\].pe__1732_/B1 g_row\[0\].g_col\[1\].pe__2036_/B2 VGND VGND
+ VPWR VPWR g_row\[0\].g_col\[1\].pe__1522_/B sky130_fd_sc_hd__a22o_2
Xg_row\[0\].g_col\[0\].pe__2485_ g_row\[0\].g_col\[0\].pe__2754_/Q g_row\[0\].g_col\[0\].pe__2422_/A
+ g_row\[0\].g_col\[0\].pe__2484_/Y g_row\[0\].g_col\[0\].pe__1348_/A VGND VGND VPWR
+ VPWR g_row\[0\].g_col\[0\].pe__2486_/B sky130_fd_sc_hd__o211a_2
Xg_row\[0\].g_col\[1\].pe__1452_ g_row\[0\].g_col\[1\].pe__1816_/A g_row\[0\].g_col\[1\].pe__1452_/B
+ VGND VGND VPWR VPWR g_row\[0\].g_col\[1\].pe__1507_/A sky130_fd_sc_hd__xor2_2
Xg_row\[0\].g_col\[0\].pe__1436_ place1205/X g_row\[0\].g_col\[0\].pe__1784_/A2 g_row\[0\].g_col\[0\].pe__1784_/A3
+ g_row\[0\].g_col\[0\].pe__1801_/B place1204/X VGND VGND VPWR VPWR g_row\[0\].g_col\[0\].pe__1437_/B
+ sky130_fd_sc_hd__a32o_2
Xg_row\[0\].g_col\[0\].pe__1367_ g_row\[0\].g_col\[0\].pe__2768_/Q g_row\[0\].g_col\[0\].pe__1366_/B
+ g_row\[0\].g_col\[0\].pe__2776_/A VGND VGND VPWR VPWR g_row\[0\].g_col\[0\].pe__1368_/B
+ sky130_fd_sc_hd__o21ai_2
Xg_row\[0\].g_col\[1\].pe__1383_ g_row\[0\].g_col\[1\].pe__2674_/A g_row\[0\].g_col\[1\].pe__2680_/B
+ VGND VGND VPWR VPWR g_row\[0\].g_col\[1\].pe__1383_/X sky130_fd_sc_hd__or2_2
Xg_row\[0\].g_col\[0\].pe_place827 g_row\[0\].g_col\[0\].pe__2510_/X VGND VGND VPWR
+ VPWR g_row\[0\].g_col\[0\].pe__2590_/A sky130_fd_sc_hd__buf_6
Xg_row\[0\].g_col\[1\].pe__2004_ g_row\[0\].g_col\[1\].pe__2005_/A g_row\[0\].g_col\[1\].pe__2005_/B
+ VGND VGND VPWR VPWR g_row\[0\].g_col\[1\].pe__2006_/A sky130_fd_sc_hd__and2_2
XTAP_TAPCELL_ROW_57_1066 VGND VPWR sky130_fd_sc_hd__tapvpwrvgnd_1
XFILLER_59_601 VGND VGND VPWR VPWR sky130_fd_sc_hd__decap_3
XFILLER_59_623 VGND VGND VPWR VPWR sky130_fd_sc_hd__decap_3
Xg_row\[1\].g_col\[1\].pe__2759_ clkbuf_leaf_76_clk/X g_row\[1\].g_col\[1\].pe__2759_/D
+ VGND VGND VPWR VPWR g_row\[1\].g_col\[1\].pe__2759_/Q sky130_fd_sc_hd__dfxtp_2
XTAP_TAPCELL_ROW_70_1255 VGND VPWR sky130_fd_sc_hd__tapvpwrvgnd_1
XTAP_TAPCELL_ROW_70_1266 VGND VPWR sky130_fd_sc_hd__tapvpwrvgnd_1
XFILLER_58_155 VGND VGND VPWR VPWR sky130_fd_sc_hd__fill_1
XFILLER_86_475 VGND VGND VPWR VPWR sky130_fd_sc_hd__fill_1
XFILLER_73_125 VGND VGND VPWR VPWR sky130_fd_sc_hd__fill_1
XFILLER_74_648 VGND VGND VPWR VPWR sky130_fd_sc_hd__decap_3
XFILLER_39_391 VGND VGND VPWR VPWR sky130_fd_sc_hd__fill_1
Xg_row\[1\].g_col\[1\].pe_place881 g_row\[1\].g_col\[1\].pe__1602_/A VGND VGND VPWR
+ VPWR g_row\[1\].g_col\[1\].pe__2075_/A sky130_fd_sc_hd__buf_6
Xg_row\[1\].g_col\[1\].pe_place892 g_row\[1\].g_col\[1\].pe__1801_/B VGND VGND VPWR
+ VPWR g_row\[1\].g_col\[1\].pe__1920_/A2 sky130_fd_sc_hd__buf_6
XFILLER_27_564 VGND VGND VPWR VPWR sky130_fd_sc_hd__fill_1
XPHY_EDGE_ROW_14_Left_108 VGND VGND VPWR VPWR sky130_fd_sc_hd__decap_3
Xg_row\[0\].g_col\[1\].pe__2768_ _338_/CLK g_row\[0\].g_col\[1\].pe__2768_/D VGND
+ VGND VPWR VPWR g_row\[0\].g_col\[1\].pe__2768_/Q sky130_fd_sc_hd__dfxtp_2
X_321_ _322_/CLK _321_/D VGND VGND VPWR VPWR _321_/Q sky130_fd_sc_hd__dfxtp_2
Xg_row\[0\].g_col\[1\].pe__1719_ g_row\[0\].g_col\[1\].pe__1714_/A g_row\[0\].g_col\[1\].pe__1714_/B
+ g_row\[0\].g_col\[1\].pe__1714_/C VGND VGND VPWR VPWR g_row\[0\].g_col\[1\].pe__1719_/Y
+ sky130_fd_sc_hd__a21oi_2
Xg_row\[0\].g_col\[1\].pe_hold1975 g_row\[0\].g_col\[1\].pe__1391_/X VGND VGND VPWR
+ VPWR g_row\[0\].g_col\[1\].pe__2731_/D sky130_fd_sc_hd__clkbuf_2
XFILLER_42_589 VGND VGND VPWR VPWR sky130_fd_sc_hd__fill_2
Xg_row\[0\].g_col\[1\].pe__2699_ clkbuf_leaf_6_clk/X g_row\[0\].g_col\[1\].pe__2699_/D
+ VGND VGND VPWR VPWR g_row\[0\].g_col\[1\].pe__2699_/Q sky130_fd_sc_hd__dfxtp_2
X_183_ _189_/A _183_/B_N VGND VGND VPWR VPWR _183_/Y sky130_fd_sc_hd__nor2b_4
XFILLER_6_413 VGND VGND VPWR VPWR sky130_fd_sc_hd__decap_3
XPHY_EDGE_ROW_23_Left_117 VGND VGND VPWR VPWR sky130_fd_sc_hd__decap_3
XFILLER_2_630 VGND VGND VPWR VPWR sky130_fd_sc_hd__decap_3
XFILLER_2_641 VGND VGND VPWR VPWR sky130_fd_sc_hd__decap_3
XFILLER_49_144 VGND VGND VPWR VPWR sky130_fd_sc_hd__fill_2
XFILLER_65_604 VGND VGND VPWR VPWR sky130_fd_sc_hd__decap_3
Xg_row\[1\].g_col\[0\].pe__2330_ g_row\[1\].g_col\[0\].pe__2330_/A g_row\[1\].g_col\[0\].pe__2330_/B
+ g_row\[1\].g_col\[0\].pe__2330_/C VGND VGND VPWR VPWR g_row\[1\].g_col\[0\].pe__2330_/X
+ sky130_fd_sc_hd__or3_2
XFILLER_49_188 VGND VGND VPWR VPWR sky130_fd_sc_hd__decap_3
XTAP_TAPCELL_ROW_88_1527 VGND VPWR sky130_fd_sc_hd__tapvpwrvgnd_1
Xg_row\[1\].g_col\[0\].pe__2261_ g_row\[1\].g_col\[0\].pe__2262_/A g_row\[1\].g_col\[0\].pe__2262_/B
+ VGND VGND VPWR VPWR g_row\[1\].g_col\[0\].pe__2261_/Y sky130_fd_sc_hd__nor2_2
XFILLER_18_531 VGND VGND VPWR VPWR sky130_fd_sc_hd__fill_1
XPHY_EDGE_ROW_32_Left_126 VGND VGND VPWR VPWR sky130_fd_sc_hd__decap_3
Xg_row\[1\].g_col\[0\].pe__2192_ g_row\[1\].g_col\[0\].pe__2192_/A g_row\[1\].g_col\[0\].pe__2192_/B
+ VGND VGND VPWR VPWR g_row\[1\].g_col\[0\].pe__2192_/Y sky130_fd_sc_hd__nor2_2
XFILLER_18_575 VGND VGND VPWR VPWR sky130_fd_sc_hd__decap_3
XFILLER_52_309 VGND VGND VPWR VPWR sky130_fd_sc_hd__decap_3
Xg_row\[1\].g_col\[0\].pe_place1108 g_row\[1\].g_col\[0\].pe__2592_/A VGND VGND VPWR
+ VPWR g_row\[1\].g_col\[0\].pe__2626_/B1 sky130_fd_sc_hd__buf_6
XFILLER_33_545 VGND VGND VPWR VPWR sky130_fd_sc_hd__decap_3
Xg_row\[0\].g_col\[0\].pe_hold2310 g_row\[0\].g_col\[0\].pe_hold2886/X VGND VGND VPWR
+ VPWR g_row\[0\].g_col\[0\].pe_hold2887/A sky130_fd_sc_hd__clkbuf_2
Xg_row\[0\].g_col\[0\].pe_hold3033 g_row\[0\].g_col\[0\].pe__1376_/A VGND VGND VPWR
+ VPWR g_row\[0\].g_col\[0\].pe__2650_/A2 sky130_fd_sc_hd__clkbuf_2
Xg_row\[0\].g_col\[0\].pe_hold3044 g_row\[0\].g_col\[0\].pe_hold3044/A VGND VGND VPWR
+ VPWR g_row\[0\].g_col\[0\].pe__1399_/A1 sky130_fd_sc_hd__clkbuf_2
Xg_row\[0\].g_col\[0\].pe_hold3055 _277_/Q VGND VGND VPWR VPWR g_row\[0\].g_col\[0\].pe_hold3055/X
+ sky130_fd_sc_hd__clkbuf_2
Xg_row\[0\].g_col\[0\].pe_hold2321 g_row\[0\].g_col\[0\].pe_hold2934/X VGND VGND VPWR
+ VPWR ANTENNA_107/DIODE sky130_fd_sc_hd__clkbuf_2
Xg_row\[0\].g_col\[0\].pe_hold3066 _285_/Q VGND VGND VPWR VPWR g_row\[0\].g_col\[0\].pe_hold3066/X
+ sky130_fd_sc_hd__clkbuf_2
Xg_row\[0\].g_col\[0\].pe_hold3077 g_row\[0\].g_col\[0\].pe__2734_/Q VGND VGND VPWR
+ VPWR g_row\[0\].g_col\[0\].pe_hold3077/X sky130_fd_sc_hd__clkbuf_2
Xg_row\[0\].g_col\[0\].pe__2270_ g_row\[0\].g_col\[0\].pe__2330_/A g_row\[0\].g_col\[0\].pe__2330_/B
+ VGND VGND VPWR VPWR g_row\[0\].g_col\[0\].pe__2297_/A sky130_fd_sc_hd__nor2_2
Xg_row\[0\].g_col\[1\].pe_place946 g_row\[0\].g_col\[1\].pe__2348_/A VGND VGND VPWR
+ VPWR g_row\[0\].g_col\[1\].pe__2209_/A sky130_fd_sc_hd__buf_6
Xg_row\[0\].g_col\[1\].pe_place968 g_row\[0\].g_col\[1\].pe__1372_/X VGND VGND VPWR
+ VPWR g_row\[0\].g_col\[1\].pe__2678_/A sky130_fd_sc_hd__buf_6
Xg_row\[0\].g_col\[1\].pe_place957 g_row\[0\].g_col\[1\].pe__1415_/Y VGND VGND VPWR
+ VPWR g_row\[0\].g_col\[1\].pe__1729_/A3 sky130_fd_sc_hd__buf_6
XPHY_EDGE_ROW_41_Left_135 VGND VGND VPWR VPWR sky130_fd_sc_hd__decap_3
Xclkload10 clkload10/A VGND VGND VPWR VPWR clkload10/X sky130_fd_sc_hd__clkbuf_8
Xg_row\[0\].g_col\[0\].pe_hold1686 g_row\[0\].g_col\[0\].pe_hold3087/X VGND VGND VPWR
+ VPWR g_row\[0\].g_col\[0\].pe__2063_/B1 sky130_fd_sc_hd__clkbuf_2
Xg_row\[1\].g_col\[1\].pe__1992_ g_row\[1\].g_col\[1\].pe__1991_/A g_row\[1\].g_col\[1\].pe__1991_/B
+ g_row\[1\].g_col\[1\].pe__1991_/C g_row\[1\].g_col\[1\].pe__1991_/D VGND VGND VPWR
+ VPWR g_row\[1\].g_col\[1\].pe__1993_/B sky130_fd_sc_hd__a22o_2
Xg_row\[1\].g_col\[0\].pe__1976_ place1090/X g_row\[1\].g_col\[0\].pe__1471_/X g_row\[1\].g_col\[0\].pe__1474_/Y
+ g_row\[1\].g_col\[0\].pe__2616_/B VGND VGND VPWR VPWR g_row\[1\].g_col\[0\].pe__1977_/B
+ sky130_fd_sc_hd__a22o_2
Xoutput1401 output1401/A VGND VGND VPWR VPWR results_flat[51] sky130_fd_sc_hd__buf_2
Xoutput1412 output1412/A VGND VGND VPWR VPWR results_flat[61] sky130_fd_sc_hd__buf_2
Xhold3506 hold3506/A VGND VGND VPWR VPWR hold3506/X sky130_fd_sc_hd__clkbuf_2
Xhold2805 hold3585/X VGND VGND VPWR VPWR hold3586/A sky130_fd_sc_hd__clkbuf_2
Xhold3539 hold3539/A VGND VGND VPWR VPWR hold3539/X sky130_fd_sc_hd__clkbuf_2
Xhold3528 hold3528/A VGND VGND VPWR VPWR hold3528/X sky130_fd_sc_hd__clkbuf_2
Xhold3517 hold3517/A VGND VGND VPWR VPWR hold3517/X sky130_fd_sc_hd__clkbuf_2
Xg_row\[1\].g_col\[1\].pe__2613_ g_row\[1\].g_col\[1\].pe__2626_/A1 place1096/X g_row\[1\].g_col\[1\].pe__2626_/B1
+ g_row\[1\].g_col\[1\].pe__2612_/X VGND VGND VPWR VPWR g_row\[1\].g_col\[1\].pe__2613_/X
+ sky130_fd_sc_hd__o211a_2
XTAP_TAPCELL_ROW_39_802 VGND VPWR sky130_fd_sc_hd__tapvpwrvgnd_1
Xg_row\[0\].g_col\[0\].pe__1985_ g_row\[0\].g_col\[0\].pe__2094_/A g_row\[0\].g_col\[0\].pe__1985_/B
+ g_row\[0\].g_col\[0\].pe__1985_/C VGND VGND VPWR VPWR g_row\[0\].g_col\[0\].pe__1988_/B
+ sky130_fd_sc_hd__nand3b_2
Xg_row\[1\].g_col\[1\].pe__2544_ g_row\[1\].g_col\[1\].pe__2466_/X g_row\[1\].g_col\[1\].pe__2544_/B
+ VGND VGND VPWR VPWR g_row\[1\].g_col\[1\].pe__2546_/A sky130_fd_sc_hd__and2b_2
Xg_row\[1\].g_col\[0\].pe__2528_ g_row\[1\].g_col\[0\].pe__2528_/A1 g_row\[1\].g_col\[0\].pe__2560_/A2
+ g_row\[1\].g_col\[0\].pe__2560_/B1 g_row\[1\].g_col\[0\].pe__2527_/X VGND VGND VPWR
+ VPWR g_row\[1\].g_col\[0\].pe__2528_/X sky130_fd_sc_hd__a22o_2
XFILLER_68_475 VGND VGND VPWR VPWR sky130_fd_sc_hd__fill_1
XPHY_EDGE_ROW_50_Left_144 VGND VGND VPWR VPWR sky130_fd_sc_hd__decap_3
Xg_row\[1\].g_col\[1\].pe__2475_ g_row\[1\].g_col\[1\].pe__2489_/B g_row\[1\].g_col\[1\].pe__2492_/A
+ g_row\[1\].g_col\[1\].pe__2474_/Y VGND VGND VPWR VPWR g_row\[1\].g_col\[1\].pe__2490_/A
+ sky130_fd_sc_hd__a21boi_2
Xg_row\[1\].g_col\[0\].pe__2459_ g_row\[1\].g_col\[0\].pe__2754_/Q g_row\[1\].g_col\[0\].pe__2739_/Q
+ VGND VGND VPWR VPWR g_row\[1\].g_col\[0\].pe__2460_/B sky130_fd_sc_hd__and2b_2
Xg_row\[1\].g_col\[1\].pe_place1020 g_row\[1\].g_col\[1\].pe__2163_/A VGND VGND VPWR
+ VPWR g_row\[1\].g_col\[1\].pe__2388_/A sky130_fd_sc_hd__buf_6
Xg_row\[1\].g_col\[1\].pe_place1031 g_row\[1\].g_col\[1\].pe__2698_/Q VGND VGND VPWR
+ VPWR g_row\[1\].g_col\[1\].pe__2215_/B2 sky130_fd_sc_hd__buf_6
Xg_row\[1\].g_col\[1\].pe__1426_ g_row\[1\].g_col\[1\].pe__2614_/B g_row\[1\].g_col\[1\].pe__1732_/A2
+ g_row\[1\].g_col\[1\].pe__1732_/B1 g_row\[1\].g_col\[1\].pe__2612_/B VGND VGND VPWR
+ VPWR g_row\[1\].g_col\[1\].pe__1427_/B sky130_fd_sc_hd__a22o_2
XFILLER_43_309 VGND VGND VPWR VPWR sky130_fd_sc_hd__fill_1
XFILLER_52_810 VGND VGND VPWR VPWR sky130_fd_sc_hd__fill_2
Xg_row\[0\].g_col\[0\].pe__2606_ g_row\[0\].g_col\[0\].pe__2640_/A1 g_row\[0\].g_col\[0\].pe__2606_/A2
+ g_row\[0\].g_col\[0\].pe__2640_/C1 g_row\[0\].g_col\[0\].pe__2605_/X VGND VGND VPWR
+ VPWR g_row\[0\].g_col\[0\].pe__2606_/X sky130_fd_sc_hd__o211a_2
Xg_row\[1\].g_col\[1\].pe_place1042 g_row\[1\].g_col\[1\].pe__2693_/Q VGND VGND VPWR
+ VPWR g_row\[1\].g_col\[1\].pe__1782_/A2 sky130_fd_sc_hd__buf_6
Xg_row\[1\].g_col\[1\].pe_place1053 g_row\[1\].g_col\[1\].pe__2679_/C1 VGND VGND VPWR
+ VPWR g_row\[1\].g_col\[1\].pe__2687_/C1 sky130_fd_sc_hd__buf_6
Xg_row\[1\].g_col\[1\].pe__1357_ g_row\[1\].g_col\[1\].pe__2764_/Q g_row\[1\].g_col\[1\].pe__1357_/B
+ VGND VGND VPWR VPWR output1406/A sky130_fd_sc_hd__xor2_2
Xg_row\[0\].g_col\[1\].pe__2622_ g_row\[0\].g_col\[1\].pe__2624_/A1 place1204/X g_row\[0\].g_col\[1\].pe__2381_/A
+ g_row\[0\].g_col\[1\].pe__2621_/X VGND VGND VPWR VPWR g_row\[0\].g_col\[1\].pe__2699_/D
+ sky130_fd_sc_hd__o211a_2
Xg_row\[0\].g_col\[1\].pe__2553_ g_row\[0\].g_col\[1\].pe__2551_/Y g_row\[0\].g_col\[1\].pe__2552_/X
+ g_row\[0\].g_col\[1\].pe__2559_/A VGND VGND VPWR VPWR g_row\[0\].g_col\[1\].pe__2553_/X
+ sky130_fd_sc_hd__a21o_2
XFILLER_34_38 VGND VGND VPWR VPWR sky130_fd_sc_hd__fill_1
Xg_row\[0\].g_col\[1\].pe__1504_ g_row\[0\].g_col\[1\].pe__1504_/A g_row\[0\].g_col\[1\].pe__2341_/B
+ VGND VGND VPWR VPWR g_row\[0\].g_col\[1\].pe__1504_/Y sky130_fd_sc_hd__nor2_2
XFILLER_24_589 VGND VGND VPWR VPWR sky130_fd_sc_hd__decap_3
Xg_row\[0\].g_col\[0\].pe__2468_ g_row\[0\].g_col\[0\].pe__2538_/A g_row\[0\].g_col\[0\].pe__2538_/B
+ g_row\[0\].g_col\[0\].pe__2538_/C g_row\[0\].g_col\[0\].pe__2466_/X g_row\[0\].g_col\[0\].pe__2497_/A
+ VGND VGND VPWR VPWR g_row\[0\].g_col\[0\].pe__2551_/C sky130_fd_sc_hd__a311o_2
Xg_row\[0\].g_col\[1\].pe_place1129 g_row\[0\].g_col\[1\].pe__2726_/Q VGND VGND VPWR
+ VPWR g_row\[0\].g_col\[1\].pe__1707_/A sky130_fd_sc_hd__buf_6
Xg_row\[0\].g_col\[1\].pe_place1118 g_row\[0\].g_col\[1\].pe_hold3123/X VGND VGND
+ VPWR VPWR g_row\[0\].g_col\[1\].pe__1977_/A sky130_fd_sc_hd__buf_6
Xg_row\[0\].g_col\[1\].pe__2484_ g_row\[0\].g_col\[1\].pe__2484_/A VGND VGND VPWR
+ VPWR g_row\[0\].g_col\[1\].pe__2484_/Y sky130_fd_sc_hd__inv_2
Xclkload4 clkload4/A VGND VGND VPWR VPWR clkload4/X sky130_fd_sc_hd__clkbuf_16
Xg_row\[0\].g_col\[0\].pe__1419_ g_row\[0\].g_col\[0\].pe__2686_/A g_row\[0\].g_col\[0\].pe__1419_/B
+ VGND VGND VPWR VPWR g_row\[0\].g_col\[0\].pe__1428_/B sky130_fd_sc_hd__xor2_2
Xg_row\[0\].g_col\[0\].pe__2399_ g_row\[0\].g_col\[0\].pe__2754_/Q VGND VGND VPWR
+ VPWR g_row\[0\].g_col\[0\].pe__2399_/Y sky130_fd_sc_hd__inv_2
Xg_row\[0\].g_col\[1\].pe__1366_ g_row\[0\].g_col\[1\].pe__2478_/A g_row\[0\].g_col\[1\].pe__1366_/B
+ VGND VGND VPWR VPWR output1375/A sky130_fd_sc_hd__xnor2_2
XFILLER_3_449 VGND VGND VPWR VPWR sky130_fd_sc_hd__fill_2
XFILLER_59_57 VGND VGND VPWR VPWR sky130_fd_sc_hd__fill_1
XFILLER_78_217 VGND VGND VPWR VPWR sky130_fd_sc_hd__fill_1
XFILLER_79_718 VGND VGND VPWR VPWR sky130_fd_sc_hd__decap_3
XTAP_TAPCELL_ROW_6_298 VGND VPWR sky130_fd_sc_hd__tapvpwrvgnd_1
XFILLER_28_840 VGND VGND VPWR VPWR sky130_fd_sc_hd__fill_2
XFILLER_34_309 VGND VGND VPWR VPWR sky130_fd_sc_hd__fill_1
XFILLER_55_670 VGND VGND VPWR VPWR sky130_fd_sc_hd__fill_2
XFILLER_62_618 VGND VGND VPWR VPWR sky130_fd_sc_hd__decap_3
XFILLER_61_128 VGND VGND VPWR VPWR sky130_fd_sc_hd__fill_1
XTAP_TAPCELL_ROW_83_1457 VGND VPWR sky130_fd_sc_hd__tapvpwrvgnd_1
Xg_row\[0\].g_col\[1\].pe_hold1794 g_row\[0\].g_col\[1\].pe__1836_/X VGND VGND VPWR
+ VPWR g_row\[0\].g_col\[1\].pe__2739_/D sky130_fd_sc_hd__clkbuf_2
XTAP_TAPCELL_ROW_25_584 VGND VPWR sky130_fd_sc_hd__tapvpwrvgnd_1
X_304_ _304_/CLK _304_/D VGND VGND VPWR VPWR _304_/Q sky130_fd_sc_hd__dfxtp_2
XFILLER_30_548 VGND VGND VPWR VPWR sky130_fd_sc_hd__decap_3
XFILLER_7_700 VGND VGND VPWR VPWR sky130_fd_sc_hd__decap_3
X_235_ _235_/A _235_/B_N VGND VGND VPWR VPWR _235_/Y sky130_fd_sc_hd__nor2b_4
XFILLER_7_722 VGND VGND VPWR VPWR sky130_fd_sc_hd__decap_3
Xg_row\[1\].g_col\[0\].pe__1830_ g_row\[1\].g_col\[0\].pe__1830_/A g_row\[1\].g_col\[0\].pe__1830_/B
+ g_row\[1\].g_col\[0\].pe__1830_/C VGND VGND VPWR VPWR g_row\[1\].g_col\[0\].pe__1832_/B
+ sky130_fd_sc_hd__or3_2
Xg_row\[1\].g_col\[0\].pe__1761_ g_row\[1\].g_col\[0\].pe__1804_/A place1098/A place1100/A
+ g_row\[1\].g_col\[0\].pe__1804_/B VGND VGND VPWR VPWR g_row\[1\].g_col\[0\].pe__1762_/B
+ sky130_fd_sc_hd__a22o_2
Xg_row\[1\].g_col\[0\].pe__1692_ g_row\[1\].g_col\[0\].pe__1689_/Y g_row\[1\].g_col\[0\].pe__1722_/B
+ g_row\[1\].g_col\[0\].pe__1691_/Y VGND VGND VPWR VPWR g_row\[1\].g_col\[0\].pe__1695_/A
+ sky130_fd_sc_hd__a21o_2
XFILLER_78_751 VGND VGND VPWR VPWR sky130_fd_sc_hd__decap_3
XFILLER_93_710 VGND VGND VPWR VPWR sky130_fd_sc_hd__decap_3
XFILLER_93_732 VGND VGND VPWR VPWR sky130_fd_sc_hd__decap_3
Xg_row\[0\].g_col\[0\].pe__1770_ g_row\[0\].g_col\[0\].pe__1770_/A g_row\[0\].g_col\[0\].pe__1770_/B
+ VGND VGND VPWR VPWR g_row\[0\].g_col\[0\].pe__1793_/A sky130_fd_sc_hd__xnor2_2
Xg_row\[1\].g_col\[0\].pe__2313_ g_row\[1\].g_col\[0\].pe__2388_/A g_row\[1\].g_col\[0\].pe__2313_/A2
+ g_row\[1\].g_col\[0\].pe__1541_/X g_row\[1\].g_col\[0\].pe__2121_/A VGND VGND VPWR
+ VPWR g_row\[1\].g_col\[0\].pe__2314_/B sky130_fd_sc_hd__a22o_2
Xg_row\[1\].g_col\[1\].pe__2260_ g_row\[1\].g_col\[1\].pe__2330_/A g_row\[1\].g_col\[1\].pe__2330_/B
+ VGND VGND VPWR VPWR g_row\[1\].g_col\[1\].pe__2262_/B sky130_fd_sc_hd__xnor2_2
Xg_row\[1\].g_col\[0\].pe__2244_ g_row\[1\].g_col\[0\].pe__2277_/A g_row\[1\].g_col\[0\].pe__2277_/B
+ VGND VGND VPWR VPWR g_row\[1\].g_col\[0\].pe__2288_/B sky130_fd_sc_hd__xor2_2
Xg_row\[1\].g_col\[1\].pe__2191_ g_row\[1\].g_col\[1\].pe__2191_/A g_row\[1\].g_col\[1\].pe__2228_/B
+ VGND VGND VPWR VPWR g_row\[1\].g_col\[1\].pe__2202_/A sky130_fd_sc_hd__or2_4
Xg_row\[1\].g_col\[0\].pe__2175_ g_row\[1\].g_col\[0\].pe__2128_/B g_row\[1\].g_col\[0\].pe__2128_/C
+ g_row\[1\].g_col\[0\].pe__2128_/A VGND VGND VPWR VPWR g_row\[1\].g_col\[0\].pe__2175_/X
+ sky130_fd_sc_hd__a21o_2
XFILLER_61_640 VGND VGND VPWR VPWR sky130_fd_sc_hd__decap_3
XFILLER_61_673 VGND VGND VPWR VPWR sky130_fd_sc_hd__decap_3
XTAP_TAPCELL_ROW_44_871 VGND VPWR sky130_fd_sc_hd__tapvpwrvgnd_1
Xg_row\[0\].g_col\[0\].pe__2322_ g_row\[0\].g_col\[0\].pe__2337_/B g_row\[0\].g_col\[0\].pe__2337_/C
+ VGND VGND VPWR VPWR g_row\[0\].g_col\[0\].pe__2323_/B sky130_fd_sc_hd__nor2_2
XFILLER_21_559 VGND VGND VPWR VPWR sky130_fd_sc_hd__fill_1
Xg_row\[0\].g_col\[0\].pe__2253_ g_row\[0\].g_col\[0\].pe__2253_/A g_row\[0\].g_col\[0\].pe__2253_/B
+ VGND VGND VPWR VPWR g_row\[0\].g_col\[0\].pe__2253_/Y sky130_fd_sc_hd__nand2_2
Xg_row\[0\].g_col\[0\].pe__2184_ g_row\[0\].g_col\[0\].pe__2222_/A g_row\[0\].g_col\[0\].pe__2184_/B
+ g_row\[0\].g_col\[0\].pe__2184_/C VGND VGND VPWR VPWR g_row\[0\].g_col\[0\].pe__2184_/X
+ sky130_fd_sc_hd__and3b_2
Xg_row\[1\].g_col\[1\].pe__1975_ g_row\[1\].g_col\[1\].pe__1974_/A g_row\[1\].g_col\[1\].pe__1974_/B
+ g_row\[1\].g_col\[1\].pe__1974_/C g_row\[1\].g_col\[1\].pe__1974_/D VGND VGND VPWR
+ VPWR g_row\[1\].g_col\[1\].pe__1978_/B sky130_fd_sc_hd__a22oi_2
Xg_row\[1\].g_col\[0\].pe__1959_ g_row\[1\].g_col\[0\].pe__2021_/A g_row\[1\].g_col\[0\].pe__1959_/B
+ VGND VGND VPWR VPWR g_row\[1\].g_col\[0\].pe__1961_/B sky130_fd_sc_hd__xnor2_2
XFILLER_88_504 VGND VGND VPWR VPWR sky130_fd_sc_hd__fill_1
XTAP_TAPCELL_ROW_54_1014 VGND VPWR sky130_fd_sc_hd__tapvpwrvgnd_1
XTAP_TAPCELL_ROW_54_1025 VGND VPWR sky130_fd_sc_hd__tapvpwrvgnd_1
Xhold3303 hold3303/A VGND VGND VPWR VPWR hold3303/X sky130_fd_sc_hd__clkbuf_2
Xhold3314 hold3314/A VGND VGND VPWR VPWR hold3314/X sky130_fd_sc_hd__clkbuf_2
Xhold3325 hold3325/A VGND VGND VPWR VPWR hold3325/X sky130_fd_sc_hd__clkbuf_2
Xhold2602 hold3379/X VGND VGND VPWR VPWR hold3380/A sky130_fd_sc_hd__clkbuf_2
Xhold2613 hold3335/X VGND VGND VPWR VPWR hold3336/A sky130_fd_sc_hd__clkbuf_2
Xhold3336 hold3336/A VGND VGND VPWR VPWR hold3336/X sky130_fd_sc_hd__clkbuf_2
Xhold3347 a_inputs_flat[6] VGND VGND VPWR VPWR hold3347/X sky130_fd_sc_hd__clkbuf_2
Xhold3358 hold3358/A VGND VGND VPWR VPWR hold3358/X sky130_fd_sc_hd__clkbuf_2
XPHY_EDGE_ROW_89_Right_89 VGND VGND VPWR VPWR sky130_fd_sc_hd__decap_3
Xhold1901 hold2042/X VGND VGND VPWR VPWR hold2043/A sky130_fd_sc_hd__clkbuf_2
Xhold2624 hold3403/X VGND VGND VPWR VPWR hold3404/A sky130_fd_sc_hd__clkbuf_2
Xhold2635 hold2635/A VGND VGND VPWR VPWR _283_/D sky130_fd_sc_hd__clkbuf_2
Xhold2646 _189_/Y VGND VGND VPWR VPWR hold2646/X sky130_fd_sc_hd__clkbuf_2
Xhold3369 hold3369/A VGND VGND VPWR VPWR hold3369/X sky130_fd_sc_hd__clkbuf_2
XFILLER_29_615 VGND VGND VPWR VPWR sky130_fd_sc_hd__fill_1
Xg_row\[0\].g_col\[0\].pe__1968_ g_row\[0\].g_col\[0\].pe__2167_/A g_row\[0\].g_col\[0\].pe__1968_/B
+ g_row\[0\].g_col\[0\].pe__1968_/C VGND VGND VPWR VPWR g_row\[0\].g_col\[0\].pe__1974_/A
+ sky130_fd_sc_hd__nand3b_2
Xhold2657 hold3388/X VGND VGND VPWR VPWR _151_/B_N sky130_fd_sc_hd__clkbuf_2
Xhold2668 hold3428/X VGND VGND VPWR VPWR hold3429/A sky130_fd_sc_hd__clkbuf_2
Xhold2679 hold3433/X VGND VGND VPWR VPWR hold3434/A sky130_fd_sc_hd__clkbuf_2
Xg_row\[1\].g_col\[1\].pe__2527_ g_row\[1\].g_col\[1\].pe__2525_/Y g_row\[1\].g_col\[1\].pe__2526_/X
+ g_row\[1\].g_col\[1\].pe__2559_/A VGND VGND VPWR VPWR g_row\[1\].g_col\[1\].pe__2527_/X
+ sky130_fd_sc_hd__a21o_2
Xg_row\[0\].g_col\[1\].pe__1984_ g_row\[0\].g_col\[1\].pe__1424_/A g_row\[0\].g_col\[1\].pe__1424_/B
+ g_row\[0\].g_col\[1\].pe__1983_/Y VGND VGND VPWR VPWR g_row\[0\].g_col\[1\].pe__1985_/C
+ sky130_fd_sc_hd__a21o_2
XTAP_TAPCELL_ROW_3_257 VGND VPWR sky130_fd_sc_hd__tapvpwrvgnd_1
XFILLER_16_309 VGND VGND VPWR VPWR sky130_fd_sc_hd__decap_3
XFILLER_45_15 VGND VGND VPWR VPWR sky130_fd_sc_hd__fill_1
Xg_row\[0\].g_col\[0\].pe__1899_ g_row\[0\].g_col\[0\].pe__1899_/A g_row\[0\].g_col\[0\].pe__1899_/B
+ VGND VGND VPWR VPWR g_row\[0\].g_col\[0\].pe__1899_/X sky130_fd_sc_hd__and2_2
Xhold1989 hold1989/A VGND VGND VPWR VPWR hold1989/X sky130_fd_sc_hd__clkbuf_2
Xg_row\[1\].g_col\[1\].pe__2458_ g_row\[1\].g_col\[1\].pe__2458_/A g_row\[1\].g_col\[1\].pe__2458_/B
+ VGND VGND VPWR VPWR g_row\[1\].g_col\[1\].pe__2526_/A sky130_fd_sc_hd__nor2_2
Xg_row\[1\].g_col\[1\].pe__2389_ g_row\[1\].g_col\[1\].pe__2364_/A g_row\[1\].g_col\[1\].pe__2364_/B
+ g_row\[1\].g_col\[1\].pe__2366_/X VGND VGND VPWR VPWR g_row\[1\].g_col\[1\].pe__2390_/B
+ sky130_fd_sc_hd__o21a_2
Xg_row\[0\].g_col\[1\].pe__2605_ g_row\[0\].g_col\[1\].pe__2669_/A g_row\[0\].g_col\[1\].pe__2605_/B
+ VGND VGND VPWR VPWR g_row\[0\].g_col\[1\].pe__2605_/X sky130_fd_sc_hd__or2_2
XFILLER_24_342 VGND VGND VPWR VPWR sky130_fd_sc_hd__fill_1
XFILLER_24_375 VGND VGND VPWR VPWR sky130_fd_sc_hd__fill_1
XFILLER_40_813 VGND VGND VPWR VPWR sky130_fd_sc_hd__decap_3
XTAP_TAPCELL_ROW_65_1187 VGND VPWR sky130_fd_sc_hd__tapvpwrvgnd_1
Xg_row\[0\].g_col\[1\].pe__2536_ g_row\[0\].g_col\[1\].pe__2595_/A g_row\[0\].g_col\[1\].pe__2536_/B
+ VGND VGND VPWR VPWR g_row\[0\].g_col\[1\].pe__2759_/D sky130_fd_sc_hd__and2_2
XTAP_TAPCELL_ROW_22_543 VGND VPWR sky130_fd_sc_hd__tapvpwrvgnd_1
Xg_row\[0\].g_col\[1\].pe__2467_ g_row\[0\].g_col\[1\].pe__2446_/B g_row\[0\].g_col\[1\].pe__2761_/Q
+ VGND VGND VPWR VPWR g_row\[0\].g_col\[1\].pe__2497_/A sky130_fd_sc_hd__and2b_2
Xg_row\[0\].g_col\[1\].pe__1418_ g_row\[0\].g_col\[1\].pe__1704_/A2 g_row\[0\].g_col\[1\].pe__1729_/A2
+ g_row\[0\].g_col\[1\].pe__1729_/A3 g_row\[0\].g_col\[1\].pe__1729_/B1 g_row\[0\].g_col\[1\].pe__2036_/B2
+ VGND VGND VPWR VPWR g_row\[0\].g_col\[1\].pe__1419_/B sky130_fd_sc_hd__a32o_2
XFILLER_20_581 VGND VGND VPWR VPWR sky130_fd_sc_hd__decap_3
XFILLER_20_592 VGND VGND VPWR VPWR sky130_fd_sc_hd__fill_2
Xg_row\[0\].g_col\[1\].pe__2398_ g_row\[0\].g_col\[1\].pe__2398_/A g_row\[0\].g_col\[1\].pe__2639_/B
+ VGND VGND VPWR VPWR g_row\[0\].g_col\[1\].pe__2398_/X sky130_fd_sc_hd__and2_2
Xg_row\[0\].g_col\[1\].pe__1349_ g_row\[0\].g_col\[1\].pe__2760_/Q g_row\[0\].g_col\[1\].pe__1349_/B
+ VGND VGND VPWR VPWR output1367/A sky130_fd_sc_hd__xnor2_2
XFILLER_10_95 VGND VGND VPWR VPWR sky130_fd_sc_hd__decap_3
XFILLER_79_559 VGND VGND VPWR VPWR sky130_fd_sc_hd__fill_1
XFILLER_47_445 VGND VGND VPWR VPWR sky130_fd_sc_hd__decap_3
XFILLER_19_169 VGND VGND VPWR VPWR sky130_fd_sc_hd__decap_3
XFILLER_28_670 VGND VGND VPWR VPWR sky130_fd_sc_hd__decap_3
XFILLER_62_415 VGND VGND VPWR VPWR sky130_fd_sc_hd__fill_1
XFILLER_74_275 VGND VGND VPWR VPWR sky130_fd_sc_hd__fill_1
XFILLER_16_821 VGND VGND VPWR VPWR sky130_fd_sc_hd__fill_1
XFILLER_34_139 VGND VGND VPWR VPWR sky130_fd_sc_hd__fill_1
XFILLER_43_662 VGND VGND VPWR VPWR sky130_fd_sc_hd__fill_1
XFILLER_43_673 VGND VGND VPWR VPWR sky130_fd_sc_hd__fill_2
XTAP_TAPCELL_ROW_41_830 VGND VPWR sky130_fd_sc_hd__tapvpwrvgnd_1
X_149_ _173_/A _149_/B_N VGND VGND VPWR VPWR _149_/Y sky130_fd_sc_hd__nor2b_4
Xplace1207 place1208/X VGND VGND VPWR VPWR place1207/X sky130_fd_sc_hd__buf_6
Xg_row\[1\].g_col\[0\].pe__1813_ g_row\[1\].g_col\[0\].pe__1813_/A g_row\[1\].g_col\[0\].pe__1813_/B
+ VGND VGND VPWR VPWR g_row\[1\].g_col\[0\].pe__1813_/Y sky130_fd_sc_hd__nand2_2
Xplace1218 place1218/A VGND VGND VPWR VPWR place1218/X sky130_fd_sc_hd__buf_6
Xg_row\[1\].g_col\[1\].pe__1760_ g_row\[1\].g_col\[1\].pe__1816_/B g_row\[1\].g_col\[1\].pe__1760_/B
+ VGND VGND VPWR VPWR g_row\[1\].g_col\[1\].pe__1780_/A sky130_fd_sc_hd__xnor2_2
Xg_row\[1\].g_col\[0\].pe__1744_ g_row\[1\].g_col\[0\].pe__1815_/B g_row\[1\].g_col\[0\].pe__1815_/A
+ VGND VGND VPWR VPWR g_row\[1\].g_col\[0\].pe__1819_/A sky130_fd_sc_hd__nand2b_2
XFILLER_32_3 VGND VGND VPWR VPWR sky130_fd_sc_hd__fill_1
XFILLER_3_791 VGND VGND VPWR VPWR sky130_fd_sc_hd__decap_3
Xg_row\[1\].g_col\[1\].pe__1691_ g_row\[1\].g_col\[1\].pe__1721_/A g_row\[1\].g_col\[1\].pe__1721_/B
+ VGND VGND VPWR VPWR g_row\[1\].g_col\[1\].pe__1691_/Y sky130_fd_sc_hd__nor2_2
Xg_row\[1\].g_col\[0\].pe__1675_ g_row\[1\].g_col\[0\].pe__1676_/A g_row\[1\].g_col\[0\].pe__1676_/B
+ VGND VGND VPWR VPWR g_row\[1\].g_col\[0\].pe__1823_/A sky130_fd_sc_hd__nor2_2
Xg_row\[1\].g_col\[0\].pe_hold2833 g_row\[1\].g_col\[0\].pe_hold2833/A VGND VGND VPWR
+ VPWR g_row\[1\].g_col\[0\].pe__2710_/D sky130_fd_sc_hd__clkbuf_2
Xg_row\[0\].g_col\[0\].pe__1822_ g_row\[0\].g_col\[0\].pe__1818_/B g_row\[0\].g_col\[0\].pe__1819_/B
+ g_row\[0\].g_col\[0\].pe__1822_/C g_row\[0\].g_col\[0\].pe__1822_/D VGND VGND VPWR
+ VPWR g_row\[0\].g_col\[0\].pe__1822_/X sky130_fd_sc_hd__and4bb_2
Xg_row\[1\].g_col\[0\].pe_hold2855 g_row\[1\].g_col\[0\].pe__2665_/X VGND VGND VPWR
+ VPWR g_row\[1\].g_col\[0\].pe__2666_/C1 sky130_fd_sc_hd__clkbuf_2
XTAP_TAPCELL_ROW_49_941 VGND VPWR sky130_fd_sc_hd__tapvpwrvgnd_1
XTAP_TAPCELL_ROW_49_952 VGND VPWR sky130_fd_sc_hd__tapvpwrvgnd_1
Xg_row\[1\].g_col\[1\].pe__2312_ g_row\[1\].g_col\[1\].pe__2340_/B2 g_row\[1\].g_col\[1\].pe__2363_/A2
+ g_row\[1\].g_col\[1\].pe__2388_/B g_row\[1\].g_col\[1\].pe__2030_/A VGND VGND VPWR
+ VPWR g_row\[1\].g_col\[1\].pe__2316_/A sky130_fd_sc_hd__a22o_2
Xg_row\[1\].g_col\[0\].pe_hold2899 _299_/Q VGND VGND VPWR VPWR g_row\[1\].g_col\[0\].pe_hold2899/X
+ sky130_fd_sc_hd__clkbuf_2
XFILLER_26_618 VGND VGND VPWR VPWR sky130_fd_sc_hd__decap_3
XTAP_TAPCELL_ROW_0_205 VGND VPWR sky130_fd_sc_hd__tapvpwrvgnd_1
XTAP_TAPCELL_ROW_0_216 VGND VPWR sky130_fd_sc_hd__tapvpwrvgnd_1
Xg_row\[0\].g_col\[0\].pe__1753_ g_row\[0\].g_col\[0\].pe__1756_/A g_row\[0\].g_col\[0\].pe__1756_/B
+ VGND VGND VPWR VPWR g_row\[0\].g_col\[0\].pe__1770_/A sky130_fd_sc_hd__xor2_2
XFILLER_19_670 VGND VGND VPWR VPWR sky130_fd_sc_hd__fill_2
Xg_row\[0\].g_col\[0\].pe__1684_ place1213/X g_row\[0\].g_col\[0\].pe__1732_/A2 g_row\[0\].g_col\[0\].pe__1732_/B1
+ place1216/X VGND VGND VPWR VPWR g_row\[0\].g_col\[0\].pe__1685_/B sky130_fd_sc_hd__a22o_2
Xg_row\[1\].g_col\[1\].pe__2243_ g_row\[1\].g_col\[1\].pe__2364_/A g_row\[1\].g_col\[1\].pe__2243_/B
+ VGND VGND VPWR VPWR g_row\[1\].g_col\[1\].pe__2277_/B sky130_fd_sc_hd__xnor2_2
Xg_row\[1\].g_col\[0\].pe__2227_ g_row\[1\].g_col\[0\].pe__2228_/A g_row\[1\].g_col\[0\].pe__2228_/B
+ g_row\[1\].g_col\[0\].pe__2228_/C VGND VGND VPWR VPWR g_row\[1\].g_col\[0\].pe__2262_/A
+ sky130_fd_sc_hd__o21ai_2
Xg_row\[1\].g_col\[1\].pe__2174_ g_row\[1\].g_col\[1\].pe__2174_/A g_row\[1\].g_col\[1\].pe__2174_/B
+ VGND VGND VPWR VPWR g_row\[1\].g_col\[1\].pe__2182_/A sky130_fd_sc_hd__nand2_2
XFILLER_22_813 VGND VGND VPWR VPWR sky130_fd_sc_hd__fill_1
Xg_row\[1\].g_col\[0\].pe__2158_ g_row\[1\].g_col\[0\].pe__2404_/A1 g_row\[1\].g_col\[0\].pe__2158_/A2
+ g_row\[1\].g_col\[0\].pe__2155_/X g_row\[1\].g_col\[0\].pe__2157_/Y VGND VGND VPWR
+ VPWR g_row\[1\].g_col\[0\].pe__2158_/X sky130_fd_sc_hd__o22a_2
Xg_row\[0\].g_col\[0\].pe__2305_ g_row\[0\].g_col\[0\].pe__2305_/A g_row\[0\].g_col\[0\].pe__2305_/B
+ VGND VGND VPWR VPWR g_row\[0\].g_col\[0\].pe__2305_/Y sky130_fd_sc_hd__xnor2_2
Xg_row\[1\].g_col\[0\].pe__2089_ place1086/X g_row\[1\].g_col\[0\].pe__1471_/X g_row\[1\].g_col\[0\].pe__1474_/Y
+ g_row\[1\].g_col\[0\].pe__2241_/B2 VGND VGND VPWR VPWR g_row\[1\].g_col\[0\].pe__2090_/B
+ sky130_fd_sc_hd__a22o_2
Xg_row\[0\].g_col\[1\].pe__2321_ g_row\[0\].g_col\[1\].pe__2368_/A g_row\[0\].g_col\[1\].pe__2348_/B
+ VGND VGND VPWR VPWR g_row\[0\].g_col\[1\].pe__2337_/C sky130_fd_sc_hd__and2_2
Xg_row\[0\].g_col\[0\].pe__2236_ g_row\[0\].g_col\[0\].pe__2394_/B1 g_row\[0\].g_col\[0\].pe__2233_/X
+ g_row\[0\].g_col\[0\].pe__2234_/Y g_row\[0\].g_col\[0\].pe__2236_/B1 g_row\[0\].g_col\[0\].pe__2599_/A
+ VGND VGND VPWR VPWR g_row\[0\].g_col\[0\].pe__2236_/X sky130_fd_sc_hd__o32a_2
Xg_row\[0\].g_col\[1\].pe__2252_ g_row\[0\].g_col\[1\].pe__2273_/A g_row\[0\].g_col\[1\].pe__2273_/B
+ VGND VGND VPWR VPWR g_row\[0\].g_col\[1\].pe__2271_/A sky130_fd_sc_hd__xnor2_2
Xg_row\[0\].g_col\[0\].pe__2167_ g_row\[0\].g_col\[0\].pe__2167_/A g_row\[0\].g_col\[0\].pe__2167_/B
+ g_row\[0\].g_col\[0\].pe__2167_/C VGND VGND VPWR VPWR g_row\[0\].g_col\[0\].pe__2167_/X
+ sky130_fd_sc_hd__and3_2
Xg_row\[1\].g_col\[1\].pe_hold3119 g_row\[1\].g_col\[1\].pe__2707_/Q VGND VGND VPWR
+ VPWR g_row\[1\].g_col\[1\].pe_hold3119/X sky130_fd_sc_hd__clkbuf_2
Xg_row\[0\].g_col\[1\].pe__2183_ g_row\[0\].g_col\[1\].pe__2183_/A g_row\[0\].g_col\[1\].pe__2183_/B
+ VGND VGND VPWR VPWR g_row\[0\].g_col\[1\].pe__2203_/B sky130_fd_sc_hd__xor2_2
XTAP_TAPCELL_ROW_8_327 VGND VPWR sky130_fd_sc_hd__tapvpwrvgnd_1
Xg_row\[0\].g_col\[0\].pe__2098_ g_row\[0\].g_col\[0\].pe__2048_/A g_row\[0\].g_col\[0\].pe__2048_/B
+ g_row\[0\].g_col\[0\].pe__2048_/C g_row\[0\].g_col\[0\].pe__2047_/B g_row\[0\].g_col\[0\].pe__2047_/A
+ VGND VGND VPWR VPWR g_row\[0\].g_col\[0\].pe__2099_/C sky130_fd_sc_hd__a32o_2
Xg_row\[1\].g_col\[1\].pe_hold1728 g_row\[1\].g_col\[1\].pe__2745_/Q VGND VGND VPWR
+ VPWR g_row\[1\].g_col\[1\].pe__2116_/A sky130_fd_sc_hd__clkbuf_2
Xg_row\[1\].g_col\[1\].pe_hold1706 g_row\[1\].g_col\[1\].pe__2422_/A VGND VGND VPWR
+ VPWR g_row\[1\].g_col\[1\].pe__2395_/A2 sky130_fd_sc_hd__clkbuf_2
Xg_row\[1\].g_col\[1\].pe__1958_ g_row\[1\].g_col\[1\].pe__2138_/B2 g_row\[1\].g_col\[1\].pe__1504_/Y
+ g_row\[1\].g_col\[1\].pe__1541_/X g_row\[1\].g_col\[1\].pe__2073_/B2 VGND VGND VPWR
+ VPWR g_row\[1\].g_col\[1\].pe__1959_/B sky130_fd_sc_hd__a22o_2
Xhold3100 hold3100/A VGND VGND VPWR VPWR hold3100/X sky130_fd_sc_hd__clkbuf_2
Xhold3133 hold3133/A VGND VGND VPWR VPWR hold3133/X sky130_fd_sc_hd__clkbuf_2
Xg_row\[1\].g_col\[1\].pe_hold1739 g_row\[1\].g_col\[1\].pe__2430_/A VGND VGND VPWR
+ VPWR g_row\[1\].g_col\[1\].pe__2334_/A2 sky130_fd_sc_hd__clkbuf_2
Xg_row\[1\].g_col\[1\].pe__1889_ g_row\[1\].g_col\[1\].pe__1951_/A g_row\[1\].g_col\[1\].pe__1889_/B
+ VGND VGND VPWR VPWR g_row\[1\].g_col\[1\].pe__1894_/B sky130_fd_sc_hd__nor2_2
XFILLER_0_238 VGND VGND VPWR VPWR sky130_fd_sc_hd__fill_1
Xhold2410 hold3134/X VGND VGND VPWR VPWR hold3135/A sky130_fd_sc_hd__clkbuf_2
Xhold2421 hold3146/X VGND VGND VPWR VPWR hold3147/A sky130_fd_sc_hd__clkbuf_2
Xhold3144 a_inputs_flat[14] VGND VGND VPWR VPWR hold3144/X sky130_fd_sc_hd__clkbuf_2
Xhold3155 hold3155/A VGND VGND VPWR VPWR hold3155/X sky130_fd_sc_hd__clkbuf_2
Xhold3166 hold3166/A VGND VGND VPWR VPWR hold3166/X sky130_fd_sc_hd__clkbuf_2
XFILLER_29_401 VGND VGND VPWR VPWR sky130_fd_sc_hd__decap_3
Xhold2432 hold3165/X VGND VGND VPWR VPWR hold3166/A sky130_fd_sc_hd__clkbuf_2
Xhold2443 hold2443/A VGND VGND VPWR VPWR _328_/D sky130_fd_sc_hd__clkbuf_2
Xhold2454 _247_/Y VGND VGND VPWR VPWR hold2454/X sky130_fd_sc_hd__clkbuf_2
Xhold3177 hold3177/A VGND VGND VPWR VPWR hold3177/X sky130_fd_sc_hd__clkbuf_2
Xhold3188 hold3188/A VGND VGND VPWR VPWR hold3188/X sky130_fd_sc_hd__clkbuf_2
Xhold3199 hold3199/A VGND VGND VPWR VPWR hold3199/X sky130_fd_sc_hd__clkbuf_2
Xhold2465 hold3164/X VGND VGND VPWR VPWR _157_/B_N sky130_fd_sc_hd__clkbuf_2
Xhold2476 hold3218/X VGND VGND VPWR VPWR hold3219/A sky130_fd_sc_hd__clkbuf_2
Xhold2487 hold3195/X VGND VGND VPWR VPWR hold3196/A sky130_fd_sc_hd__clkbuf_2
Xhold2498 hold3235/X VGND VGND VPWR VPWR hold3236/A sky130_fd_sc_hd__clkbuf_2
XFILLER_57_798 VGND VGND VPWR VPWR sky130_fd_sc_hd__fill_2
XTAP_TAPCELL_ROW_67_1216 VGND VPWR sky130_fd_sc_hd__tapvpwrvgnd_1
Xg_row\[0\].g_col\[1\].pe__1967_ g_row\[0\].g_col\[1\].pe__1449_/A g_row\[0\].g_col\[1\].pe__1449_/B
+ g_row\[0\].g_col\[1\].pe__1966_/Y VGND VGND VPWR VPWR g_row\[0\].g_col\[1\].pe__1968_/C
+ sky130_fd_sc_hd__a21o_2
XFILLER_16_117 VGND VGND VPWR VPWR sky130_fd_sc_hd__decap_3
XFILLER_72_757 VGND VGND VPWR VPWR sky130_fd_sc_hd__fill_2
XTAP_TAPCELL_ROW_27_613 VGND VPWR sky130_fd_sc_hd__tapvpwrvgnd_1
Xg_row\[0\].g_col\[1\].pe__1898_ g_row\[0\].g_col\[1\].pe__1604_/A g_row\[0\].g_col\[1\].pe__1604_/B
+ g_row\[0\].g_col\[1\].pe__1860_/B g_row\[0\].g_col\[1\].pe__1859_/B g_row\[0\].g_col\[1\].pe__1859_/A
+ VGND VGND VPWR VPWR g_row\[0\].g_col\[1\].pe__1939_/A sky130_fd_sc_hd__a32o_2
XTAP_TAPCELL_ROW_80_1405 VGND VPWR sky130_fd_sc_hd__tapvpwrvgnd_1
XTAP_TAPCELL_ROW_80_1416 VGND VPWR sky130_fd_sc_hd__tapvpwrvgnd_1
XFILLER_52_492 VGND VGND VPWR VPWR sky130_fd_sc_hd__decap_3
Xg_row\[0\].g_col\[1\].pe__2519_ g_row\[0\].g_col\[1\].pe__2519_/A g_row\[0\].g_col\[1\].pe__2519_/B
+ VGND VGND VPWR VPWR g_row\[0\].g_col\[1\].pe__2519_/Y sky130_fd_sc_hd__nand2_2
XFILLER_9_839 VGND VGND VPWR VPWR sky130_fd_sc_hd__fill_1
XFILLER_40_698 VGND VGND VPWR VPWR sky130_fd_sc_hd__fill_2
XANTENNA_90 hold3315/X VGND VGND VPWR VPWR sky130_fd_sc_hd__diode_2
XFILLER_4_500 VGND VGND VPWR VPWR sky130_fd_sc_hd__fill_2
XTAP_TAPCELL_ROW_78_1378 VGND VPWR sky130_fd_sc_hd__tapvpwrvgnd_1
XFILLER_21_83 VGND VGND VPWR VPWR sky130_fd_sc_hd__fill_1
XFILLER_4_577 VGND VGND VPWR VPWR sky130_fd_sc_hd__decap_3
XFILLER_4_599 VGND VGND VPWR VPWR sky130_fd_sc_hd__decap_3
XFILLER_0_750 VGND VGND VPWR VPWR sky130_fd_sc_hd__decap_3
XTAP_TAPCELL_ROW_91_1578 VGND VPWR sky130_fd_sc_hd__tapvpwrvgnd_1
Xg_row\[1\].g_col\[0\].pe__1460_ g_row\[1\].g_col\[0\].pe__2731_/Q g_row\[1\].g_col\[0\].pe__1460_/B
+ g_row\[1\].g_col\[0\].pe__2732_/Q VGND VGND VPWR VPWR g_row\[1\].g_col\[0\].pe__1461_/B
+ sky130_fd_sc_hd__or3b_4
Xg_row\[1\].g_col\[0\].pe__1391_ g_row\[1\].g_col\[0\].pe__1391_/A1 g_row\[1\].g_col\[0\].pe__2679_/A2
+ g_row\[1\].g_col\[0\].pe__1391_/B1 g_row\[1\].g_col\[0\].pe__1403_/C1 VGND VGND
+ VPWR VPWR g_row\[1\].g_col\[0\].pe__1391_/X sky130_fd_sc_hd__o211a_2
XFILLER_35_404 VGND VGND VPWR VPWR sky130_fd_sc_hd__fill_1
XFILLER_47_253 VGND VGND VPWR VPWR sky130_fd_sc_hd__fill_1
XTAP_TAPCELL_ROW_46_900 VGND VPWR sky130_fd_sc_hd__tapvpwrvgnd_1
XFILLER_75_584 VGND VGND VPWR VPWR sky130_fd_sc_hd__decap_3
XFILLER_35_459 VGND VGND VPWR VPWR sky130_fd_sc_hd__decap_3
Xg_row\[1\].g_col\[0\].pe__2012_ g_row\[1\].g_col\[0\].pe__1951_/A g_row\[1\].g_col\[0\].pe__1951_/B
+ g_row\[1\].g_col\[0\].pe__2009_/B g_row\[1\].g_col\[0\].pe__2006_/A VGND VGND VPWR
+ VPWR g_row\[1\].g_col\[0\].pe__2062_/C sky130_fd_sc_hd__a31o_2
XFILLER_62_278 VGND VGND VPWR VPWR sky130_fd_sc_hd__fill_1
XFILLER_90_576 VGND VGND VPWR VPWR sky130_fd_sc_hd__fill_1
XFILLER_30_197 VGND VGND VPWR VPWR sky130_fd_sc_hd__fill_1
Xg_row\[0\].g_col\[0\].pe__2021_ g_row\[0\].g_col\[0\].pe__2217_/A g_row\[0\].g_col\[0\].pe__2021_/B
+ VGND VGND VPWR VPWR g_row\[0\].g_col\[0\].pe__2071_/B sky130_fd_sc_hd__xnor2_2
Xg_row\[1\].g_col\[1\].pe__1812_ g_row\[1\].g_col\[1\].pe__1813_/A g_row\[1\].g_col\[1\].pe__1780_/Y
+ g_row\[1\].g_col\[1\].pe__1810_/X g_row\[1\].g_col\[1\].pe__1811_/X VGND VGND VPWR
+ VPWR g_row\[1\].g_col\[1\].pe__1812_/X sky130_fd_sc_hd__o31a_2
Xg_row\[1\].g_col\[0\].pe__2776_ g_row\[1\].g_col\[0\].pe__2776_/A VGND VGND VPWR
+ VPWR output1396/A sky130_fd_sc_hd__buf_2
Xg_row\[1\].g_col\[1\].pe__1743_ g_row\[1\].g_col\[1\].pe__1743_/A g_row\[1\].g_col\[1\].pe__1743_/B
+ VGND VGND VPWR VPWR g_row\[1\].g_col\[1\].pe__1815_/A sky130_fd_sc_hd__xnor2_2
Xg_row\[1\].g_col\[0\].pe__1727_ g_row\[1\].g_col\[0\].pe__1804_/A place1093/X place1096/X
+ g_row\[1\].g_col\[0\].pe__1804_/B VGND VGND VPWR VPWR g_row\[1\].g_col\[0\].pe__1728_/B
+ sky130_fd_sc_hd__a22o_2
Xg_row\[1\].g_col\[1\].pe__1674_ g_row\[1\].g_col\[1\].pe__1690_/A g_row\[1\].g_col\[1\].pe__1690_/B
+ VGND VGND VPWR VPWR g_row\[1\].g_col\[1\].pe__1676_/B sky130_fd_sc_hd__nand2_2
Xg_row\[1\].g_col\[0\].pe__1658_ g_row\[1\].g_col\[0\].pe__1676_/A g_row\[1\].g_col\[0\].pe__1658_/B
+ VGND VGND VPWR VPWR g_row\[1\].g_col\[0\].pe__1664_/A sky130_fd_sc_hd__xnor2_2
Xg_row\[1\].g_col\[0\].pe__1589_ g_row\[1\].g_col\[0\].pe__1547_/A g_row\[1\].g_col\[0\].pe__1547_/B
+ g_row\[1\].g_col\[0\].pe__1588_/Y VGND VGND VPWR VPWR g_row\[1\].g_col\[0\].pe__1594_/B
+ sky130_fd_sc_hd__a21o_2
Xg_row\[0\].g_col\[1\].pe__1821_ g_row\[0\].g_col\[1\].pe__1822_/C g_row\[0\].g_col\[1\].pe__1821_/B
+ g_row\[0\].g_col\[1\].pe__1821_/C g_row\[0\].g_col\[1\].pe__1821_/D VGND VGND VPWR
+ VPWR g_row\[0\].g_col\[1\].pe__1821_/X sky130_fd_sc_hd__and4_2
Xg_row\[0\].g_col\[0\].pe__1805_ g_row\[0\].g_col\[0\].pe__1804_/A place1220/X place1222/X
+ g_row\[0\].g_col\[0\].pe__1804_/X g_row\[0\].g_col\[0\].pe__1801_/X VGND VGND VPWR
+ VPWR g_row\[0\].g_col\[0\].pe__1808_/B sky130_fd_sc_hd__a221o_2
Xg_row\[0\].g_col\[0\].pe__1736_ g_row\[0\].g_col\[0\].pe__1736_/A g_row\[0\].g_col\[0\].pe__1736_/B
+ VGND VGND VPWR VPWR g_row\[0\].g_col\[0\].pe__1740_/B sky130_fd_sc_hd__xnor2_2
Xg_row\[0\].g_col\[1\].pe__1752_ g_row\[0\].g_col\[1\].pe__2686_/A g_row\[0\].g_col\[1\].pe__1752_/B
+ VGND VGND VPWR VPWR g_row\[0\].g_col\[1\].pe__1756_/B sky130_fd_sc_hd__xor2_2
Xg_row\[0\].g_col\[1\].pe__1683_ g_row\[0\].g_col\[1\].pe__1686_/A g_row\[0\].g_col\[1\].pe__1686_/B
+ VGND VGND VPWR VPWR g_row\[0\].g_col\[1\].pe__1713_/A sky130_fd_sc_hd__xor2_2
Xg_row\[1\].g_col\[1\].pe__2226_ g_row\[1\].g_col\[1\].pe__2226_/A g_row\[1\].g_col\[1\].pe__2226_/B
+ VGND VGND VPWR VPWR g_row\[1\].g_col\[1\].pe__2228_/C sky130_fd_sc_hd__xor2_2
Xg_row\[0\].g_col\[0\].pe__1667_ g_row\[0\].g_col\[0\].pe__1663_/A g_row\[0\].g_col\[0\].pe__1663_/B
+ g_row\[0\].g_col\[0\].pe__1666_/Y VGND VGND VPWR VPWR g_row\[0\].g_col\[0\].pe__1701_/B
+ sky130_fd_sc_hd__a21boi_2
XFILLER_22_632 VGND VGND VPWR VPWR sky130_fd_sc_hd__decap_3
XTAP_TAPCELL_ROW_62_1135 VGND VPWR sky130_fd_sc_hd__tapvpwrvgnd_1
XTAP_TAPCELL_ROW_62_1146 VGND VPWR sky130_fd_sc_hd__tapvpwrvgnd_1
Xg_row\[0\].g_col\[0\].pe__1598_ g_row\[0\].g_col\[0\].pe__1672_/A1 g_row\[0\].g_col\[0\].pe__1558_/B
+ g_row\[0\].g_col\[0\].pe__2388_/B place1223/X VGND VGND VPWR VPWR g_row\[0\].g_col\[0\].pe__1604_/A
+ sky130_fd_sc_hd__a22o_2
Xg_row\[1\].g_col\[1\].pe__2157_ g_row\[1\].g_col\[1\].pe__2157_/A g_row\[1\].g_col\[1\].pe__2157_/B
+ VGND VGND VPWR VPWR g_row\[1\].g_col\[1\].pe__2157_/Y sky130_fd_sc_hd__nand2_2
Xg_row\[1\].g_col\[1\].pe__2088_ g_row\[1\].g_col\[1\].pe__2087_/A g_row\[1\].g_col\[1\].pe__2087_/B
+ g_row\[1\].g_col\[1\].pe__2087_/C g_row\[1\].g_col\[1\].pe__2087_/D VGND VGND VPWR
+ VPWR g_row\[1\].g_col\[1\].pe__2091_/B sky130_fd_sc_hd__a22o_4
XTAP_TAPCELL_ROW_32_693 VGND VPWR sky130_fd_sc_hd__tapvpwrvgnd_1
Xg_row\[0\].g_col\[1\].pe__2304_ g_row\[0\].g_col\[1\].pe__2304_/A g_row\[0\].g_col\[1\].pe__2304_/B
+ g_row\[0\].g_col\[1\].pe__2304_/C VGND VGND VPWR VPWR g_row\[0\].g_col\[1\].pe__2305_/B
+ sky130_fd_sc_hd__and3_2
Xg_row\[0\].g_col\[0\].pe__2219_ g_row\[0\].g_col\[0\].pe__2219_/A g_row\[0\].g_col\[0\].pe__2219_/B
+ VGND VGND VPWR VPWR g_row\[0\].g_col\[0\].pe__2220_/B sky130_fd_sc_hd__xor2_2
Xg_row\[0\].g_col\[1\].pe__2235_ g_row\[0\].g_col\[1\].pe__2235_/A VGND VGND VPWR
+ VPWR g_row\[0\].g_col\[1\].pe__2436_/A sky130_fd_sc_hd__inv_2
Xg_row\[0\].g_col\[1\].pe__2166_ g_row\[0\].g_col\[1\].pe__2165_/B g_row\[0\].g_col\[1\].pe__2165_/C
+ g_row\[0\].g_col\[1\].pe__2165_/A VGND VGND VPWR VPWR g_row\[0\].g_col\[1\].pe__2167_/C
+ sky130_fd_sc_hd__a21o_2
Xg_row\[1\].g_col\[1\].pe_hold2248 g_row\[1\].g_col\[1\].pe__2644_/X VGND VGND VPWR
+ VPWR g_row\[1\].g_col\[1\].pe__2707_/D sky130_fd_sc_hd__clkbuf_2
Xg_row\[0\].g_col\[1\].pe__2097_ g_row\[0\].g_col\[1\].pe__2097_/A g_row\[0\].g_col\[1\].pe__2097_/B
+ g_row\[0\].g_col\[1\].pe__2097_/C VGND VGND VPWR VPWR g_row\[0\].g_col\[1\].pe__2184_/B
+ sky130_fd_sc_hd__or3_4
XFILLER_49_529 VGND VGND VPWR VPWR sky130_fd_sc_hd__decap_3
XFILLER_67_57 VGND VGND VPWR VPWR sky130_fd_sc_hd__decap_3
XFILLER_77_838 VGND VGND VPWR VPWR sky130_fd_sc_hd__fill_2
XFILLER_88_153 VGND VGND VPWR VPWR sky130_fd_sc_hd__fill_1
XFILLER_29_220 VGND VGND VPWR VPWR sky130_fd_sc_hd__decap_3
XFILLER_67_68 VGND VGND VPWR VPWR sky130_fd_sc_hd__fill_2
Xhold1550 hold3485/X VGND VGND VPWR VPWR hold3486/A sky130_fd_sc_hd__clkbuf_2
Xhold1561 hold3460/X VGND VGND VPWR VPWR hold3461/A sky130_fd_sc_hd__clkbuf_2
XFILLER_29_275 VGND VGND VPWR VPWR sky130_fd_sc_hd__fill_1
XFILLER_57_595 VGND VGND VPWR VPWR sky130_fd_sc_hd__decap_3
Xhold1572 hold2700/X VGND VGND VPWR VPWR hold2701/A sky130_fd_sc_hd__clkbuf_2
Xhold1583 hold3520/X VGND VGND VPWR VPWR hold3521/A sky130_fd_sc_hd__clkbuf_2
Xhold1594 hold3502/X VGND VGND VPWR VPWR hold3503/A sky130_fd_sc_hd__clkbuf_2
Xg_row\[1\].g_col\[0\].pe_place933 g_row\[1\].g_col\[0\].pe__1387_/B VGND VGND VPWR
+ VPWR g_row\[1\].g_col\[0\].pe__2680_/B sky130_fd_sc_hd__buf_6
Xg_row\[1\].g_col\[0\].pe_place922 g_row\[1\].g_col\[0\].pe__1801_/B VGND VGND VPWR
+ VPWR g_row\[1\].g_col\[0\].pe__1729_/B1 sky130_fd_sc_hd__buf_6
Xg_row\[1\].g_col\[0\].pe_place911 g_row\[1\].g_col\[0\].pe__2075_/A VGND VGND VPWR
+ VPWR g_row\[1\].g_col\[0\].pe__2364_/A sky130_fd_sc_hd__buf_6
XFILLER_32_418 VGND VGND VPWR VPWR sky130_fd_sc_hd__fill_2
XFILLER_13_643 VGND VGND VPWR VPWR sky130_fd_sc_hd__decap_3
XFILLER_13_676 VGND VGND VPWR VPWR sky130_fd_sc_hd__decap_3
XTAP_TAPCELL_ROW_51_980 VGND VPWR sky130_fd_sc_hd__tapvpwrvgnd_1
XTAP_TAPCELL_ROW_10_354 VGND VPWR sky130_fd_sc_hd__tapvpwrvgnd_1
XTAP_TAPCELL_ROW_10_365 VGND VPWR sky130_fd_sc_hd__tapvpwrvgnd_1
XTAP_TAPCELL_ROW_93_1607 VGND VPWR sky130_fd_sc_hd__tapvpwrvgnd_1
Xclkbuf_leaf_101_clk clkbuf_4_2_0_clk/X VGND VGND VPWR VPWR _333_/CLK sky130_fd_sc_hd__clkbuf_16
XTAP_TAPCELL_ROW_93_1618 VGND VPWR sky130_fd_sc_hd__tapvpwrvgnd_1
Xg_row\[0\].g_col\[0\].pe_place1175 g_row\[0\].g_col\[0\].pe__2771_/Q VGND VGND VPWR
+ VPWR g_row\[0\].g_col\[0\].pe__1348_/A sky130_fd_sc_hd__buf_6
Xg_row\[0\].g_col\[0\].pe_place1186 g_row\[0\].g_col\[0\].pe__2728_/Q VGND VGND VPWR
+ VPWR g_row\[0\].g_col\[0\].pe__2094_/A sky130_fd_sc_hd__buf_6
Xg_row\[0\].g_col\[0\].pe_place1197 hold2359/A VGND VGND VPWR VPWR g_row\[0\].g_col\[0\].pe__2083_/A
+ sky130_fd_sc_hd__buf_6
Xg_row\[1\].g_col\[0\].pe__2630_ place1257/X hold1986/X VGND VGND VPWR VPWR g_row\[1\].g_col\[0\].pe__2630_/X
+ sky130_fd_sc_hd__or2_2
Xg_row\[1\].g_col\[0\].pe__2561_ g_row\[1\].g_col\[0\].pe__2561_/A g_row\[1\].g_col\[0\].pe__2561_/B
+ VGND VGND VPWR VPWR g_row\[1\].g_col\[0\].pe__2763_/D sky130_fd_sc_hd__and2_4
Xg_row\[1\].g_col\[0\].pe__2492_ g_row\[1\].g_col\[0\].pe__2492_/A g_row\[1\].g_col\[0\].pe__2492_/B
+ VGND VGND VPWR VPWR g_row\[1\].g_col\[0\].pe__2567_/A sky130_fd_sc_hd__and2_2
Xg_row\[1\].g_col\[0\].pe__1512_ g_row\[1\].g_col\[0\].pe__1512_/A g_row\[1\].g_col\[0\].pe__1512_/B
+ VGND VGND VPWR VPWR g_row\[1\].g_col\[0\].pe__1512_/Y sky130_fd_sc_hd__nor2_2
Xg_row\[1\].g_col\[0\].pe__1443_ g_row\[1\].g_col\[0\].pe__1479_/A g_row\[1\].g_col\[0\].pe__1479_/B
+ VGND VGND VPWR VPWR g_row\[1\].g_col\[0\].pe__1662_/A sky130_fd_sc_hd__xor2_2
XFILLER_35_201 VGND VGND VPWR VPWR sky130_fd_sc_hd__decap_3
XFILLER_36_735 VGND VGND VPWR VPWR sky130_fd_sc_hd__decap_3
XFILLER_48_584 VGND VGND VPWR VPWR sky130_fd_sc_hd__decap_3
Xg_row\[1\].g_col\[0\].pe__1374_ place1257/X _276_/Q VGND VGND VPWR VPWR g_row\[1\].g_col\[0\].pe__1387_/B
+ sky130_fd_sc_hd__nand2_2
XFILLER_35_223 VGND VGND VPWR VPWR sky130_fd_sc_hd__fill_1
XFILLER_91_841 VGND VGND VPWR VPWR sky130_fd_sc_hd__fill_1
Xg_row\[0\].g_col\[0\].pe__1521_ place1204/X g_row\[0\].g_col\[0\].pe__1732_/A2 g_row\[0\].g_col\[0\].pe__1732_/B1
+ place1205/X VGND VGND VPWR VPWR g_row\[0\].g_col\[0\].pe__1522_/B sky130_fd_sc_hd__a22o_2
XFILLER_35_278 VGND VGND VPWR VPWR sky130_fd_sc_hd__fill_2
XTAP_TAPCELL_ROW_18_476 VGND VPWR sky130_fd_sc_hd__tapvpwrvgnd_1
XTAP_TAPCELL_ROW_18_487 VGND VPWR sky130_fd_sc_hd__tapvpwrvgnd_1
Xg_row\[0\].g_col\[0\].pe__1452_ g_row\[0\].g_col\[0\].pe__1816_/A g_row\[0\].g_col\[0\].pe__1452_/B
+ VGND VGND VPWR VPWR g_row\[0\].g_col\[0\].pe__1507_/A sky130_fd_sc_hd__xor2_2
Xg_row\[1\].g_col\[1\].pe__2011_ g_row\[1\].g_col\[1\].pe__2011_/A1 g_row\[1\].g_col\[1\].pe__2010_/X
+ hold1641/X VGND VGND VPWR VPWR g_row\[1\].g_col\[1\].pe__2011_/Y sky130_fd_sc_hd__a21oi_2
Xg_row\[0\].g_col\[0\].pe__1383_ g_row\[0\].g_col\[0\].pe__1383_/A g_row\[0\].g_col\[0\].pe__1385_/B
+ VGND VGND VPWR VPWR g_row\[0\].g_col\[0\].pe__1383_/X sky130_fd_sc_hd__or2_2
XFILLER_31_495 VGND VGND VPWR VPWR sky130_fd_sc_hd__decap_3
Xg_row\[0\].g_col\[1\].pe__2020_ g_row\[0\].g_col\[1\].pe__2616_/B g_row\[0\].g_col\[1\].pe__1549_/B
+ g_row\[0\].g_col\[1\].pe__2216_/B1 g_row\[0\].g_col\[1\].pe__2138_/B2 VGND VGND
+ VPWR VPWR g_row\[0\].g_col\[1\].pe__2021_/B sky130_fd_sc_hd__a22o_2
Xg_row\[0\].g_col\[0\].pe__2004_ g_row\[0\].g_col\[0\].pe__2005_/A g_row\[0\].g_col\[0\].pe__2005_/B
+ VGND VGND VPWR VPWR g_row\[0\].g_col\[0\].pe__2006_/A sky130_fd_sc_hd__and2_2
Xg_row\[1\].g_col\[1\].pe__2775_ g_row\[1\].g_col\[1\].pe__2775_/A VGND VGND VPWR
+ VPWR output1397/A sky130_fd_sc_hd__buf_2
Xg_row\[1\].g_col\[0\].pe__2759_ clkbuf_leaf_58_clk/X g_row\[1\].g_col\[0\].pe__2759_/D
+ VGND VGND VPWR VPWR g_row\[1\].g_col\[0\].pe__2759_/Q sky130_fd_sc_hd__dfxtp_2
XFILLER_86_602 VGND VGND VPWR VPWR sky130_fd_sc_hd__decap_3
XFILLER_86_613 VGND VGND VPWR VPWR sky130_fd_sc_hd__decap_3
Xg_row\[1\].g_col\[1\].pe__1726_ g_row\[1\].g_col\[1\].pe__1824_/B g_row\[1\].g_col\[1\].pe__1726_/B
+ VGND VGND VPWR VPWR g_row\[1\].g_col\[1\].pe__1747_/A sky130_fd_sc_hd__xnor2_2
Xg_row\[1\].g_col\[1\].pe__1657_ g_row\[1\].g_col\[1\].pe__1657_/A g_row\[1\].g_col\[1\].pe__1657_/B
+ VGND VGND VPWR VPWR g_row\[1\].g_col\[1\].pe__1658_/B sky130_fd_sc_hd__nand2_2
XFILLER_39_595 VGND VGND VPWR VPWR sky130_fd_sc_hd__decap_3
Xg_row\[1\].g_col\[1\].pe__1588_ g_row\[1\].g_col\[1\].pe__1588_/A g_row\[1\].g_col\[1\].pe__1588_/B
+ VGND VGND VPWR VPWR g_row\[1\].g_col\[1\].pe__1588_/Y sky130_fd_sc_hd__nor2_2
Xg_row\[1\].g_col\[0\].pe_hold1770 g_row\[1\].g_col\[0\].pe__2594_/X VGND VGND VPWR
+ VPWR g_row\[1\].g_col\[0\].pe__2595_/B sky130_fd_sc_hd__clkbuf_2
Xg_row\[0\].g_col\[1\].pe__1804_ g_row\[0\].g_col\[1\].pe__1804_/A g_row\[0\].g_col\[1\].pe__1804_/B
+ VGND VGND VPWR VPWR g_row\[0\].g_col\[1\].pe__1804_/X sky130_fd_sc_hd__or2_2
XFILLER_27_779 VGND VGND VPWR VPWR sky130_fd_sc_hd__fill_1
Xg_row\[0\].g_col\[0\].pe__2768_ clkbuf_leaf_52_clk/X g_row\[0\].g_col\[0\].pe__2768_/D
+ VGND VGND VPWR VPWR g_row\[0\].g_col\[0\].pe__2768_/Q sky130_fd_sc_hd__dfxtp_2
Xg_row\[0\].g_col\[1\].pe__1735_ g_row\[0\].g_col\[1\].pe__1758_/A g_row\[0\].g_col\[1\].pe__1758_/B
+ g_row\[0\].g_col\[1\].pe__1734_/X VGND VGND VPWR VPWR g_row\[0\].g_col\[1\].pe__1740_/A
+ sky130_fd_sc_hd__a21oi_2
XFILLER_14_418 VGND VGND VPWR VPWR sky130_fd_sc_hd__fill_2
XTAP_TAPCELL_ROW_37_763 VGND VPWR sky130_fd_sc_hd__tapvpwrvgnd_1
Xg_row\[0\].g_col\[0\].pe__1719_ g_row\[0\].g_col\[0\].pe__1714_/A g_row\[0\].g_col\[0\].pe__1714_/B
+ g_row\[0\].g_col\[0\].pe__1714_/C VGND VGND VPWR VPWR g_row\[0\].g_col\[0\].pe__1719_/Y
+ sky130_fd_sc_hd__a21oi_2
Xg_row\[0\].g_col\[0\].pe__2699_ clkbuf_leaf_20_clk/X g_row\[0\].g_col\[0\].pe__2699_/D
+ VGND VGND VPWR VPWR hold2339/A sky130_fd_sc_hd__dfxtp_2
Xg_row\[0\].g_col\[1\].pe__1666_ g_row\[0\].g_col\[1\].pe__1697_/B g_row\[0\].g_col\[1\].pe__1697_/A
+ VGND VGND VPWR VPWR g_row\[0\].g_col\[1\].pe__1666_/Y sky130_fd_sc_hd__nand2b_2
Xg_row\[1\].g_col\[1\].pe__2209_ g_row\[1\].g_col\[1\].pe__2209_/A g_row\[1\].g_col\[1\].pe__2209_/B
+ VGND VGND VPWR VPWR g_row\[1\].g_col\[1\].pe__2210_/B sky130_fd_sc_hd__xnor2_2
Xg_row\[0\].g_col\[1\].pe__1597_ g_row\[0\].g_col\[1\].pe__1571_/A g_row\[0\].g_col\[1\].pe__1571_/B
+ g_row\[0\].g_col\[1\].pe__1596_/X VGND VGND VPWR VPWR g_row\[0\].g_col\[1\].pe__1606_/A
+ sky130_fd_sc_hd__a21oi_2
XFILLER_6_617 VGND VGND VPWR VPWR sky130_fd_sc_hd__decap_3
Xg_row\[0\].g_col\[1\].pe__2218_ g_row\[0\].g_col\[1\].pe__2239_/A g_row\[0\].g_col\[1\].pe__2239_/B
+ VGND VGND VPWR VPWR g_row\[0\].g_col\[1\].pe__2219_/B sky130_fd_sc_hd__xor2_2
XTAP_TAPCELL_ROW_75_1337 VGND VPWR sky130_fd_sc_hd__tapvpwrvgnd_1
Xg_row\[0\].g_col\[1\].pe__2149_ g_row\[0\].g_col\[1\].pe__2161_/A g_row\[0\].g_col\[1\].pe__2161_/B
+ VGND VGND VPWR VPWR g_row\[0\].g_col\[1\].pe__2200_/A sky130_fd_sc_hd__xnor2_2
Xg_row\[1\].g_col\[1\].pe_hold2089 g_row\[1\].g_col\[1\].pe_hold2828/X VGND VGND VPWR
+ VPWR g_row\[1\].g_col\[1\].pe_hold2829/A sky130_fd_sc_hd__clkbuf_2
XFILLER_49_337 VGND VGND VPWR VPWR sky130_fd_sc_hd__fill_2
XFILLER_18_735 VGND VGND VPWR VPWR sky130_fd_sc_hd__decap_3
XFILLER_17_223 VGND VGND VPWR VPWR sky130_fd_sc_hd__fill_1
XFILLER_18_757 VGND VGND VPWR VPWR sky130_fd_sc_hd__decap_3
XFILLER_73_841 VGND VGND VPWR VPWR sky130_fd_sc_hd__fill_1
XFILLER_32_248 VGND VGND VPWR VPWR sky130_fd_sc_hd__decap_3
XFILLER_60_546 VGND VGND VPWR VPWR sky130_fd_sc_hd__fill_1
XFILLER_72_395 VGND VGND VPWR VPWR sky130_fd_sc_hd__fill_1
XTAP_TAPCELL_ROW_15_435 VGND VPWR sky130_fd_sc_hd__tapvpwrvgnd_1
XTAP_TAPCELL_ROW_86_1499 VGND VPWR sky130_fd_sc_hd__tapvpwrvgnd_1
Xg_row\[0\].g_col\[0\].pe_hold1802 g_row\[0\].g_col\[0\].pe_hold3077/X VGND VGND VPWR
+ VPWR g_row\[0\].g_col\[0\].pe__1397_/A1 sky130_fd_sc_hd__clkbuf_2
Xg_row\[0\].g_col\[0\].pe_hold1835 g_row\[0\].g_col\[0\].pe_hold3113/X VGND VGND VPWR
+ VPWR g_row\[0\].g_col\[0\].pe__1950_/B sky130_fd_sc_hd__clkbuf_2
Xg_row\[1\].g_col\[0\].pe__1992_ g_row\[1\].g_col\[0\].pe__1991_/A g_row\[1\].g_col\[0\].pe__1991_/B
+ g_row\[1\].g_col\[0\].pe__1991_/C g_row\[1\].g_col\[0\].pe__1991_/D VGND VGND VPWR
+ VPWR g_row\[1\].g_col\[0\].pe__1993_/B sky130_fd_sc_hd__a22o_2
XFILLER_5_650 VGND VGND VPWR VPWR sky130_fd_sc_hd__decap_3
Xinput1290 hold3562/X VGND VGND VPWR VPWR hold3563/A sky130_fd_sc_hd__buf_2
XFILLER_4_182 VGND VGND VPWR VPWR sky130_fd_sc_hd__fill_1
Xg_row\[1\].g_col\[0\].pe__2613_ g_row\[1\].g_col\[0\].pe__2640_/A1 g_row\[1\].g_col\[0\].pe__2613_/A2
+ g_row\[1\].g_col\[0\].pe__2640_/C1 g_row\[1\].g_col\[0\].pe__2612_/X VGND VGND VPWR
+ VPWR g_row\[1\].g_col\[0\].pe__2613_/X sky130_fd_sc_hd__o211a_2
Xg_row\[1\].g_col\[1\].pe__2560_ g_row\[1\].g_col\[1\].pe__2560_/A1 g_row\[1\].g_col\[1\].pe__2568_/A2
+ g_row\[1\].g_col\[1\].pe__2568_/B1 g_row\[1\].g_col\[1\].pe__2559_/X VGND VGND VPWR
+ VPWR g_row\[1\].g_col\[1\].pe__2560_/X sky130_fd_sc_hd__a22o_2
Xg_row\[1\].g_col\[0\].pe__2544_ g_row\[1\].g_col\[0\].pe__2466_/X g_row\[1\].g_col\[0\].pe__2544_/B
+ VGND VGND VPWR VPWR g_row\[1\].g_col\[0\].pe__2546_/A sky130_fd_sc_hd__and2b_2
XFILLER_68_624 VGND VGND VPWR VPWR sky130_fd_sc_hd__decap_3
Xg_row\[1\].g_col\[1\].pe__2491_ g_row\[1\].g_col\[1\].pe__2491_/A g_row\[1\].g_col\[1\].pe__2491_/B
+ g_row\[1\].g_col\[1\].pe__2505_/A VGND VGND VPWR VPWR g_row\[1\].g_col\[1\].pe__2492_/B
+ sky130_fd_sc_hd__or3_2
Xg_row\[1\].g_col\[1\].pe__1511_ g_row\[1\].g_col\[1\].pe__1640_/A g_row\[1\].g_col\[1\].pe__1640_/B
+ g_row\[1\].g_col\[1\].pe__1510_/X VGND VGND VPWR VPWR g_row\[1\].g_col\[1\].pe__1550_/A
+ sky130_fd_sc_hd__a21oi_2
Xg_row\[1\].g_col\[1\].pe__1442_ g_row\[1\].g_col\[1\].pe__1442_/A g_row\[1\].g_col\[1\].pe__1442_/B
+ VGND VGND VPWR VPWR g_row\[1\].g_col\[1\].pe__1479_/B sky130_fd_sc_hd__xnor2_2
Xg_row\[1\].g_col\[0\].pe__2475_ g_row\[1\].g_col\[0\].pe__2489_/B g_row\[1\].g_col\[0\].pe__2492_/A
+ g_row\[1\].g_col\[0\].pe__2474_/Y VGND VGND VPWR VPWR g_row\[1\].g_col\[0\].pe__2490_/A
+ sky130_fd_sc_hd__a21boi_2
Xg_row\[0\].g_col\[0\].pe__2622_ g_row\[0\].g_col\[0\].pe__2628_/A1 g_row\[0\].g_col\[0\].pe__2622_/A2
+ g_row\[0\].g_col\[0\].pe__2628_/B1 g_row\[0\].g_col\[0\].pe__2621_/X VGND VGND VPWR
+ VPWR g_row\[0\].g_col\[0\].pe__2622_/X sky130_fd_sc_hd__o211a_2
Xg_row\[1\].g_col\[0\].pe__1426_ place1093/X g_row\[1\].g_col\[0\].pe__1732_/A2 g_row\[1\].g_col\[0\].pe__1732_/B1
+ place1096/X VGND VGND VPWR VPWR g_row\[1\].g_col\[0\].pe__1427_/B sky130_fd_sc_hd__a22o_2
XFILLER_76_690 VGND VGND VPWR VPWR sky130_fd_sc_hd__decap_3
Xg_row\[1\].g_col\[0\].pe__1357_ g_row\[1\].g_col\[0\].pe__2764_/Q g_row\[1\].g_col\[0\].pe__1357_/B
+ VGND VGND VPWR VPWR output1389/A sky130_fd_sc_hd__xor2_2
Xg_row\[0\].g_col\[0\].pe__2553_ g_row\[0\].g_col\[0\].pe__2551_/Y g_row\[0\].g_col\[0\].pe__2552_/X
+ g_row\[0\].g_col\[0\].pe__2559_/A VGND VGND VPWR VPWR g_row\[0\].g_col\[0\].pe__2553_/X
+ sky130_fd_sc_hd__a21o_2
XTAP_TAPCELL_ROW_34_722 VGND VPWR sky130_fd_sc_hd__tapvpwrvgnd_1
Xg_row\[0\].g_col\[0\].pe__1504_ g_row\[0\].g_col\[0\].pe__1504_/A g_row\[0\].g_col\[0\].pe__2341_/B
+ VGND VGND VPWR VPWR g_row\[0\].g_col\[0\].pe__1504_/Y sky130_fd_sc_hd__nor2_2
Xg_row\[0\].g_col\[0\].pe__2484_ g_row\[0\].g_col\[0\].pe__2484_/A VGND VGND VPWR
+ VPWR g_row\[0\].g_col\[0\].pe__2484_/Y sky130_fd_sc_hd__inv_2
Xg_row\[0\].g_col\[1\].pe__1520_ g_row\[0\].g_col\[1\].pe__1580_/A g_row\[0\].g_col\[1\].pe__1580_/B
+ VGND VGND VPWR VPWR g_row\[0\].g_col\[1\].pe__1523_/A sky130_fd_sc_hd__xor2_2
Xg_row\[0\].g_col\[1\].pe__1451_ g_row\[0\].g_col\[1\].pe__1749_/A2 g_row\[0\].g_col\[1\].pe__1748_/B
+ g_row\[0\].g_col\[1\].pe__1738_/B1 g_row\[0\].g_col\[1\].pe__1761_/A2 VGND VGND
+ VPWR VPWR g_row\[0\].g_col\[1\].pe__1452_/B sky130_fd_sc_hd__a22o_2
Xg_row\[0\].g_col\[0\].pe__1366_ g_row\[0\].g_col\[0\].pe__2478_/A g_row\[0\].g_col\[0\].pe__1366_/B
+ VGND VGND VPWR VPWR output1358/A sky130_fd_sc_hd__xnor2_2
Xg_row\[0\].g_col\[1\].pe__2003_ g_row\[0\].g_col\[1\].pe__2013_/A g_row\[0\].g_col\[1\].pe__2013_/B
+ VGND VGND VPWR VPWR g_row\[0\].g_col\[1\].pe__2005_/B sky130_fd_sc_hd__xor2_2
XTAP_TAPCELL_ROW_57_1067 VGND VPWR sky130_fd_sc_hd__tapvpwrvgnd_1
Xg_row\[1\].g_col\[1\].pe__2758_ clkbuf_leaf_74_clk/X g_row\[1\].g_col\[1\].pe__2758_/D
+ VGND VGND VPWR VPWR g_row\[1\].g_col\[1\].pe__2758_/Q sky130_fd_sc_hd__dfxtp_2
XTAP_TAPCELL_ROW_70_1256 VGND VPWR sky130_fd_sc_hd__tapvpwrvgnd_1
Xg_row\[1\].g_col\[1\].pe__1709_ g_row\[1\].g_col\[1\].pe__1709_/A g_row\[1\].g_col\[1\].pe__1709_/B
+ VGND VGND VPWR VPWR g_row\[1\].g_col\[1\].pe__1736_/A sky130_fd_sc_hd__xor2_2
XFILLER_74_605 VGND VGND VPWR VPWR sky130_fd_sc_hd__decap_3
XTAP_TAPCELL_ROW_70_1267 VGND VPWR sky130_fd_sc_hd__tapvpwrvgnd_1
Xg_row\[1\].g_col\[1\].pe__2689_ g_row\[1\].g_col\[1\].pe__2689_/A g_row\[1\].g_col\[1\].pe__2724_/Q
+ g_row\[1\].g_col\[1\].pe__2689_/CIN VGND VGND VPWR VPWR g_row\[1\].g_col\[1\].pe__1761_/B2
+ g_row\[1\].g_col\[1\].pe__2689_/SUM sky130_fd_sc_hd__fa_1
XFILLER_74_638 VGND VGND VPWR VPWR sky130_fd_sc_hd__decap_3
XFILLER_27_532 VGND VGND VPWR VPWR sky130_fd_sc_hd__decap_3
XFILLER_27_543 VGND VGND VPWR VPWR sky130_fd_sc_hd__decap_3
XFILLER_55_841 VGND VGND VPWR VPWR sky130_fd_sc_hd__fill_1
Xg_row\[1\].g_col\[1\].pe_place882 g_row\[1\].g_col\[1\].pe__2348_/A VGND VGND VPWR
+ VPWR g_row\[1\].g_col\[1\].pe__1676_/A sky130_fd_sc_hd__buf_6
Xg_row\[1\].g_col\[1\].pe_place893 g_row\[1\].g_col\[1\].pe__1415_/Y VGND VGND VPWR
+ VPWR g_row\[1\].g_col\[1\].pe__1729_/A3 sky130_fd_sc_hd__buf_6
XFILLER_42_502 VGND VGND VPWR VPWR sky130_fd_sc_hd__decap_3
XFILLER_70_811 VGND VGND VPWR VPWR sky130_fd_sc_hd__fill_1
Xg_row\[0\].g_col\[1\].pe__2767_ _338_/CLK g_row\[0\].g_col\[1\].pe__2767_/D VGND
+ VGND VPWR VPWR g_row\[0\].g_col\[1\].pe__2767_/Q sky130_fd_sc_hd__dfxtp_2
XFILLER_15_738 VGND VGND VPWR VPWR sky130_fd_sc_hd__decap_3
XFILLER_42_546 VGND VGND VPWR VPWR sky130_fd_sc_hd__decap_3
X_320_ _322_/CLK _320_/D VGND VGND VPWR VPWR _320_/Q sky130_fd_sc_hd__dfxtp_2
Xg_row\[0\].g_col\[1\].pe__1718_ g_row\[0\].g_col\[1\].pe__1724_/S g_row\[0\].g_col\[1\].pe__1718_/B
+ VGND VGND VPWR VPWR g_row\[0\].g_col\[1\].pe__1743_/B sky130_fd_sc_hd__xnor2_2
Xg_row\[0\].g_col\[1\].pe__2698_ clkload11/A g_row\[0\].g_col\[1\].pe__2698_/D VGND
+ VGND VPWR VPWR g_row\[0\].g_col\[1\].pe__2698_/Q sky130_fd_sc_hd__dfxtp_2
Xg_row\[0\].g_col\[1\].pe__1649_ g_row\[0\].g_col\[1\].pe__1688_/A g_row\[0\].g_col\[1\].pe__1688_/B
+ g_row\[0\].g_col\[1\].pe__1648_/X VGND VGND VPWR VPWR g_row\[0\].g_col\[1\].pe__1660_/A
+ sky130_fd_sc_hd__a21oi_2
X_251_ _269_/A _251_/B_N VGND VGND VPWR VPWR _251_/Y sky130_fd_sc_hd__nor2b_4
XFILLER_80_79 VGND VGND VPWR VPWR sky130_fd_sc_hd__fill_1
XFILLER_6_469 VGND VGND VPWR VPWR sky130_fd_sc_hd__fill_1
XFILLER_89_281 VGND VGND VPWR VPWR sky130_fd_sc_hd__fill_1
XFILLER_37_329 VGND VGND VPWR VPWR sky130_fd_sc_hd__fill_2
XTAP_TAPCELL_ROW_88_1528 VGND VPWR sky130_fd_sc_hd__tapvpwrvgnd_1
Xg_row\[1\].g_col\[0\].pe__2260_ g_row\[1\].g_col\[0\].pe__2330_/A g_row\[1\].g_col\[0\].pe__2330_/B
+ VGND VGND VPWR VPWR g_row\[1\].g_col\[0\].pe__2262_/B sky130_fd_sc_hd__xnor2_2
Xg_row\[1\].g_col\[0\].pe__2191_ g_row\[1\].g_col\[0\].pe__2191_/A g_row\[1\].g_col\[0\].pe__2228_/B
+ VGND VGND VPWR VPWR g_row\[1\].g_col\[0\].pe__2202_/A sky130_fd_sc_hd__or2_4
Xg_row\[1\].g_col\[0\].pe_place1109 g_row\[1\].g_col\[0\].pe__2677_/B1 VGND VGND VPWR
+ VPWR g_row\[1\].g_col\[0\].pe__2687_/C1 sky130_fd_sc_hd__buf_6
XFILLER_73_682 VGND VGND VPWR VPWR sky130_fd_sc_hd__decap_3
Xg_row\[0\].g_col\[0\].pe_hold2300 g_row\[0\].g_col\[0\].pe_hold2877/X VGND VGND VPWR
+ VPWR g_row\[0\].g_col\[0\].pe_hold2878/A sky130_fd_sc_hd__clkbuf_2
Xg_row\[0\].g_col\[0\].pe_hold3034 g_row\[0\].g_col\[0\].pe__2650_/X VGND VGND VPWR
+ VPWR g_row\[0\].g_col\[0\].pe_hold3034/X sky130_fd_sc_hd__clkbuf_2
XFILLER_33_557 VGND VGND VPWR VPWR sky130_fd_sc_hd__decap_3
Xg_row\[0\].g_col\[0\].pe_hold2311 g_row\[0\].g_col\[0\].pe_hold2888/X VGND VGND VPWR
+ VPWR g_row\[0\].g_col\[0\].pe__2695_/D sky130_fd_sc_hd__clkbuf_2
Xg_row\[0\].g_col\[0\].pe_hold2322 g_row\[0\].g_col\[0\].pe__2622_/X VGND VGND VPWR
+ VPWR g_row\[0\].g_col\[0\].pe__2699_/D sky130_fd_sc_hd__clkbuf_2
Xg_row\[0\].g_col\[0\].pe_hold3056 g_row\[0\].g_col\[0\].pe__2636_/B VGND VGND VPWR
+ VPWR g_row\[0\].g_col\[0\].pe__2600_/A2 sky130_fd_sc_hd__clkbuf_2
Xg_row\[0\].g_col\[0\].pe_hold3067 g_row\[0\].g_col\[0\].pe__2619_/X VGND VGND VPWR
+ VPWR g_row\[0\].g_col\[0\].pe_hold3067/X sky130_fd_sc_hd__clkbuf_2
XFILLER_14_782 VGND VGND VPWR VPWR sky130_fd_sc_hd__decap_3
Xg_row\[0\].g_col\[0\].pe_hold2366 g_row\[0\].g_col\[0\].pe__2775_/A VGND VGND VPWR
+ VPWR g_row\[0\].g_col\[0\].pe__2513_/A1 sky130_fd_sc_hd__clkbuf_2
Xg_row\[0\].g_col\[1\].pe_place947 g_row\[0\].g_col\[1\].pe__1457_/X VGND VGND VPWR
+ VPWR g_row\[0\].g_col\[1\].pe__1715_/B sky130_fd_sc_hd__buf_6
Xg_row\[0\].g_col\[1\].pe_place936 g_row\[0\].g_col\[1\].pe_place937/A VGND VGND VPWR
+ VPWR g_row\[0\].g_col\[1\].pe__1558_/B sky130_fd_sc_hd__buf_6
XFILLER_13_281 VGND VGND VPWR VPWR sky130_fd_sc_hd__fill_1
Xg_row\[0\].g_col\[1\].pe_place969 g_row\[0\].g_col\[1\].pe__1372_/X VGND VGND VPWR
+ VPWR g_row\[0\].g_col\[1\].pe__2686_/B sky130_fd_sc_hd__buf_6
Xg_row\[0\].g_col\[1\].pe_place958 g_row\[0\].g_col\[1\].pe__1414_/X VGND VGND VPWR
+ VPWR g_row\[0\].g_col\[1\].pe__1729_/A2 sky130_fd_sc_hd__buf_6
Xg_row\[0\].g_col\[0\].pe_hold1687 g_row\[0\].g_col\[0\].pe__2063_/Y VGND VGND VPWR
+ VPWR g_row\[0\].g_col\[0\].pe__2064_/B sky130_fd_sc_hd__clkbuf_2
Xg_row\[0\].g_col\[0\].pe_hold1698 ANTENNA_145/DIODE VGND VGND VPWR VPWR g_row\[0\].g_col\[0\].pe__2116_/A
+ sky130_fd_sc_hd__clkbuf_2
Xclkload11 clkload11/A VGND VGND VPWR VPWR clkload11/X sky130_fd_sc_hd__clkbuf_8
Xg_row\[1\].g_col\[1\].pe__1991_ g_row\[1\].g_col\[1\].pe__1991_/A g_row\[1\].g_col\[1\].pe__1991_/B
+ g_row\[1\].g_col\[1\].pe__1991_/C g_row\[1\].g_col\[1\].pe__1991_/D VGND VGND VPWR
+ VPWR g_row\[1\].g_col\[1\].pe__1991_/X sky130_fd_sc_hd__and4_4
Xg_row\[1\].g_col\[0\].pe__1975_ g_row\[1\].g_col\[0\].pe__1974_/A g_row\[1\].g_col\[0\].pe__1974_/B
+ g_row\[1\].g_col\[0\].pe__1974_/C g_row\[1\].g_col\[0\].pe__1974_/D VGND VGND VPWR
+ VPWR g_row\[1\].g_col\[0\].pe__1978_/B sky130_fd_sc_hd__a22oi_2
Xoutput1402 output1402/A VGND VGND VPWR VPWR results_flat[52] sky130_fd_sc_hd__buf_2
Xoutput1413 output1413/A VGND VGND VPWR VPWR results_flat[62] sky130_fd_sc_hd__buf_2
Xhold3507 hold3507/A VGND VGND VPWR VPWR hold3507/X sky130_fd_sc_hd__clkbuf_2
Xhold3529 a_inputs_flat[25] VGND VGND VPWR VPWR hold3529/X sky130_fd_sc_hd__clkbuf_2
Xhold3518 hold3518/A VGND VGND VPWR VPWR hold3518/X sky130_fd_sc_hd__clkbuf_2
Xg_row\[1\].g_col\[1\].pe__2612_ g_row\[1\].g_col\[1\].pe__2639_/A g_row\[1\].g_col\[1\].pe__2612_/B
+ VGND VGND VPWR VPWR g_row\[1\].g_col\[1\].pe__2612_/X sky130_fd_sc_hd__or2_2
XFILLER_68_421 VGND VGND VPWR VPWR sky130_fd_sc_hd__fill_2
Xhold2806 hold3587/X VGND VGND VPWR VPWR hold3588/A sky130_fd_sc_hd__clkbuf_2
XFILLER_68_465 VGND VGND VPWR VPWR sky130_fd_sc_hd__fill_2
Xg_row\[0\].g_col\[0\].pe__1984_ g_row\[0\].g_col\[0\].pe__1424_/A g_row\[0\].g_col\[0\].pe__1424_/B
+ g_row\[0\].g_col\[0\].pe__1983_/Y VGND VGND VPWR VPWR g_row\[0\].g_col\[0\].pe__1985_/C
+ sky130_fd_sc_hd__a21o_2
Xg_row\[1\].g_col\[0\].pe__2527_ g_row\[1\].g_col\[0\].pe__2525_/Y g_row\[1\].g_col\[0\].pe__2526_/X
+ g_row\[1\].g_col\[0\].pe__2559_/A VGND VGND VPWR VPWR g_row\[1\].g_col\[0\].pe__2527_/X
+ sky130_fd_sc_hd__a21o_2
XFILLER_18_18 VGND VGND VPWR VPWR sky130_fd_sc_hd__decap_3
XFILLER_68_498 VGND VGND VPWR VPWR sky130_fd_sc_hd__fill_1
Xg_row\[1\].g_col\[1\].pe__2474_ g_row\[1\].g_col\[1\].pe__2766_/Q g_row\[1\].g_col\[1\].pe__2474_/B
+ VGND VGND VPWR VPWR g_row\[1\].g_col\[1\].pe__2474_/Y sky130_fd_sc_hd__xnor2_2
Xg_row\[1\].g_col\[0\].pe__2458_ g_row\[1\].g_col\[0\].pe__2458_/A g_row\[1\].g_col\[0\].pe__2458_/B
+ VGND VGND VPWR VPWR g_row\[1\].g_col\[0\].pe__2526_/A sky130_fd_sc_hd__nor2_2
XFILLER_37_841 VGND VGND VPWR VPWR sky130_fd_sc_hd__fill_1
Xg_row\[1\].g_col\[1\].pe_place1010 g_row\[1\].g_col\[1\].pe__2728_/Q VGND VGND VPWR
+ VPWR g_row\[1\].g_col\[1\].pe__1733_/A sky130_fd_sc_hd__buf_6
Xg_row\[1\].g_col\[1\].pe_place1021 g_row\[1\].g_col\[1\].pe__2704_/Q VGND VGND VPWR
+ VPWR g_row\[1\].g_col\[1\].pe__2163_/A sky130_fd_sc_hd__buf_6
Xg_row\[0\].g_col\[0\].pe__2605_ g_row\[0\].g_col\[0\].pe__2639_/A place1218/A VGND
+ VGND VPWR VPWR g_row\[0\].g_col\[0\].pe__2605_/X sky130_fd_sc_hd__or2_2
Xg_row\[1\].g_col\[1\].pe_place1032 g_row\[1\].g_col\[1\].pe__2698_/Q VGND VGND VPWR
+ VPWR g_row\[1\].g_col\[1\].pe__2036_/B2 sky130_fd_sc_hd__buf_6
Xg_row\[1\].g_col\[1\].pe_place1043 g_row\[1\].g_col\[1\].pe__2605_/B VGND VGND VPWR
+ VPWR g_row\[1\].g_col\[1\].pe__1901_/B2 sky130_fd_sc_hd__buf_6
Xg_row\[1\].g_col\[1\].pe_place1054 g_row\[1\].g_col\[1\].pe__2640_/C1 VGND VGND VPWR
+ VPWR g_row\[1\].g_col\[1\].pe__2679_/C1 sky130_fd_sc_hd__buf_6
Xg_row\[1\].g_col\[1\].pe__1356_ g_row\[1\].g_col\[1\].pe__2763_/Q g_row\[1\].g_col\[1\].pe__1355_/B
+ g_row\[1\].g_col\[1\].pe__2771_/Q VGND VGND VPWR VPWR g_row\[1\].g_col\[1\].pe__1357_/B
+ sky130_fd_sc_hd__o21a_2
Xg_row\[1\].g_col\[0\].pe__2389_ g_row\[1\].g_col\[0\].pe__2364_/A g_row\[1\].g_col\[0\].pe__2364_/B
+ g_row\[1\].g_col\[0\].pe__2366_/X VGND VGND VPWR VPWR g_row\[1\].g_col\[0\].pe__2390_/B
+ sky130_fd_sc_hd__o21a_2
Xg_row\[0\].g_col\[1\].pe__2621_ place1249/X g_row\[0\].g_col\[1\].pe__2621_/B VGND
+ VGND VPWR VPWR g_row\[0\].g_col\[1\].pe__2621_/X sky130_fd_sc_hd__or2_2
XFILLER_51_310 VGND VGND VPWR VPWR sky130_fd_sc_hd__decap_3
Xclkbuf_leaf_90_clk clkload1/A VGND VGND VPWR VPWR clkbuf_leaf_90_clk/X sky130_fd_sc_hd__clkbuf_16
Xg_row\[0\].g_col\[0\].pe__2536_ g_row\[0\].g_col\[0\].pe__2595_/A g_row\[0\].g_col\[0\].pe__2536_/B
+ VGND VGND VPWR VPWR g_row\[0\].g_col\[0\].pe__2759_/D sky130_fd_sc_hd__and2_2
Xg_row\[0\].g_col\[1\].pe__2552_ g_row\[0\].g_col\[1\].pe__2551_/B g_row\[0\].g_col\[1\].pe__2551_/C
+ g_row\[0\].g_col\[1\].pe__2551_/A VGND VGND VPWR VPWR g_row\[0\].g_col\[1\].pe__2552_/X
+ sky130_fd_sc_hd__a21o_2
XFILLER_24_557 VGND VGND VPWR VPWR sky130_fd_sc_hd__decap_3
Xg_row\[0\].g_col\[1\].pe__1503_ g_row\[0\].g_col\[1\].pe__2735_/Q g_row\[0\].g_col\[1\].pe__2734_/Q
+ VGND VGND VPWR VPWR g_row\[0\].g_col\[1\].pe__2341_/B sky130_fd_sc_hd__nor2_2
Xg_row\[0\].g_col\[0\].pe__2467_ g_row\[0\].g_col\[0\].pe__2446_/B g_row\[0\].g_col\[0\].pe__2761_/Q
+ VGND VGND VPWR VPWR g_row\[0\].g_col\[0\].pe__2497_/A sky130_fd_sc_hd__and2b_2
Xg_row\[0\].g_col\[1\].pe_place1119 g_row\[0\].g_col\[1\].pe__2734_/Q VGND VGND VPWR
+ VPWR g_row\[0\].g_col\[1\].pe__2368_/A sky130_fd_sc_hd__buf_6
Xg_row\[0\].g_col\[1\].pe__2483_ g_row\[0\].g_col\[1\].pe__2508_/A g_row\[0\].g_col\[1\].pe__2508_/B
+ g_row\[0\].g_col\[1\].pe__2425_/A VGND VGND VPWR VPWR g_row\[0\].g_col\[1\].pe__2509_/S
+ sky130_fd_sc_hd__a21oi_2
Xclkload5 clkload5/A VGND VGND VPWR VPWR clkload5/X sky130_fd_sc_hd__clkbuf_16
Xg_row\[0\].g_col\[0\].pe__1418_ place1207/X g_row\[0\].g_col\[0\].pe__1414_/X g_row\[0\].g_col\[0\].pe__1415_/Y
+ g_row\[0\].g_col\[0\].pe__1784_/B1 place1205/X VGND VGND VPWR VPWR g_row\[0\].g_col\[0\].pe__1419_/B
+ sky130_fd_sc_hd__a32o_2
Xg_row\[0\].g_col\[0\].pe__2398_ g_row\[0\].g_col\[0\].pe__2398_/A hold1929/X VGND
+ VGND VPWR VPWR g_row\[0\].g_col\[0\].pe__2398_/X sky130_fd_sc_hd__and2_2
XFILLER_50_49 VGND VGND VPWR VPWR sky130_fd_sc_hd__fill_2
Xg_row\[0\].g_col\[0\].pe__1349_ g_row\[0\].g_col\[0\].pe__2760_/Q g_row\[0\].g_col\[0\].pe__1349_/B
+ VGND VGND VPWR VPWR output1399/A sky130_fd_sc_hd__xnor2_2
Xg_row\[0\].g_col\[1\].pe__1365_ g_row\[0\].g_col\[1\].pe__2767_/Q g_row\[0\].g_col\[1\].pe__2766_/Q
+ g_row\[0\].g_col\[1\].pe__1361_/B ANTENNA_146/DIODE VGND VGND VPWR VPWR g_row\[0\].g_col\[1\].pe__1366_/B
+ sky130_fd_sc_hd__o31a_2
XTAP_TAPCELL_ROW_6_299 VGND VPWR sky130_fd_sc_hd__tapvpwrvgnd_1
XFILLER_27_384 VGND VGND VPWR VPWR sky130_fd_sc_hd__fill_1
XFILLER_42_332 VGND VGND VPWR VPWR sky130_fd_sc_hd__fill_1
XTAP_TAPCELL_ROW_83_1458 VGND VPWR sky130_fd_sc_hd__tapvpwrvgnd_1
Xclkbuf_leaf_81_clk clkbuf_4_8_0_clk/X VGND VGND VPWR VPWR clkbuf_leaf_81_clk/X sky130_fd_sc_hd__clkbuf_16
XFILLER_42_398 VGND VGND VPWR VPWR sky130_fd_sc_hd__fill_1
XFILLER_70_674 VGND VGND VPWR VPWR sky130_fd_sc_hd__decap_3
XTAP_TAPCELL_ROW_25_585 VGND VPWR sky130_fd_sc_hd__tapvpwrvgnd_1
X_303_ _303_/CLK _303_/D VGND VGND VPWR VPWR _303_/Q sky130_fd_sc_hd__dfxtp_2
XFILLER_11_774 VGND VGND VPWR VPWR sky130_fd_sc_hd__fill_1
X_165_ _165_/A _165_/B_N VGND VGND VPWR VPWR _165_/Y sky130_fd_sc_hd__nor2b_4
XFILLER_40_71 VGND VGND VPWR VPWR sky130_fd_sc_hd__fill_2
Xg_row\[1\].g_col\[0\].pe__1760_ g_row\[1\].g_col\[0\].pe__1816_/B g_row\[1\].g_col\[0\].pe__1760_/B
+ VGND VGND VPWR VPWR g_row\[1\].g_col\[0\].pe__1780_/A sky130_fd_sc_hd__xnor2_2
XFILLER_40_82 VGND VGND VPWR VPWR sky130_fd_sc_hd__fill_2
Xg_row\[1\].g_col\[0\].pe__1691_ g_row\[1\].g_col\[0\].pe__1721_/A g_row\[1\].g_col\[0\].pe__1721_/B
+ VGND VGND VPWR VPWR g_row\[1\].g_col\[0\].pe__1691_/Y sky130_fd_sc_hd__nor2_2
XFILLER_78_763 VGND VGND VPWR VPWR sky130_fd_sc_hd__decap_3
XFILLER_65_413 VGND VGND VPWR VPWR sky130_fd_sc_hd__fill_1
Xg_row\[1\].g_col\[0\].pe__2312_ g_row\[1\].g_col\[0\].pe__1965_/A g_row\[1\].g_col\[0\].pe__2363_/A2
+ g_row\[1\].g_col\[0\].pe__2388_/B g_row\[1\].g_col\[0\].pe__2030_/A VGND VGND VPWR
+ VPWR g_row\[1\].g_col\[0\].pe__2316_/A sky130_fd_sc_hd__a22o_2
XFILLER_19_841 VGND VGND VPWR VPWR sky130_fd_sc_hd__fill_1
Xg_row\[1\].g_col\[0\].pe__2243_ g_row\[1\].g_col\[0\].pe__2364_/A g_row\[1\].g_col\[0\].pe__2243_/B
+ VGND VGND VPWR VPWR g_row\[1\].g_col\[0\].pe__2277_/B sky130_fd_sc_hd__xnor2_2
XFILLER_18_362 VGND VGND VPWR VPWR sky130_fd_sc_hd__fill_2
XFILLER_53_608 VGND VGND VPWR VPWR sky130_fd_sc_hd__decap_3
XFILLER_46_693 VGND VGND VPWR VPWR sky130_fd_sc_hd__fill_2
Xg_row\[1\].g_col\[1\].pe__2190_ g_row\[1\].g_col\[1\].pe__2190_/A g_row\[1\].g_col\[1\].pe__2190_/B
+ VGND VGND VPWR VPWR g_row\[1\].g_col\[1\].pe__2228_/B sky130_fd_sc_hd__nor2_2
Xg_row\[1\].g_col\[0\].pe__2174_ g_row\[1\].g_col\[0\].pe__2174_/A g_row\[1\].g_col\[0\].pe__2174_/B
+ VGND VGND VPWR VPWR g_row\[1\].g_col\[0\].pe__2182_/A sky130_fd_sc_hd__nand2_2
XFILLER_33_343 VGND VGND VPWR VPWR sky130_fd_sc_hd__decap_3
XFILLER_61_652 VGND VGND VPWR VPWR sky130_fd_sc_hd__decap_3
Xclkbuf_leaf_72_clk clkload4/A VGND VGND VPWR VPWR clkbuf_leaf_72_clk/X sky130_fd_sc_hd__clkbuf_16
XANTENNA_180 ANTENNA_180/DIODE VGND VGND VPWR VPWR sky130_fd_sc_hd__diode_2
XFILLER_61_685 VGND VGND VPWR VPWR sky130_fd_sc_hd__decap_3
XTAP_TAPCELL_ROW_44_872 VGND VPWR sky130_fd_sc_hd__tapvpwrvgnd_1
Xg_row\[0\].g_col\[0\].pe__2321_ g_row\[0\].g_col\[0\].pe__2368_/A g_row\[0\].g_col\[0\].pe__2348_/B
+ VGND VGND VPWR VPWR g_row\[0\].g_col\[0\].pe__2337_/C sky130_fd_sc_hd__and2_2
Xg_row\[0\].g_col\[0\].pe__2252_ g_row\[0\].g_col\[0\].pe__2273_/A g_row\[0\].g_col\[0\].pe__2273_/B
+ VGND VGND VPWR VPWR g_row\[0\].g_col\[0\].pe__2271_/A sky130_fd_sc_hd__xnor2_2
Xg_row\[0\].g_col\[0\].pe__2183_ g_row\[0\].g_col\[0\].pe__2183_/A g_row\[0\].g_col\[0\].pe__2183_/B
+ VGND VGND VPWR VPWR g_row\[0\].g_col\[0\].pe__2203_/B sky130_fd_sc_hd__xor2_2
Xg_row\[1\].g_col\[1\].pe__1974_ g_row\[1\].g_col\[1\].pe__1974_/A g_row\[1\].g_col\[1\].pe__1974_/B
+ g_row\[1\].g_col\[1\].pe__1974_/C g_row\[1\].g_col\[1\].pe__1974_/D VGND VGND VPWR
+ VPWR g_row\[1\].g_col\[1\].pe__1978_/A sky130_fd_sc_hd__and4_4
Xg_row\[1\].g_col\[0\].pe__1958_ place1094/A g_row\[1\].g_col\[0\].pe__1549_/B g_row\[1\].g_col\[0\].pe__2074_/B1
+ g_row\[1\].g_col\[0\].pe__2612_/B VGND VGND VPWR VPWR g_row\[1\].g_col\[0\].pe__1959_/B
+ sky130_fd_sc_hd__a22o_2
XTAP_TAPCELL_ROW_54_1015 VGND VPWR sky130_fd_sc_hd__tapvpwrvgnd_1
XTAP_TAPCELL_ROW_54_1026 VGND VPWR sky130_fd_sc_hd__tapvpwrvgnd_1
Xhold3304 hold3304/A VGND VGND VPWR VPWR hold3304/X sky130_fd_sc_hd__clkbuf_2
Xhold3315 hold3315/A VGND VGND VPWR VPWR hold3315/X sky130_fd_sc_hd__clkbuf_2
Xg_row\[1\].g_col\[0\].pe__1889_ g_row\[1\].g_col\[0\].pe__1951_/A g_row\[1\].g_col\[0\].pe__1889_/B
+ VGND VGND VPWR VPWR g_row\[1\].g_col\[0\].pe__1894_/B sky130_fd_sc_hd__nor2_2
Xhold2603 hold3381/X VGND VGND VPWR VPWR _185_/B_N sky130_fd_sc_hd__clkbuf_2
Xhold3326 b_inputs_flat[0] VGND VGND VPWR VPWR hold3326/X sky130_fd_sc_hd__clkbuf_2
Xhold3337 hold3337/A VGND VGND VPWR VPWR hold3337/X sky130_fd_sc_hd__clkbuf_2
Xhold3348 hold3348/A VGND VGND VPWR VPWR hold3348/X sky130_fd_sc_hd__clkbuf_2
XFILLER_69_752 VGND VGND VPWR VPWR sky130_fd_sc_hd__decap_3
Xhold2614 hold3337/X VGND VGND VPWR VPWR hold3338/A sky130_fd_sc_hd__clkbuf_2
Xhold2625 hold3405/X VGND VGND VPWR VPWR hold3406/A sky130_fd_sc_hd__clkbuf_2
Xhold2636 hold3452/X VGND VGND VPWR VPWR hold3453/A sky130_fd_sc_hd__clkbuf_2
Xhold2647 hold2647/A VGND VGND VPWR VPWR _300_/D sky130_fd_sc_hd__clkbuf_2
Xhold3359 hold3359/A VGND VGND VPWR VPWR hold3359/X sky130_fd_sc_hd__clkbuf_2
Xg_row\[0\].g_col\[0\].pe__1967_ g_row\[0\].g_col\[0\].pe__1449_/A g_row\[0\].g_col\[0\].pe__1449_/B
+ g_row\[0\].g_col\[0\].pe__1966_/Y VGND VGND VPWR VPWR g_row\[0\].g_col\[0\].pe__1968_/C
+ sky130_fd_sc_hd__a21o_2
Xhold2658 _151_/Y VGND VGND VPWR VPWR hold2658/X sky130_fd_sc_hd__clkbuf_2
Xhold2669 hold3430/X VGND VGND VPWR VPWR _175_/B_N sky130_fd_sc_hd__clkbuf_2
Xg_row\[1\].g_col\[1\].pe__2526_ g_row\[1\].g_col\[1\].pe__2526_/A g_row\[1\].g_col\[1\].pe__2526_/B
+ VGND VGND VPWR VPWR g_row\[1\].g_col\[1\].pe__2526_/X sky130_fd_sc_hd__or2_2
Xg_row\[0\].g_col\[1\].pe__1983_ g_row\[0\].g_col\[1\].pe__2703_/Q VGND VGND VPWR
+ VPWR g_row\[0\].g_col\[1\].pe__1983_/Y sky130_fd_sc_hd__inv_2
XFILLER_84_744 VGND VGND VPWR VPWR sky130_fd_sc_hd__decap_3
XTAP_TAPCELL_ROW_3_258 VGND VPWR sky130_fd_sc_hd__tapvpwrvgnd_1
Xg_row\[1\].g_col\[1\].pe__2457_ g_row\[1\].g_col\[1\].pe__2758_/Q g_row\[1\].g_col\[1\].pe__2457_/B
+ VGND VGND VPWR VPWR g_row\[1\].g_col\[1\].pe__2458_/B sky130_fd_sc_hd__and2b_2
XFILLER_56_468 VGND VGND VPWR VPWR sky130_fd_sc_hd__decap_3
Xg_row\[0\].g_col\[0\].pe__1898_ g_row\[0\].g_col\[0\].pe__1604_/A g_row\[0\].g_col\[0\].pe__1604_/B
+ g_row\[0\].g_col\[0\].pe__1860_/B g_row\[0\].g_col\[0\].pe__1859_/B g_row\[0\].g_col\[0\].pe__1859_/A
+ VGND VGND VPWR VPWR g_row\[0\].g_col\[0\].pe__1939_/A sky130_fd_sc_hd__a32o_2
Xg_row\[1\].g_col\[1\].pe__1408_ hold1641/X g_row\[1\].g_col\[1\].pe__1408_/B VGND
+ VGND VPWR VPWR g_row\[1\].g_col\[1\].pe__1408_/Y sky130_fd_sc_hd__nor2_2
Xg_row\[1\].g_col\[1\].pe__2388_ g_row\[1\].g_col\[1\].pe__2388_/A g_row\[1\].g_col\[1\].pe__2388_/B
+ VGND VGND VPWR VPWR g_row\[1\].g_col\[1\].pe__2390_/A sky130_fd_sc_hd__nand2_2
Xg_row\[0\].g_col\[1\].pe__2604_ g_row\[0\].g_col\[1\].pe__2670_/A1 place1220/X g_row\[0\].g_col\[1\].pe__2679_/C1
+ g_row\[0\].g_col\[1\].pe__2603_/X VGND VGND VPWR VPWR g_row\[0\].g_col\[1\].pe__2604_/X
+ sky130_fd_sc_hd__o211a_2
Xclkbuf_leaf_63_clk clkload5/A VGND VGND VPWR VPWR _300_/CLK sky130_fd_sc_hd__clkbuf_16
XFILLER_24_365 VGND VGND VPWR VPWR sky130_fd_sc_hd__fill_1
XTAP_TAPCELL_ROW_65_1188 VGND VPWR sky130_fd_sc_hd__tapvpwrvgnd_1
Xg_row\[0\].g_col\[0\].pe__2519_ g_row\[0\].g_col\[0\].pe__2519_/A g_row\[0\].g_col\[0\].pe__2519_/B
+ VGND VGND VPWR VPWR g_row\[0\].g_col\[0\].pe__2519_/Y sky130_fd_sc_hd__nand2_2
Xg_row\[0\].g_col\[1\].pe__2535_ g_row\[0\].g_col\[1\].pe__2535_/A1 g_row\[0\].g_col\[1\].pe__2591_/A2
+ g_row\[0\].g_col\[1\].pe__2591_/B1 g_row\[0\].g_col\[1\].pe__2534_/X VGND VGND VPWR
+ VPWR g_row\[0\].g_col\[1\].pe__2535_/X sky130_fd_sc_hd__a22o_2
XTAP_TAPCELL_ROW_22_533 VGND VPWR sky130_fd_sc_hd__tapvpwrvgnd_1
Xg_row\[0\].g_col\[1\].pe__2466_ g_row\[0\].g_col\[1\].pe__2452_/B g_row\[0\].g_col\[1\].pe__2760_/Q
+ VGND VGND VPWR VPWR g_row\[0\].g_col\[1\].pe__2466_/X sky130_fd_sc_hd__and2b_2
XTAP_TAPCELL_ROW_22_544 VGND VPWR sky130_fd_sc_hd__tapvpwrvgnd_1
Xg_row\[0\].g_col\[1\].pe__2397_ g_row\[0\].g_col\[1\].pe__2398_/A g_row\[0\].g_col\[1\].pe__2397_/B
+ VGND VGND VPWR VPWR g_row\[0\].g_col\[1\].pe__2397_/Y sky130_fd_sc_hd__nor2_2
XFILLER_4_704 VGND VGND VPWR VPWR sky130_fd_sc_hd__decap_3
Xg_row\[0\].g_col\[1\].pe__1348_ g_row\[0\].g_col\[1\].pe__1348_/A g_row\[0\].g_col\[1\].pe__1348_/B
+ VGND VGND VPWR VPWR g_row\[0\].g_col\[1\].pe__1349_/B sky130_fd_sc_hd__nand2_2
XFILLER_4_748 VGND VGND VPWR VPWR sky130_fd_sc_hd__decap_3
XFILLER_10_85 VGND VGND VPWR VPWR sky130_fd_sc_hd__fill_1
XFILLER_79_538 VGND VGND VPWR VPWR sky130_fd_sc_hd__decap_3
XFILLER_75_711 VGND VGND VPWR VPWR sky130_fd_sc_hd__decap_3
XFILLER_19_50 VGND VGND VPWR VPWR sky130_fd_sc_hd__fill_2
XFILLER_28_693 VGND VGND VPWR VPWR sky130_fd_sc_hd__fill_1
XFILLER_15_354 VGND VGND VPWR VPWR sky130_fd_sc_hd__fill_1
Xclkbuf_leaf_54_clk clkload8/A VGND VGND VPWR VPWR clkbuf_leaf_54_clk/X sky130_fd_sc_hd__clkbuf_16
XFILLER_35_82 VGND VGND VPWR VPWR sky130_fd_sc_hd__fill_1
XFILLER_15_398 VGND VGND VPWR VPWR sky130_fd_sc_hd__decap_3
XTAP_TAPCELL_ROW_41_820 VGND VPWR sky130_fd_sc_hd__tapvpwrvgnd_1
XTAP_TAPCELL_ROW_41_831 VGND VPWR sky130_fd_sc_hd__tapvpwrvgnd_1
XFILLER_11_571 VGND VGND VPWR VPWR sky130_fd_sc_hd__fill_1
X_217_ _219_/A _217_/B_N VGND VGND VPWR VPWR _217_/Y sky130_fd_sc_hd__nor2b_4
Xg_row\[1\].g_col\[0\].pe__1812_ g_row\[1\].g_col\[0\].pe__1813_/A g_row\[1\].g_col\[0\].pe__1780_/Y
+ g_row\[1\].g_col\[0\].pe__1810_/X g_row\[1\].g_col\[0\].pe__1811_/X VGND VGND VPWR
+ VPWR g_row\[1\].g_col\[0\].pe__1812_/X sky130_fd_sc_hd__o31a_2
Xplace1208 place1208/A VGND VGND VPWR VPWR place1208/X sky130_fd_sc_hd__buf_6
Xg_row\[1\].g_col\[0\].pe__1743_ g_row\[1\].g_col\[0\].pe__1743_/A g_row\[1\].g_col\[0\].pe__1743_/B
+ VGND VGND VPWR VPWR g_row\[1\].g_col\[0\].pe__1815_/A sky130_fd_sc_hd__xnor2_2
Xg_row\[1\].g_col\[1\].pe__1690_ g_row\[1\].g_col\[1\].pe__1690_/A g_row\[1\].g_col\[1\].pe__1690_/B
+ VGND VGND VPWR VPWR g_row\[1\].g_col\[1\].pe__1722_/B sky130_fd_sc_hd__xor2_2
Xg_row\[1\].g_col\[0\].pe__1674_ g_row\[1\].g_col\[0\].pe__1690_/A g_row\[1\].g_col\[0\].pe__1690_/B
+ VGND VGND VPWR VPWR g_row\[1\].g_col\[0\].pe__1676_/B sky130_fd_sc_hd__nand2_2
XFILLER_25_3 VGND VGND VPWR VPWR sky130_fd_sc_hd__fill_1
XFILLER_85_519 VGND VGND VPWR VPWR sky130_fd_sc_hd__fill_1
Xg_row\[0\].g_col\[0\].pe__1821_ g_row\[0\].g_col\[0\].pe__1822_/C g_row\[0\].g_col\[0\].pe__1821_/B
+ g_row\[0\].g_col\[0\].pe__1821_/C g_row\[0\].g_col\[0\].pe__1821_/D VGND VGND VPWR
+ VPWR g_row\[0\].g_col\[0\].pe__1821_/X sky130_fd_sc_hd__and4_2
Xg_row\[1\].g_col\[0\].pe_hold2856 g_row\[1\].g_col\[0\].pe__2666_/X VGND VGND VPWR
+ VPWR g_row\[1\].g_col\[0\].pe_hold2856/X sky130_fd_sc_hd__clkbuf_2
Xg_row\[1\].g_col\[0\].pe_hold2834 g_row\[1\].g_col\[0\].pe__2712_/Q VGND VGND VPWR
+ VPWR g_row\[1\].g_col\[0\].pe__2653_/B sky130_fd_sc_hd__clkbuf_2
XFILLER_38_424 VGND VGND VPWR VPWR sky130_fd_sc_hd__decap_3
XFILLER_65_232 VGND VGND VPWR VPWR sky130_fd_sc_hd__fill_1
XTAP_TAPCELL_ROW_49_942 VGND VPWR sky130_fd_sc_hd__tapvpwrvgnd_1
Xg_row\[0\].g_col\[0\].pe__1752_ g_row\[0\].g_col\[0\].pe__1785_/A g_row\[0\].g_col\[0\].pe__1752_/B
+ VGND VGND VPWR VPWR g_row\[0\].g_col\[0\].pe__1756_/B sky130_fd_sc_hd__xor2_2
Xg_row\[1\].g_col\[1\].pe__2311_ g_row\[1\].g_col\[1\].pe__2311_/A g_row\[1\].g_col\[1\].pe__2311_/B
+ VGND VGND VPWR VPWR g_row\[1\].g_col\[1\].pe__2319_/A sky130_fd_sc_hd__nand2_2
XTAP_TAPCELL_ROW_0_206 VGND VPWR sky130_fd_sc_hd__tapvpwrvgnd_1
XTAP_TAPCELL_ROW_0_217 VGND VPWR sky130_fd_sc_hd__tapvpwrvgnd_1
Xg_row\[0\].g_col\[0\].pe__1683_ g_row\[0\].g_col\[0\].pe__1686_/A g_row\[0\].g_col\[0\].pe__1686_/B
+ VGND VGND VPWR VPWR g_row\[0\].g_col\[0\].pe__1713_/A sky130_fd_sc_hd__xor2_2
Xg_row\[1\].g_col\[1\].pe__2242_ g_row\[1\].g_col\[1\].pe__2340_/B2 g_row\[1\].g_col\[1\].pe__2313_/A2
+ g_row\[1\].g_col\[1\].pe__2313_/B1 g_row\[1\].g_col\[1\].pe__2030_/A VGND VGND VPWR
+ VPWR g_row\[1\].g_col\[1\].pe__2243_/B sky130_fd_sc_hd__a22o_2
Xg_row\[1\].g_col\[0\].pe__2226_ g_row\[1\].g_col\[0\].pe__2226_/A g_row\[1\].g_col\[0\].pe__2226_/B
+ VGND VGND VPWR VPWR g_row\[1\].g_col\[0\].pe__2228_/C sky130_fd_sc_hd__xor2_2
XFILLER_34_641 VGND VGND VPWR VPWR sky130_fd_sc_hd__decap_3
XFILLER_53_449 VGND VGND VPWR VPWR sky130_fd_sc_hd__decap_3
Xclkbuf_leaf_45_clk clkbuf_4_12_0_clk/X VGND VGND VPWR VPWR clkbuf_leaf_45_clk/X sky130_fd_sc_hd__clkbuf_16
Xg_row\[1\].g_col\[1\].pe__2173_ g_row\[1\].g_col\[1\].pe__2222_/A g_row\[1\].g_col\[1\].pe__2253_/A
+ VGND VGND VPWR VPWR g_row\[1\].g_col\[1\].pe__2183_/A sky130_fd_sc_hd__xnor2_2
Xg_row\[1\].g_col\[0\].pe__2157_ g_row\[1\].g_col\[0\].pe__2157_/A g_row\[1\].g_col\[0\].pe__2157_/B
+ VGND VGND VPWR VPWR g_row\[1\].g_col\[0\].pe__2157_/Y sky130_fd_sc_hd__nand2_2
XFILLER_80_268 VGND VGND VPWR VPWR sky130_fd_sc_hd__fill_2
XFILLER_33_195 VGND VGND VPWR VPWR sky130_fd_sc_hd__decap_3
Xg_row\[0\].g_col\[0\].pe__2304_ g_row\[0\].g_col\[0\].pe__2304_/A g_row\[0\].g_col\[0\].pe__2304_/B
+ g_row\[0\].g_col\[0\].pe__2304_/C VGND VGND VPWR VPWR g_row\[0\].g_col\[0\].pe__2305_/B
+ sky130_fd_sc_hd__and3_2
Xg_row\[1\].g_col\[0\].pe__2088_ g_row\[1\].g_col\[0\].pe__2087_/A g_row\[1\].g_col\[0\].pe__2087_/B
+ g_row\[1\].g_col\[0\].pe__2087_/C g_row\[1\].g_col\[0\].pe__2087_/D VGND VGND VPWR
+ VPWR g_row\[1\].g_col\[0\].pe__2091_/B sky130_fd_sc_hd__a22o_4
Xg_row\[0\].g_col\[1\].pe__2320_ g_row\[0\].g_col\[1\].pe__2368_/A g_row\[0\].g_col\[1\].pe__2348_/B
+ VGND VGND VPWR VPWR g_row\[0\].g_col\[1\].pe__2337_/B sky130_fd_sc_hd__nor2_2
Xg_row\[0\].g_col\[1\].pe__2251_ g_row\[0\].g_col\[1\].pe__2283_/A g_row\[0\].g_col\[1\].pe__2251_/B
+ VGND VGND VPWR VPWR g_row\[0\].g_col\[1\].pe__2273_/B sky130_fd_sc_hd__and2_2
Xg_row\[0\].g_col\[0\].pe__2235_ g_row\[0\].g_col\[0\].pe__2235_/A VGND VGND VPWR
+ VPWR ANTENNA_142/DIODE sky130_fd_sc_hd__inv_2
Xg_row\[0\].g_col\[0\].pe__2166_ g_row\[0\].g_col\[0\].pe__2165_/B g_row\[0\].g_col\[0\].pe__2165_/C
+ g_row\[0\].g_col\[0\].pe__2165_/A VGND VGND VPWR VPWR g_row\[0\].g_col\[0\].pe__2167_/C
+ sky130_fd_sc_hd__a21o_2
Xg_row\[0\].g_col\[1\].pe__2182_ g_row\[0\].g_col\[1\].pe__2182_/A g_row\[0\].g_col\[1\].pe__2182_/B
+ VGND VGND VPWR VPWR g_row\[0\].g_col\[1\].pe__2183_/B sky130_fd_sc_hd__xor2_2
XFILLER_1_707 VGND VGND VPWR VPWR sky130_fd_sc_hd__fill_2
XFILLER_89_814 VGND VGND VPWR VPWR sky130_fd_sc_hd__decap_3
Xg_row\[0\].g_col\[0\].pe__2097_ g_row\[0\].g_col\[0\].pe__2097_/A g_row\[0\].g_col\[0\].pe__2097_/B
+ g_row\[0\].g_col\[0\].pe__2097_/C VGND VGND VPWR VPWR g_row\[0\].g_col\[0\].pe__2184_/B
+ sky130_fd_sc_hd__or3_4
Xg_row\[1\].g_col\[1\].pe_hold1707 g_row\[1\].g_col\[1\].pe__2747_/Q VGND VGND VPWR
+ VPWR g_row\[1\].g_col\[1\].pe__2235_/A sky130_fd_sc_hd__clkbuf_2
Xg_row\[1\].g_col\[1\].pe__1957_ g_row\[1\].g_col\[1\].pe__2019_/B2 g_row\[1\].g_col\[1\].pe__2177_/A2
+ g_row\[1\].g_col\[1\].pe__2177_/B1 g_row\[1\].g_col\[1\].pe__1957_/B2 VGND VGND
+ VPWR VPWR g_row\[1\].g_col\[1\].pe__1961_/A sky130_fd_sc_hd__a22o_2
XTAP_TAPCELL_ROW_8_328 VGND VPWR sky130_fd_sc_hd__tapvpwrvgnd_1
Xg_row\[1\].g_col\[1\].pe_hold1729 g_row\[1\].g_col\[1\].pe__2116_/Y VGND VGND VPWR
+ VPWR g_row\[1\].g_col\[1\].pe__2158_/A2 sky130_fd_sc_hd__clkbuf_2
Xg_row\[1\].g_col\[1\].pe__1888_ g_row\[1\].g_col\[1\].pe__1888_/A g_row\[1\].g_col\[1\].pe__1888_/B
+ g_row\[1\].g_col\[1\].pe__1888_/C VGND VGND VPWR VPWR g_row\[1\].g_col\[1\].pe__1889_/B
+ sky130_fd_sc_hd__nor3_2
Xhold2411 hold3136/X VGND VGND VPWR VPWR _265_/B_N sky130_fd_sc_hd__clkbuf_2
Xhold2422 hold3148/X VGND VGND VPWR VPWR hold3149/A sky130_fd_sc_hd__clkbuf_2
Xhold3134 hold3134/A VGND VGND VPWR VPWR hold3134/X sky130_fd_sc_hd__clkbuf_2
Xhold3145 hold3145/A VGND VGND VPWR VPWR hold3145/X sky130_fd_sc_hd__clkbuf_2
Xhold3156 hold3156/A VGND VGND VPWR VPWR hold3156/X sky130_fd_sc_hd__clkbuf_2
Xhold3167 hold3167/A VGND VGND VPWR VPWR hold3167/X sky130_fd_sc_hd__clkbuf_2
Xhold2433 hold3167/X VGND VGND VPWR VPWR hold3168/A sky130_fd_sc_hd__clkbuf_2
Xhold2444 hold3151/X VGND VGND VPWR VPWR hold3152/A sky130_fd_sc_hd__clkbuf_2
Xhold2455 hold2455/A VGND VGND VPWR VPWR _329_/D sky130_fd_sc_hd__clkbuf_2
Xhold3178 hold3178/A VGND VGND VPWR VPWR hold3178/X sky130_fd_sc_hd__clkbuf_2
Xhold3189 hold3189/A VGND VGND VPWR VPWR hold3189/X sky130_fd_sc_hd__clkbuf_2
XFILLER_29_424 VGND VGND VPWR VPWR sky130_fd_sc_hd__fill_1
Xhold2466 _157_/Y VGND VGND VPWR VPWR hold2466/X sky130_fd_sc_hd__clkbuf_2
Xhold2477 hold3220/X VGND VGND VPWR VPWR _221_/B_N sky130_fd_sc_hd__clkbuf_2
Xhold2488 hold3197/X VGND VGND VPWR VPWR hold3198/A sky130_fd_sc_hd__clkbuf_2
Xg_row\[1\].g_col\[1\].pe__2509_ g_row\[1\].g_col\[1\].pe__2503_/B g_row\[1\].g_col\[1\].pe__2486_/B
+ g_row\[1\].g_col\[1\].pe__2509_/S VGND VGND VPWR VPWR g_row\[1\].g_col\[1\].pe__2509_/X
+ sky130_fd_sc_hd__mux2_1
Xg_row\[0\].g_col\[1\].pe__1966_ g_row\[0\].g_col\[1\].pe__2701_/Q VGND VGND VPWR
+ VPWR g_row\[0\].g_col\[1\].pe__1966_/Y sky130_fd_sc_hd__inv_2
XFILLER_44_405 VGND VGND VPWR VPWR sky130_fd_sc_hd__decap_3
Xhold2499 hold3237/X VGND VGND VPWR VPWR hold3238/A sky130_fd_sc_hd__clkbuf_2
XTAP_TAPCELL_ROW_27_614 VGND VPWR sky130_fd_sc_hd__tapvpwrvgnd_1
XTAP_TAPCELL_ROW_67_1217 VGND VPWR sky130_fd_sc_hd__tapvpwrvgnd_1
Xg_row\[0\].g_col\[1\].pe__1897_ g_row\[0\].g_col\[1\].pe__1886_/A g_row\[0\].g_col\[1\].pe__1897_/B
+ VGND VGND VPWR VPWR g_row\[0\].g_col\[1\].pe__1941_/B sky130_fd_sc_hd__nand2b_2
XFILLER_44_449 VGND VGND VPWR VPWR sky130_fd_sc_hd__fill_1
Xclkbuf_leaf_36_clk clkload6/A VGND VGND VPWR VPWR clkbuf_leaf_36_clk/X sky130_fd_sc_hd__clkbuf_16
XFILLER_13_825 VGND VGND VPWR VPWR sky130_fd_sc_hd__decap_3
XTAP_TAPCELL_ROW_80_1406 VGND VPWR sky130_fd_sc_hd__tapvpwrvgnd_1
XTAP_TAPCELL_ROW_80_1417 VGND VPWR sky130_fd_sc_hd__tapvpwrvgnd_1
Xg_row\[1\].g_col\[0\].pe_place1270 place1271/X VGND VGND VPWR VPWR g_row\[1\].g_col\[0\].pe__2514_/A
+ sky130_fd_sc_hd__buf_6
Xg_row\[0\].g_col\[1\].pe__2449_ g_row\[0\].g_col\[1\].pe__2741_/Q g_row\[0\].g_col\[1\].pe__2455_/B
+ g_row\[0\].g_col\[1\].pe__2399_/Y VGND VGND VPWR VPWR g_row\[0\].g_col\[1\].pe__2453_/B
+ sky130_fd_sc_hd__o21a_2
XANTENNA_80 hold3215/X VGND VGND VPWR VPWR sky130_fd_sc_hd__diode_2
XANTENNA_91 hold3323/X VGND VGND VPWR VPWR sky130_fd_sc_hd__diode_2
XTAP_TAPCELL_ROW_78_1379 VGND VPWR sky130_fd_sc_hd__tapvpwrvgnd_1
XTAP_TAPCELL_ROW_91_1568 VGND VPWR sky130_fd_sc_hd__tapvpwrvgnd_1
XTAP_TAPCELL_ROW_91_1579 VGND VPWR sky130_fd_sc_hd__tapvpwrvgnd_1
XTAP_TAPCELL_ROW_46_901 VGND VPWR sky130_fd_sc_hd__tapvpwrvgnd_1
XFILLER_47_276 VGND VGND VPWR VPWR sky130_fd_sc_hd__decap_3
XFILLER_47_287 VGND VGND VPWR VPWR sky130_fd_sc_hd__fill_2
XFILLER_90_500 VGND VGND VPWR VPWR sky130_fd_sc_hd__fill_1
XFILLER_35_449 VGND VGND VPWR VPWR sky130_fd_sc_hd__fill_2
Xclkbuf_leaf_27_clk clkload3/A VGND VGND VPWR VPWR _309_/CLK sky130_fd_sc_hd__clkbuf_16
Xg_row\[1\].g_col\[0\].pe__2011_ g_row\[1\].g_col\[0\].pe__2011_/A1 g_row\[1\].g_col\[0\].pe__2010_/X
+ g_row\[1\].g_col\[0\].pe__2514_/A VGND VGND VPWR VPWR g_row\[1\].g_col\[0\].pe__2011_/Y
+ sky130_fd_sc_hd__a21oi_2
XFILLER_31_633 VGND VGND VPWR VPWR sky130_fd_sc_hd__decap_3
XFILLER_8_840 VGND VGND VPWR VPWR sky130_fd_sc_hd__fill_2
XFILLER_11_390 VGND VGND VPWR VPWR sky130_fd_sc_hd__fill_2
Xg_row\[0\].g_col\[0\].pe__2020_ place1208/A g_row\[0\].g_col\[0\].pe__2279_/A2 g_row\[0\].g_col\[0\].pe__2279_/B1
+ place1210/A VGND VGND VPWR VPWR g_row\[0\].g_col\[0\].pe__2021_/B sky130_fd_sc_hd__a22o_2
XFILLER_7_383 VGND VGND VPWR VPWR sky130_fd_sc_hd__fill_1
Xg_row\[1\].g_col\[1\].pe__1811_ g_row\[1\].g_col\[1\].pe__1811_/A g_row\[1\].g_col\[1\].pe__1811_/B
+ g_row\[1\].g_col\[1\].pe__1811_/C g_row\[1\].g_col\[1\].pe__1780_/A VGND VGND VPWR
+ VPWR g_row\[1\].g_col\[1\].pe__1811_/X sky130_fd_sc_hd__or4b_4
Xg_row\[1\].g_col\[0\].pe__2775_ g_row\[1\].g_col\[0\].pe__2775_/A VGND VGND VPWR
+ VPWR output1380/A sky130_fd_sc_hd__buf_2
Xg_row\[1\].g_col\[1\].pe__1742_ g_row\[1\].g_col\[1\].pe__1719_/Y g_row\[1\].g_col\[1\].pe__1742_/B
+ VGND VGND VPWR VPWR g_row\[1\].g_col\[1\].pe__1743_/A sky130_fd_sc_hd__nand2b_2
Xg_row\[1\].g_col\[0\].pe__1726_ g_row\[1\].g_col\[0\].pe__1824_/B g_row\[1\].g_col\[0\].pe__1726_/B
+ VGND VGND VPWR VPWR g_row\[1\].g_col\[0\].pe__1747_/A sky130_fd_sc_hd__xnor2_2
Xg_row\[1\].g_col\[1\].pe__1673_ g_row\[1\].g_col\[1\].pe__1673_/A g_row\[1\].g_col\[1\].pe__1673_/B
+ VGND VGND VPWR VPWR g_row\[1\].g_col\[1\].pe__1690_/B sky130_fd_sc_hd__xnor2_2
XFILLER_86_828 VGND VGND VPWR VPWR sky130_fd_sc_hd__fill_1
Xg_row\[1\].g_col\[0\].pe__1657_ place1106/A g_row\[1\].g_col\[0\].pe__1657_/B VGND
+ VGND VPWR VPWR g_row\[1\].g_col\[0\].pe__1658_/B sky130_fd_sc_hd__nand2_2
Xg_row\[1\].g_col\[0\].pe__1588_ g_row\[1\].g_col\[0\].pe__1588_/A g_row\[1\].g_col\[0\].pe__1588_/B
+ VGND VGND VPWR VPWR g_row\[1\].g_col\[0\].pe__1588_/Y sky130_fd_sc_hd__nor2_2
Xg_row\[0\].g_col\[1\].pe__1820_ g_row\[0\].g_col\[1\].pe__1820_/A g_row\[0\].g_col\[1\].pe__1820_/B
+ VGND VGND VPWR VPWR g_row\[0\].g_col\[1\].pe__1821_/D sky130_fd_sc_hd__nor2_2
XFILLER_66_563 VGND VGND VPWR VPWR sky130_fd_sc_hd__decap_3
Xg_row\[0\].g_col\[0\].pe__1804_ g_row\[0\].g_col\[0\].pe__1804_/A g_row\[0\].g_col\[0\].pe__1804_/B
+ VGND VGND VPWR VPWR g_row\[0\].g_col\[0\].pe__1804_/X sky130_fd_sc_hd__or2_2
XFILLER_66_585 VGND VGND VPWR VPWR sky130_fd_sc_hd__decap_3
Xg_row\[0\].g_col\[0\].pe__1735_ g_row\[0\].g_col\[0\].pe__1758_/A g_row\[0\].g_col\[0\].pe__1758_/B
+ g_row\[0\].g_col\[0\].pe__1734_/X VGND VGND VPWR VPWR g_row\[0\].g_col\[0\].pe__1740_/A
+ sky130_fd_sc_hd__a21oi_2
Xg_row\[0\].g_col\[1\].pe__1751_ g_row\[0\].g_col\[1\].pe__1799_/A2 g_row\[0\].g_col\[1\].pe__1414_/X
+ g_row\[0\].g_col\[1\].pe__1415_/Y g_row\[0\].g_col\[1\].pe__1416_/X g_row\[0\].g_col\[1\].pe__1782_/A2
+ VGND VGND VPWR VPWR g_row\[0\].g_col\[1\].pe__1752_/B sky130_fd_sc_hd__a32o_2
XFILLER_93_393 VGND VGND VPWR VPWR sky130_fd_sc_hd__decap_3
XPHY_EDGE_ROW_5_Right_5 VGND VGND VPWR VPWR sky130_fd_sc_hd__decap_3
Xclkbuf_leaf_18_clk clkbuf_4_4_0_clk/X VGND VGND VPWR VPWR _289_/CLK sky130_fd_sc_hd__clkbuf_16
Xg_row\[0\].g_col\[1\].pe__1682_ g_row\[0\].g_col\[1\].pe__1707_/A g_row\[0\].g_col\[1\].pe__1682_/B
+ VGND VGND VPWR VPWR g_row\[0\].g_col\[1\].pe__1686_/B sky130_fd_sc_hd__xor2_2
Xg_row\[1\].g_col\[1\].pe__2225_ g_row\[1\].g_col\[1\].pe__2174_/A g_row\[1\].g_col\[1\].pe__2174_/B
+ g_row\[1\].g_col\[1\].pe__2182_/B g_row\[1\].g_col\[1\].pe__2181_/B g_row\[1\].g_col\[1\].pe__2181_/A
+ VGND VGND VPWR VPWR g_row\[1\].g_col\[1\].pe__2226_/B sky130_fd_sc_hd__a32o_2
XFILLER_22_600 VGND VGND VPWR VPWR sky130_fd_sc_hd__decap_3
Xg_row\[0\].g_col\[0\].pe__1666_ g_row\[0\].g_col\[0\].pe__1697_/B g_row\[0\].g_col\[0\].pe__1697_/A
+ VGND VGND VPWR VPWR g_row\[0\].g_col\[0\].pe__1666_/Y sky130_fd_sc_hd__nand2b_2
Xg_row\[1\].g_col\[0\].pe__2209_ g_row\[1\].g_col\[0\].pe__2209_/A g_row\[1\].g_col\[0\].pe__2209_/B
+ VGND VGND VPWR VPWR g_row\[1\].g_col\[0\].pe__2210_/B sky130_fd_sc_hd__xnor2_2
XTAP_TAPCELL_ROW_62_1136 VGND VPWR sky130_fd_sc_hd__tapvpwrvgnd_1
Xg_row\[0\].g_col\[0\].pe__1597_ g_row\[0\].g_col\[0\].pe__1571_/A g_row\[0\].g_col\[0\].pe__1571_/B
+ g_row\[0\].g_col\[0\].pe__1596_/X VGND VGND VPWR VPWR g_row\[0\].g_col\[0\].pe__1606_/A
+ sky130_fd_sc_hd__a21oi_2
Xg_row\[1\].g_col\[1\].pe__2156_ g_row\[1\].g_col\[1\].pe__2155_/B g_row\[1\].g_col\[1\].pe__2300_/A
+ g_row\[1\].g_col\[1\].pe__2200_/A VGND VGND VPWR VPWR g_row\[1\].g_col\[1\].pe__2157_/B
+ sky130_fd_sc_hd__a21o_2
XFILLER_21_143 VGND VGND VPWR VPWR sky130_fd_sc_hd__decap_3
XFILLER_22_666 VGND VGND VPWR VPWR sky130_fd_sc_hd__decap_3
XTAP_TAPCELL_ROW_62_1147 VGND VPWR sky130_fd_sc_hd__tapvpwrvgnd_1
Xg_row\[1\].g_col\[1\].pe__2087_ g_row\[1\].g_col\[1\].pe__2087_/A g_row\[1\].g_col\[1\].pe__2087_/B
+ g_row\[1\].g_col\[1\].pe__2087_/C g_row\[1\].g_col\[1\].pe__2087_/D VGND VGND VPWR
+ VPWR g_row\[1\].g_col\[1\].pe__2091_/A sky130_fd_sc_hd__nand4_2
Xg_row\[0\].g_col\[1\].pe__2303_ g_row\[0\].g_col\[1\].pe__2233_/C g_row\[0\].g_col\[1\].pe__2299_/B
+ g_row\[0\].g_col\[1\].pe__2302_/Y VGND VGND VPWR VPWR g_row\[0\].g_col\[1\].pe__2304_/C
+ sky130_fd_sc_hd__o21a_2
XFILLER_22_699 VGND VGND VPWR VPWR sky130_fd_sc_hd__fill_1
XTAP_TAPCELL_ROW_32_683 VGND VPWR sky130_fd_sc_hd__tapvpwrvgnd_1
XTAP_TAPCELL_ROW_32_694 VGND VPWR sky130_fd_sc_hd__tapvpwrvgnd_1
Xg_row\[0\].g_col\[0\].pe__2218_ g_row\[0\].g_col\[0\].pe__2239_/A g_row\[0\].g_col\[0\].pe__2239_/B
+ VGND VGND VPWR VPWR g_row\[0\].g_col\[0\].pe__2219_/B sky130_fd_sc_hd__xor2_2
Xg_row\[0\].g_col\[1\].pe__2234_ g_row\[0\].g_col\[1\].pe__2233_/A g_row\[0\].g_col\[1\].pe__2233_/C
+ g_row\[0\].g_col\[1\].pe__2298_/A VGND VGND VPWR VPWR g_row\[0\].g_col\[1\].pe__2234_/Y
+ sky130_fd_sc_hd__a21oi_2
Xg_row\[0\].g_col\[1\].pe__2165_ g_row\[0\].g_col\[1\].pe__2165_/A g_row\[0\].g_col\[1\].pe__2165_/B
+ g_row\[0\].g_col\[1\].pe__2165_/C VGND VGND VPWR VPWR g_row\[0\].g_col\[1\].pe__2167_/B
+ sky130_fd_sc_hd__nand3_2
Xg_row\[0\].g_col\[0\].pe__2149_ g_row\[0\].g_col\[0\].pe__2161_/A g_row\[0\].g_col\[0\].pe__2161_/B
+ VGND VGND VPWR VPWR g_row\[0\].g_col\[0\].pe__2200_/A sky130_fd_sc_hd__xnor2_2
Xg_row\[0\].g_col\[1\].pe__2096_ g_row\[0\].g_col\[1\].pe__2097_/B g_row\[0\].g_col\[1\].pe__2097_/C
+ g_row\[0\].g_col\[1\].pe__2097_/A VGND VGND VPWR VPWR g_row\[0\].g_col\[1\].pe__2099_/A
+ sky130_fd_sc_hd__o21ai_2
XTAP_TAPCELL_ROW_73_1298 VGND VPWR sky130_fd_sc_hd__tapvpwrvgnd_1
XFILLER_29_243 VGND VGND VPWR VPWR sky130_fd_sc_hd__decap_3
Xhold1540 hold3453/X VGND VGND VPWR VPWR hold3454/A sky130_fd_sc_hd__clkbuf_2
Xhold1551 hold2694/X VGND VGND VPWR VPWR hold2695/A sky130_fd_sc_hd__clkbuf_2
Xhold1562 hold3464/X VGND VGND VPWR VPWR hold3465/A sky130_fd_sc_hd__clkbuf_2
Xhold1573 hold3439/X VGND VGND VPWR VPWR hold3440/A sky130_fd_sc_hd__clkbuf_2
Xhold1584 hold2724/X VGND VGND VPWR VPWR hold2725/A sky130_fd_sc_hd__clkbuf_2
Xhold1595 hold3506/X VGND VGND VPWR VPWR hold3507/A sky130_fd_sc_hd__clkbuf_2
XFILLER_72_544 VGND VGND VPWR VPWR sky130_fd_sc_hd__decap_3
XFILLER_83_57 VGND VGND VPWR VPWR sky130_fd_sc_hd__fill_1
Xg_row\[1\].g_col\[0\].pe_place923 g_row\[1\].g_col\[0\].pe__1416_/X VGND VGND VPWR
+ VPWR g_row\[1\].g_col\[0\].pe__1801_/B sky130_fd_sc_hd__buf_6
Xg_row\[1\].g_col\[0\].pe_place912 g_row\[1\].g_col\[0\].pe__2075_/A VGND VGND VPWR
+ VPWR g_row\[1\].g_col\[0\].pe__2021_/A sky130_fd_sc_hd__buf_6
XFILLER_72_566 VGND VGND VPWR VPWR sky130_fd_sc_hd__decap_3
Xg_row\[1\].g_col\[0\].pe_place934 g_row\[1\].g_col\[0\].pe__2686_/B VGND VGND VPWR
+ VPWR g_row\[1\].g_col\[0\].pe__2679_/A2 sky130_fd_sc_hd__buf_6
XFILLER_25_493 VGND VGND VPWR VPWR sky130_fd_sc_hd__decap_3
XFILLER_13_655 VGND VGND VPWR VPWR sky130_fd_sc_hd__fill_2
XFILLER_8_103 VGND VGND VPWR VPWR sky130_fd_sc_hd__fill_2
XFILLER_13_688 VGND VGND VPWR VPWR sky130_fd_sc_hd__decap_3
XTAP_TAPCELL_ROW_51_970 VGND VPWR sky130_fd_sc_hd__tapvpwrvgnd_1
XTAP_TAPCELL_ROW_51_981 VGND VPWR sky130_fd_sc_hd__tapvpwrvgnd_1
XTAP_TAPCELL_ROW_10_355 VGND VPWR sky130_fd_sc_hd__tapvpwrvgnd_1
XTAP_TAPCELL_ROW_10_366 VGND VPWR sky130_fd_sc_hd__tapvpwrvgnd_1
XTAP_TAPCELL_ROW_93_1608 VGND VPWR sky130_fd_sc_hd__tapvpwrvgnd_1
XTAP_TAPCELL_ROW_93_1619 VGND VPWR sky130_fd_sc_hd__tapvpwrvgnd_1
Xg_row\[0\].g_col\[0\].pe_place1176 g_row\[0\].g_col\[0\].pe__2368_/A VGND VGND VPWR
+ VPWR g_row\[0\].g_col\[0\].pe__2345_/A sky130_fd_sc_hd__buf_6
Xg_row\[0\].g_col\[0\].pe_place1187 g_row\[0\].g_col\[0\].pe__1785_/A VGND VGND VPWR
+ VPWR g_row\[0\].g_col\[0\].pe__2686_/A sky130_fd_sc_hd__buf_6
Xg_row\[1\].g_col\[0\].pe__2560_ g_row\[1\].g_col\[0\].pe__2560_/A1 g_row\[1\].g_col\[0\].pe__2560_/A2
+ g_row\[1\].g_col\[0\].pe__2560_/B1 g_row\[1\].g_col\[0\].pe__2559_/X VGND VGND VPWR
+ VPWR g_row\[1\].g_col\[0\].pe__2560_/X sky130_fd_sc_hd__a22o_2
XFILLER_79_132 VGND VGND VPWR VPWR sky130_fd_sc_hd__decap_3
Xg_row\[1\].g_col\[0\].pe__1511_ g_row\[1\].g_col\[0\].pe__1640_/A g_row\[1\].g_col\[0\].pe__1640_/B
+ g_row\[1\].g_col\[0\].pe__1510_/X VGND VGND VPWR VPWR g_row\[1\].g_col\[0\].pe__1550_/A
+ sky130_fd_sc_hd__a21oi_2
XFILLER_68_839 VGND VGND VPWR VPWR sky130_fd_sc_hd__decap_3
Xg_row\[1\].g_col\[0\].pe__2491_ g_row\[1\].g_col\[0\].pe__2491_/A g_row\[1\].g_col\[0\].pe__2491_/B
+ g_row\[1\].g_col\[0\].pe__2505_/A VGND VGND VPWR VPWR g_row\[1\].g_col\[0\].pe__2492_/B
+ sky130_fd_sc_hd__or3_2
XFILLER_79_187 VGND VGND VPWR VPWR sky130_fd_sc_hd__fill_2
Xg_row\[1\].g_col\[0\].pe__1442_ g_row\[1\].g_col\[0\].pe__1442_/A g_row\[1\].g_col\[0\].pe__1442_/B
+ VGND VGND VPWR VPWR g_row\[1\].g_col\[0\].pe__1479_/B sky130_fd_sc_hd__xnor2_2
XFILLER_48_530 VGND VGND VPWR VPWR sky130_fd_sc_hd__fill_2
XFILLER_48_552 VGND VGND VPWR VPWR sky130_fd_sc_hd__decap_3
XFILLER_63_511 VGND VGND VPWR VPWR sky130_fd_sc_hd__fill_2
XFILLER_63_522 VGND VGND VPWR VPWR sky130_fd_sc_hd__decap_3
XFILLER_75_393 VGND VGND VPWR VPWR sky130_fd_sc_hd__decap_3
Xg_row\[0\].g_col\[0\].pe__1520_ g_row\[0\].g_col\[0\].pe__1580_/A g_row\[0\].g_col\[0\].pe__1580_/B
+ VGND VGND VPWR VPWR g_row\[0\].g_col\[0\].pe__1523_/A sky130_fd_sc_hd__xor2_2
XFILLER_63_577 VGND VGND VPWR VPWR sky130_fd_sc_hd__decap_3
XTAP_TAPCELL_ROW_18_477 VGND VPWR sky130_fd_sc_hd__tapvpwrvgnd_1
Xg_row\[1\].g_col\[1\].pe__2010_ g_row\[1\].g_col\[1\].pe__2010_/A g_row\[1\].g_col\[1\].pe__2010_/B
+ g_row\[1\].g_col\[1\].pe__2062_/A g_row\[1\].g_col\[1\].pe__2010_/D VGND VGND VPWR
+ VPWR g_row\[1\].g_col\[1\].pe__2010_/X sky130_fd_sc_hd__or4_4
XFILLER_50_238 VGND VGND VPWR VPWR sky130_fd_sc_hd__decap_3
Xg_row\[0\].g_col\[0\].pe__1451_ g_row\[0\].g_col\[0\].pe__1866_/B2 g_row\[0\].g_col\[0\].pe__1748_/B
+ g_row\[0\].g_col\[0\].pe__1738_/B1 place1213/X VGND VGND VPWR VPWR g_row\[0\].g_col\[0\].pe__1452_/B
+ sky130_fd_sc_hd__a22o_2
XFILLER_31_441 VGND VGND VPWR VPWR sky130_fd_sc_hd__decap_3
Xg_row\[0\].g_col\[0\].pe__2003_ g_row\[0\].g_col\[0\].pe__2013_/A g_row\[0\].g_col\[0\].pe__2013_/B
+ VGND VGND VPWR VPWR g_row\[0\].g_col\[0\].pe__2005_/B sky130_fd_sc_hd__xor2_2
Xclkbuf_leaf_7_clk clkload0/A VGND VGND VPWR VPWR clkbuf_leaf_7_clk/X sky130_fd_sc_hd__clkbuf_16
Xg_row\[1\].g_col\[1\].pe__2774_ g_row\[1\].g_col\[1\].pe__2774_/A VGND VGND VPWR
+ VPWR g_row\[1\].g_col\[1\].pe__2774_/X sky130_fd_sc_hd__buf_2
Xg_row\[1\].g_col\[1\].pe__1725_ g_row\[1\].g_col\[1\].pe__1723_/A g_row\[1\].g_col\[1\].pe__1723_/B
+ g_row\[1\].g_col\[1\].pe__1745_/B g_row\[1\].g_col\[1\].pe__1745_/A VGND VGND VPWR
+ VPWR g_row\[1\].g_col\[1\].pe__1726_/B sky130_fd_sc_hd__a22oi_2
Xg_row\[1\].g_col\[0\].pe__2758_ clkbuf_leaf_58_clk/X g_row\[1\].g_col\[0\].pe__2758_/D
+ VGND VGND VPWR VPWR g_row\[1\].g_col\[0\].pe__2758_/Q sky130_fd_sc_hd__dfxtp_2
Xg_row\[1\].g_col\[0\].pe__2689_ g_row\[1\].g_col\[0\].pe__2689_/A g_row\[1\].g_col\[0\].pe__2724_/Q
+ g_row\[1\].g_col\[0\].pe__2689_/CIN VGND VGND VPWR VPWR g_row\[1\].g_col\[0\].pe_place841/A
+ g_row\[1\].g_col\[0\].pe__2689_/SUM sky130_fd_sc_hd__fa_1
Xg_row\[1\].g_col\[0\].pe__1709_ g_row\[1\].g_col\[0\].pe__1709_/A g_row\[1\].g_col\[0\].pe__1709_/B
+ VGND VGND VPWR VPWR g_row\[1\].g_col\[0\].pe__1736_/A sky130_fd_sc_hd__xor2_2
XFILLER_85_113 VGND VGND VPWR VPWR sky130_fd_sc_hd__decap_3
Xg_row\[1\].g_col\[1\].pe__1656_ g_row\[1\].g_col\[1\].pe__1656_/A g_row\[1\].g_col\[1\].pe__1656_/B
+ VGND VGND VPWR VPWR g_row\[1\].g_col\[1\].pe__1659_/A sky130_fd_sc_hd__xor2_2
Xg_row\[1\].g_col\[1\].pe__1587_ g_row\[1\].g_col\[1\].pe__1587_/A g_row\[1\].g_col\[1\].pe__1587_/B
+ VGND VGND VPWR VPWR g_row\[1\].g_col\[1\].pe__1594_/A sky130_fd_sc_hd__xor2_2
XFILLER_54_511 VGND VGND VPWR VPWR sky130_fd_sc_hd__decap_3
Xg_row\[1\].g_col\[0\].pe_hold1771 g_row\[1\].g_col\[0\].pe_hold2925/X VGND VGND VPWR
+ VPWR g_row\[1\].g_col\[0\].pe_hold2926/A sky130_fd_sc_hd__clkbuf_2
Xg_row\[1\].g_col\[0\].pe_hold1760 g_row\[1\].g_col\[0\].pe__2568_/X VGND VGND VPWR
+ VPWR g_row\[1\].g_col\[0\].pe__2569_/B sky130_fd_sc_hd__clkbuf_2
Xg_row\[0\].g_col\[1\].pe__1803_ g_row\[0\].g_col\[1\].pe__1807_/A g_row\[0\].g_col\[1\].pe__1807_/B
+ VGND VGND VPWR VPWR g_row\[0\].g_col\[1\].pe__1803_/Y sky130_fd_sc_hd__nor2_2
XFILLER_26_224 VGND VGND VPWR VPWR sky130_fd_sc_hd__decap_3
Xg_row\[0\].g_col\[0\].pe__2767_ clkbuf_leaf_52_clk/X g_row\[0\].g_col\[0\].pe__2767_/D
+ VGND VGND VPWR VPWR g_row\[0\].g_col\[0\].pe__2767_/Q sky130_fd_sc_hd__dfxtp_2
Xg_row\[0\].g_col\[1\].pe__1734_ g_row\[0\].g_col\[1\].pe__1734_/A g_row\[0\].g_col\[1\].pe__1734_/B
+ VGND VGND VPWR VPWR g_row\[0\].g_col\[1\].pe__1734_/X sky130_fd_sc_hd__and2_2
XFILLER_42_706 VGND VGND VPWR VPWR sky130_fd_sc_hd__fill_1
XTAP_TAPCELL_ROW_37_764 VGND VPWR sky130_fd_sc_hd__tapvpwrvgnd_1
Xg_row\[0\].g_col\[0\].pe__1718_ g_row\[0\].g_col\[0\].pe__1724_/S g_row\[0\].g_col\[0\].pe__1718_/B
+ VGND VGND VPWR VPWR g_row\[0\].g_col\[0\].pe__1743_/B sky130_fd_sc_hd__xnor2_2
Xg_row\[0\].g_col\[0\].pe__2698_ clkbuf_leaf_22_clk/X g_row\[0\].g_col\[0\].pe__2698_/D
+ VGND VGND VPWR VPWR place1205/A sky130_fd_sc_hd__dfxtp_2
Xg_row\[0\].g_col\[0\].pe__1649_ g_row\[0\].g_col\[0\].pe__1688_/A g_row\[0\].g_col\[0\].pe__1688_/B
+ g_row\[0\].g_col\[0\].pe__1648_/X VGND VGND VPWR VPWR g_row\[0\].g_col\[0\].pe__1660_/A
+ sky130_fd_sc_hd__a21oi_2
Xg_row\[0\].g_col\[1\].pe__1665_ g_row\[0\].g_col\[1\].pe__1656_/A g_row\[0\].g_col\[1\].pe__1656_/B
+ g_row\[0\].g_col\[1\].pe__1664_/X VGND VGND VPWR VPWR g_row\[0\].g_col\[1\].pe__1697_/A
+ sky130_fd_sc_hd__a21bo_2
Xg_row\[1\].g_col\[1\].pe__2208_ g_row\[1\].g_col\[1\].pe__2121_/A g_row\[1\].g_col\[1\].pe__1657_/B
+ g_row\[1\].g_col\[1\].pe__2247_/B1 g_row\[1\].g_col\[1\].pe__2340_/B2 VGND VGND
+ VPWR VPWR g_row\[1\].g_col\[1\].pe__2209_/B sky130_fd_sc_hd__a22o_2
XFILLER_22_452 VGND VGND VPWR VPWR sky130_fd_sc_hd__fill_1
Xg_row\[0\].g_col\[1\].pe__1596_ g_row\[0\].g_col\[1\].pe__1596_/A g_row\[0\].g_col\[1\].pe__1596_/B
+ VGND VGND VPWR VPWR g_row\[0\].g_col\[1\].pe__1596_/X sky130_fd_sc_hd__and2_2
Xg_row\[1\].g_col\[1\].pe__2139_ g_row\[1\].g_col\[1\].pe__2241_/B2 g_row\[1\].g_col\[1\].pe__2313_/A2
+ g_row\[1\].g_col\[1\].pe__2313_/B1 g_row\[1\].g_col\[1\].pe__2215_/B2 VGND VGND
+ VPWR VPWR g_row\[1\].g_col\[1\].pe__2140_/B sky130_fd_sc_hd__a22o_2
XFILLER_22_474 VGND VGND VPWR VPWR sky130_fd_sc_hd__fill_2
XFILLER_10_669 VGND VGND VPWR VPWR sky130_fd_sc_hd__decap_3
Xg_row\[0\].g_col\[1\].pe__2217_ g_row\[0\].g_col\[1\].pe__2364_/A g_row\[0\].g_col\[1\].pe__2217_/B
+ VGND VGND VPWR VPWR g_row\[0\].g_col\[1\].pe__2239_/B sky130_fd_sc_hd__xnor2_2
XFILLER_2_813 VGND VGND VPWR VPWR sky130_fd_sc_hd__fill_2
XTAP_TAPCELL_ROW_75_1338 VGND VPWR sky130_fd_sc_hd__tapvpwrvgnd_1
Xg_row\[0\].g_col\[1\].pe__2148_ g_row\[0\].g_col\[1\].pe__2148_/A g_row\[0\].g_col\[1\].pe__2162_/B
+ VGND VGND VPWR VPWR g_row\[0\].g_col\[1\].pe__2161_/B sky130_fd_sc_hd__xnor2_2
Xg_row\[0\].g_col\[1\].pe__2079_ g_row\[0\].g_col\[1\].pe__2163_/A g_row\[0\].g_col\[1\].pe__2079_/B
+ VGND VGND VPWR VPWR g_row\[0\].g_col\[1\].pe__2081_/B sky130_fd_sc_hd__nand2_2
XFILLER_49_305 VGND VGND VPWR VPWR sky130_fd_sc_hd__decap_3
XFILLER_77_636 VGND VGND VPWR VPWR sky130_fd_sc_hd__decap_3
XFILLER_76_135 VGND VGND VPWR VPWR sky130_fd_sc_hd__fill_1
XFILLER_77_658 VGND VGND VPWR VPWR sky130_fd_sc_hd__fill_2
XFILLER_73_820 VGND VGND VPWR VPWR sky130_fd_sc_hd__fill_2
XFILLER_91_127 VGND VGND VPWR VPWR sky130_fd_sc_hd__fill_1
Xhold2082 hold2082/A VGND VGND VPWR VPWR hold2082/X sky130_fd_sc_hd__clkbuf_2
XFILLER_57_393 VGND VGND VPWR VPWR sky130_fd_sc_hd__fill_2
XFILLER_33_717 VGND VGND VPWR VPWR sky130_fd_sc_hd__decap_3
XFILLER_60_503 VGND VGND VPWR VPWR sky130_fd_sc_hd__fill_1
XFILLER_45_599 VGND VGND VPWR VPWR sky130_fd_sc_hd__fill_2
XFILLER_60_525 VGND VGND VPWR VPWR sky130_fd_sc_hd__decap_3
XFILLER_60_569 VGND VGND VPWR VPWR sky130_fd_sc_hd__fill_2
XTAP_TAPCELL_ROW_15_436 VGND VPWR sky130_fd_sc_hd__tapvpwrvgnd_1
Xg_row\[0\].g_col\[0\].pe_hold1803 g_row\[0\].g_col\[0\].pe__1397_/X VGND VGND VPWR
+ VPWR g_row\[0\].g_col\[0\].pe__2734_/D sky130_fd_sc_hd__clkbuf_2
Xg_row\[0\].g_col\[0\].pe_hold1836 g_row\[0\].g_col\[0\].pe__1950_/Y VGND VGND VPWR
+ VPWR g_row\[0\].g_col\[0\].pe__2011_/A1 sky130_fd_sc_hd__clkbuf_2
Xg_row\[1\].g_col\[0\].pe__1991_ g_row\[1\].g_col\[0\].pe__1991_/A g_row\[1\].g_col\[0\].pe__1991_/B
+ g_row\[1\].g_col\[0\].pe__1991_/C g_row\[1\].g_col\[0\].pe__1991_/D VGND VGND VPWR
+ VPWR g_row\[1\].g_col\[0\].pe__1991_/X sky130_fd_sc_hd__and4_4
Xinput1291 hold3147/X VGND VGND VPWR VPWR hold3148/A sky130_fd_sc_hd__buf_2
Xg_row\[1\].g_col\[0\].pe__2612_ g_row\[1\].g_col\[0\].pe__2639_/A g_row\[1\].g_col\[0\].pe__2612_/B
+ VGND VGND VPWR VPWR g_row\[1\].g_col\[0\].pe__2612_/X sky130_fd_sc_hd__or2_2
Xg_row\[1\].g_col\[1\].pe__2490_ g_row\[1\].g_col\[1\].pe__2490_/A g_row\[1\].g_col\[1\].pe__2490_/B
+ VGND VGND VPWR VPWR g_row\[1\].g_col\[1\].pe__2571_/A sky130_fd_sc_hd__nor2_2
Xg_row\[1\].g_col\[1\].pe__1510_ g_row\[1\].g_col\[1\].pe__1501_/A g_row\[1\].g_col\[1\].pe__1510_/B
+ VGND VGND VPWR VPWR g_row\[1\].g_col\[1\].pe__1510_/X sky130_fd_sc_hd__and2b_2
Xg_row\[1\].g_col\[0\].pe__2474_ g_row\[1\].g_col\[0\].pe__2766_/Q g_row\[1\].g_col\[0\].pe__2474_/B
+ VGND VGND VPWR VPWR g_row\[1\].g_col\[0\].pe__2474_/Y sky130_fd_sc_hd__xnor2_2
Xg_row\[1\].g_col\[1\].pe__1441_ g_row\[1\].g_col\[1\].pe__1733_/A g_row\[1\].g_col\[1\].pe__1441_/B
+ VGND VGND VPWR VPWR g_row\[1\].g_col\[1\].pe__1442_/B sky130_fd_sc_hd__xor2_2
XFILLER_67_179 VGND VGND VPWR VPWR sky130_fd_sc_hd__fill_1
XFILLER_83_617 VGND VGND VPWR VPWR sky130_fd_sc_hd__fill_2
Xg_row\[0\].g_col\[0\].pe__2621_ g_row\[0\].g_col\[0\].pe__2623_/A hold2339/X VGND
+ VGND VPWR VPWR g_row\[0\].g_col\[0\].pe__2621_/X sky130_fd_sc_hd__or2_2
Xg_row\[1\].g_col\[1\].pe__1372_ g_row\[1\].g_col\[1\].pe__2676_/A _276_/Q VGND VGND
+ VPWR VPWR g_row\[1\].g_col\[1\].pe__2682_/B sky130_fd_sc_hd__and2_2
Xg_row\[1\].g_col\[0\].pe__1356_ g_row\[1\].g_col\[0\].pe__2763_/Q g_row\[1\].g_col\[0\].pe__1355_/B
+ g_row\[1\].g_col\[0\].pe__2771_/Q VGND VGND VPWR VPWR g_row\[1\].g_col\[0\].pe__1357_/B
+ sky130_fd_sc_hd__o21a_2
Xg_row\[0\].g_col\[0\].pe__2552_ g_row\[0\].g_col\[0\].pe__2551_/B g_row\[0\].g_col\[0\].pe__2551_/C
+ g_row\[0\].g_col\[0\].pe__2551_/A VGND VGND VPWR VPWR g_row\[0\].g_col\[0\].pe__2552_/X
+ sky130_fd_sc_hd__a21o_2
XFILLER_36_599 VGND VGND VPWR VPWR sky130_fd_sc_hd__decap_3
XFILLER_63_374 VGND VGND VPWR VPWR sky130_fd_sc_hd__fill_1
XTAP_TAPCELL_ROW_34_723 VGND VPWR sky130_fd_sc_hd__tapvpwrvgnd_1
Xg_row\[0\].g_col\[0\].pe__1503_ g_row\[0\].g_col\[0\].pe__2735_/Q g_row\[0\].g_col\[0\].pe__2734_/Q
+ VGND VGND VPWR VPWR g_row\[0\].g_col\[0\].pe__2341_/B sky130_fd_sc_hd__nor2_2
Xg_row\[0\].g_col\[0\].pe__2483_ g_row\[0\].g_col\[0\].pe__2508_/A g_row\[0\].g_col\[0\].pe__2508_/B
+ g_row\[0\].g_col\[0\].pe__2425_/A VGND VGND VPWR VPWR g_row\[0\].g_col\[0\].pe__2509_/S
+ sky130_fd_sc_hd__a21oi_2
XFILLER_51_558 VGND VGND VPWR VPWR sky130_fd_sc_hd__fill_2
Xg_row\[0\].g_col\[0\].pe__1365_ g_row\[0\].g_col\[0\].pe__2767_/Q g_row\[0\].g_col\[0\].pe__2766_/Q
+ g_row\[0\].g_col\[0\].pe__1361_/B g_row\[0\].g_col\[0\].pe__2776_/A VGND VGND VPWR
+ VPWR g_row\[0\].g_col\[0\].pe__1366_/B sky130_fd_sc_hd__o31a_2
Xg_row\[0\].g_col\[1\].pe__2002_ g_row\[0\].g_col\[1\].pe__2002_/A g_row\[0\].g_col\[1\].pe__2002_/B
+ VGND VGND VPWR VPWR g_row\[0\].g_col\[1\].pe__2013_/B sky130_fd_sc_hd__xnor2_2
XTAP_TAPCELL_ROW_57_1068 VGND VPWR sky130_fd_sc_hd__tapvpwrvgnd_1
Xg_row\[1\].g_col\[1\].pe__2757_ clkbuf_leaf_74_clk/X g_row\[1\].g_col\[1\].pe__2757_/D
+ VGND VGND VPWR VPWR g_row\[1\].g_col\[1\].pe__2757_/Q sky130_fd_sc_hd__dfxtp_2
XTAP_TAPCELL_ROW_70_1257 VGND VPWR sky130_fd_sc_hd__tapvpwrvgnd_1
Xg_row\[1\].g_col\[1\].pe__2688_ g_row\[1\].g_col\[1\].pe__2736_/Q g_row\[1\].g_col\[1\].pe__2737_/Q
+ g_row\[1\].g_col\[1\].pe__2688_/CIN VGND VGND VPWR VPWR g_row\[1\].g_col\[1\].pe__2177_/B1
+ g_row\[1\].g_col\[1\].pe__1558_/B sky130_fd_sc_hd__fa_1
Xg_row\[1\].g_col\[1\].pe__1708_ g_row\[1\].g_col\[1\].pe__1709_/A g_row\[1\].g_col\[1\].pe__1709_/B
+ VGND VGND VPWR VPWR g_row\[1\].g_col\[1\].pe__1714_/A sky130_fd_sc_hd__nand2_2
Xg_row\[1\].g_col\[1\].pe__1639_ g_row\[1\].g_col\[1\].pe__1840_/A g_row\[1\].g_col\[1\].pe__1840_/B
+ VGND VGND VPWR VPWR g_row\[1\].g_col\[1\].pe__1834_/A sky130_fd_sc_hd__xnor2_2
XFILLER_74_628 VGND VGND VPWR VPWR sky130_fd_sc_hd__decap_3
XFILLER_39_393 VGND VGND VPWR VPWR sky130_fd_sc_hd__decap_3
XFILLER_64_15 VGND VGND VPWR VPWR sky130_fd_sc_hd__fill_1
Xg_row\[1\].g_col\[1\].pe_place883 g_row\[1\].g_col\[1\].pe__2348_/A VGND VGND VPWR
+ VPWR g_row\[1\].g_col\[1\].pe__2209_/A sky130_fd_sc_hd__buf_6
Xg_row\[1\].g_col\[1\].pe_place894 g_row\[1\].g_col\[1\].pe__1414_/X VGND VGND VPWR
+ VPWR g_row\[1\].g_col\[1\].pe__1729_/A2 sky130_fd_sc_hd__buf_6
XFILLER_15_706 VGND VGND VPWR VPWR sky130_fd_sc_hd__decap_3
XFILLER_27_577 VGND VGND VPWR VPWR sky130_fd_sc_hd__decap_3
XFILLER_82_650 VGND VGND VPWR VPWR sky130_fd_sc_hd__fill_2
Xg_row\[0\].g_col\[1\].pe__2766_ _338_/CLK g_row\[0\].g_col\[1\].pe__2766_/D VGND
+ VGND VPWR VPWR g_row\[0\].g_col\[1\].pe__2766_/Q sky130_fd_sc_hd__dfxtp_2
Xg_row\[0\].g_col\[1\].pe__1717_ g_row\[0\].g_col\[1\].pe__1816_/A g_row\[0\].g_col\[1\].pe__1717_/B
+ VGND VGND VPWR VPWR g_row\[0\].g_col\[1\].pe__1718_/B sky130_fd_sc_hd__xor2_2
Xg_row\[0\].g_col\[1\].pe__2697_ _276_/CLK g_row\[0\].g_col\[1\].pe__2697_/D VGND
+ VGND VPWR VPWR g_row\[0\].g_col\[1\].pe__2697_/Q sky130_fd_sc_hd__dfxtp_2
XFILLER_14_249 VGND VGND VPWR VPWR sky130_fd_sc_hd__decap_3
Xg_row\[0\].g_col\[1\].pe__1648_ g_row\[0\].g_col\[1\].pe__1648_/A g_row\[0\].g_col\[1\].pe__1648_/B
+ VGND VGND VPWR VPWR g_row\[0\].g_col\[1\].pe__1648_/X sky130_fd_sc_hd__and2_2
XFILLER_80_25 VGND VGND VPWR VPWR sky130_fd_sc_hd__decap_3
X_181_ _189_/A _181_/B_N VGND VGND VPWR VPWR _181_/Y sky130_fd_sc_hd__nor2b_4
Xg_row\[0\].g_col\[1\].pe__1579_ g_row\[0\].g_col\[1\].pe__1579_/A g_row\[0\].g_col\[1\].pe__1579_/B
+ VGND VGND VPWR VPWR g_row\[0\].g_col\[1\].pe__1630_/B sky130_fd_sc_hd__xor2_2
XFILLER_10_477 VGND VGND VPWR VPWR sky130_fd_sc_hd__fill_2
XFILLER_65_617 VGND VGND VPWR VPWR sky130_fd_sc_hd__decap_3
XTAP_TAPCELL_ROW_88_1529 VGND VPWR sky130_fd_sc_hd__tapvpwrvgnd_1
XFILLER_18_522 VGND VGND VPWR VPWR sky130_fd_sc_hd__decap_3
XFILLER_18_533 VGND VGND VPWR VPWR sky130_fd_sc_hd__fill_2
XFILLER_45_330 VGND VGND VPWR VPWR sky130_fd_sc_hd__decap_3
XFILLER_92_458 VGND VGND VPWR VPWR sky130_fd_sc_hd__decap_3
Xg_row\[1\].g_col\[0\].pe__2190_ g_row\[1\].g_col\[0\].pe__2190_/A g_row\[1\].g_col\[0\].pe__2190_/B
+ VGND VGND VPWR VPWR g_row\[1\].g_col\[0\].pe__2228_/B sky130_fd_sc_hd__nor2_2
XFILLER_33_503 VGND VGND VPWR VPWR sky130_fd_sc_hd__fill_1
Xg_row\[0\].g_col\[0\].pe_hold2301 g_row\[0\].g_col\[0\].pe_hold2879/X VGND VGND VPWR
+ VPWR g_row\[0\].g_col\[0\].pe__2692_/D sky130_fd_sc_hd__clkbuf_2
XFILLER_21_709 VGND VGND VPWR VPWR sky130_fd_sc_hd__fill_2
Xg_row\[0\].g_col\[0\].pe_hold2312 _316_/Q VGND VGND VPWR VPWR g_row\[0\].g_col\[0\].pe_hold2312/X
+ sky130_fd_sc_hd__clkbuf_2
Xg_row\[0\].g_col\[0\].pe_hold2323 g_row\[0\].g_col\[0\].pe_hold2904/X VGND VGND VPWR
+ VPWR g_row\[0\].g_col\[0\].pe_hold2905/A sky130_fd_sc_hd__clkbuf_2
Xg_row\[0\].g_col\[0\].pe_hold3068 _288_/Q VGND VGND VPWR VPWR g_row\[0\].g_col\[0\].pe_hold3068/X
+ sky130_fd_sc_hd__clkbuf_2
Xg_row\[0\].g_col\[0\].pe_hold2367 g_row\[0\].g_col\[0\].pe__2513_/Y VGND VGND VPWR
+ VPWR g_row\[0\].g_col\[0\].pe__2514_/B sky130_fd_sc_hd__clkbuf_2
Xg_row\[0\].g_col\[1\].pe_place937 g_row\[0\].g_col\[1\].pe_place937/A VGND VGND VPWR
+ VPWR g_row\[0\].g_col\[1\].pe__2177_/A2 sky130_fd_sc_hd__buf_6
Xg_row\[0\].g_col\[1\].pe_place959 g_row\[0\].g_col\[1\].pe__1808_/A VGND VGND VPWR
+ VPWR g_row\[0\].g_col\[1\].pe__1728_/A sky130_fd_sc_hd__buf_6
Xg_row\[0\].g_col\[1\].pe_place948 g_row\[0\].g_col\[1\].pe__1457_/X VGND VGND VPWR
+ VPWR g_row\[0\].g_col\[1\].pe__2163_/B sky130_fd_sc_hd__buf_6
Xg_row\[0\].g_col\[0\].pe_hold1688 g_row\[0\].g_col\[0\].pe__2064_/Y VGND VGND VPWR
+ VPWR g_row\[0\].g_col\[0\].pe__2743_/D sky130_fd_sc_hd__clkbuf_2
Xg_row\[0\].g_col\[0\].pe_hold1699 ANTENNA_144/DIODE VGND VGND VPWR VPWR g_row\[0\].g_col\[0\].pe__2158_/A2
+ sky130_fd_sc_hd__clkbuf_2
Xg_row\[1\].g_col\[1\].pe__1990_ g_row\[1\].g_col\[1\].pe__1988_/X g_row\[1\].g_col\[1\].pe__1987_/Y
+ g_row\[1\].g_col\[1\].pe__1981_/Y g_row\[1\].g_col\[1\].pe__1980_/X g_row\[1\].g_col\[1\].pe__1919_/B
+ VGND VGND VPWR VPWR g_row\[1\].g_col\[1\].pe__1991_/D sky130_fd_sc_hd__o2111ai_2
Xclkload12 clkload12/A VGND VGND VPWR VPWR clkload12/X sky130_fd_sc_hd__buf_2
Xg_row\[1\].g_col\[0\].pe__1974_ g_row\[1\].g_col\[0\].pe__1974_/A g_row\[1\].g_col\[0\].pe__1974_/B
+ g_row\[1\].g_col\[0\].pe__1974_/C g_row\[1\].g_col\[0\].pe__1974_/D VGND VGND VPWR
+ VPWR g_row\[1\].g_col\[0\].pe__1978_/A sky130_fd_sc_hd__and4_4
XFILLER_55_3 VGND VGND VPWR VPWR sky130_fd_sc_hd__fill_1
Xoutput1403 output1403/A VGND VGND VPWR VPWR results_flat[53] sky130_fd_sc_hd__buf_2
Xoutput1414 output1414/A VGND VGND VPWR VPWR results_flat[63] sky130_fd_sc_hd__buf_2
Xhold3519 hold3519/A VGND VGND VPWR VPWR hold3519/X sky130_fd_sc_hd__clkbuf_2
Xhold3508 a_inputs_flat[1] VGND VGND VPWR VPWR hold3508/X sky130_fd_sc_hd__clkbuf_2
Xg_row\[1\].g_col\[1\].pe__2611_ g_row\[1\].g_col\[1\].pe__2626_/A1 place1098/X g_row\[1\].g_col\[1\].pe__2626_/B1
+ g_row\[1\].g_col\[1\].pe__2611_/C1 VGND VGND VPWR VPWR g_row\[1\].g_col\[1\].pe__2611_/X
+ sky130_fd_sc_hd__o211a_2
Xhold2807 hold2807/A VGND VGND VPWR VPWR _201_/B_N sky130_fd_sc_hd__clkbuf_2
Xg_row\[1\].g_col\[1\].pe__2542_ g_row\[1\].g_col\[1\].pe__2595_/A g_row\[1\].g_col\[1\].pe__2542_/B
+ VGND VGND VPWR VPWR g_row\[1\].g_col\[1\].pe__2760_/D sky130_fd_sc_hd__and2_2
Xg_row\[0\].g_col\[0\].pe__1983_ hold2340/A VGND VGND VPWR VPWR g_row\[0\].g_col\[0\].pe__1983_/Y
+ sky130_fd_sc_hd__inv_2
Xg_row\[1\].g_col\[0\].pe__2526_ g_row\[1\].g_col\[0\].pe__2526_/A g_row\[1\].g_col\[0\].pe__2526_/B
+ VGND VGND VPWR VPWR g_row\[1\].g_col\[0\].pe__2526_/X sky130_fd_sc_hd__or2_2
Xg_row\[1\].g_col\[1\].pe__2473_ g_row\[1\].g_col\[1\].pe__2491_/B g_row\[1\].g_col\[1\].pe__2505_/A
+ g_row\[1\].g_col\[1\].pe__2491_/A VGND VGND VPWR VPWR g_row\[1\].g_col\[1\].pe__2492_/A
+ sky130_fd_sc_hd__o21ai_2
Xg_row\[1\].g_col\[0\].pe__2457_ g_row\[1\].g_col\[0\].pe__2758_/Q g_row\[1\].g_col\[0\].pe__2457_/B
+ VGND VGND VPWR VPWR g_row\[1\].g_col\[0\].pe__2458_/B sky130_fd_sc_hd__and2b_2
XFILLER_55_138 VGND VGND VPWR VPWR sky130_fd_sc_hd__decap_3
Xg_row\[1\].g_col\[1\].pe_place1011 g_row\[1\].g_col\[1\].pe__2094_/A VGND VGND VPWR
+ VPWR g_row\[1\].g_col\[1\].pe__2125_/C sky130_fd_sc_hd__buf_6
Xg_row\[1\].g_col\[1\].pe_place1022 g_row\[1\].g_col\[1\].pe__2703_/Q VGND VGND VPWR
+ VPWR g_row\[1\].g_col\[1\].pe__2121_/A sky130_fd_sc_hd__buf_6
Xg_row\[1\].g_col\[1\].pe__1424_ g_row\[1\].g_col\[1\].pe__1424_/A g_row\[1\].g_col\[1\].pe__1424_/B
+ VGND VGND VPWR VPWR g_row\[1\].g_col\[1\].pe__1424_/Y sky130_fd_sc_hd__nand2_2
Xg_row\[1\].g_col\[0\].pe__1408_ place1268/X g_row\[1\].g_col\[0\].pe__1408_/B VGND
+ VGND VPWR VPWR g_row\[1\].g_col\[0\].pe__2738_/D sky130_fd_sc_hd__nor2_2
XFILLER_48_190 VGND VGND VPWR VPWR sky130_fd_sc_hd__decap_3
Xg_row\[0\].g_col\[0\].pe__2604_ g_row\[0\].g_col\[0\].pe__2640_/A1 g_row\[0\].g_col\[0\].pe__2604_/A2
+ g_row\[0\].g_col\[0\].pe__2640_/C1 g_row\[0\].g_col\[0\].pe__2603_/X VGND VGND VPWR
+ VPWR g_row\[0\].g_col\[0\].pe__2604_/X sky130_fd_sc_hd__o211a_2
Xg_row\[1\].g_col\[1\].pe_place1033 g_row\[1\].g_col\[1\].pe__1704_/A2 VGND VGND VPWR
+ VPWR g_row\[1\].g_col\[1\].pe__2177_/B2 sky130_fd_sc_hd__buf_6
Xg_row\[1\].g_col\[1\].pe_place1044 g_row\[1\].g_col\[1\].pe__2692_/Q VGND VGND VPWR
+ VPWR g_row\[1\].g_col\[1\].pe__2605_/B sky130_fd_sc_hd__buf_6
Xg_row\[1\].g_col\[1\].pe_place1055 g_row\[1\].g_col\[1\].pe__2595_/A VGND VGND VPWR
+ VPWR g_row\[1\].g_col\[1\].pe__2640_/C1 sky130_fd_sc_hd__buf_6
Xg_row\[1\].g_col\[1\].pe__1355_ g_row\[1\].g_col\[1\].pe__2763_/Q g_row\[1\].g_col\[1\].pe__1355_/B
+ VGND VGND VPWR VPWR output1405/A sky130_fd_sc_hd__xor2_2
Xg_row\[1\].g_col\[0\].pe__2388_ g_row\[1\].g_col\[0\].pe__2388_/A g_row\[1\].g_col\[0\].pe__2388_/B
+ VGND VGND VPWR VPWR g_row\[1\].g_col\[0\].pe__2390_/A sky130_fd_sc_hd__nand2_2
XFILLER_24_536 VGND VGND VPWR VPWR sky130_fd_sc_hd__fill_1
XFILLER_36_385 VGND VGND VPWR VPWR sky130_fd_sc_hd__fill_1
XFILLER_63_182 VGND VGND VPWR VPWR sky130_fd_sc_hd__fill_2
Xg_row\[0\].g_col\[0\].pe__2535_ g_row\[0\].g_col\[0\].pe__2535_/A1 g_row\[0\].g_col\[0\].pe__2554_/A2
+ g_row\[0\].g_col\[0\].pe__2517_/Y g_row\[0\].g_col\[0\].pe__2534_/X VGND VGND VPWR
+ VPWR g_row\[0\].g_col\[0\].pe__2535_/X sky130_fd_sc_hd__a22o_2
Xg_row\[0\].g_col\[1\].pe__2551_ g_row\[0\].g_col\[1\].pe__2551_/A g_row\[0\].g_col\[1\].pe__2551_/B
+ g_row\[0\].g_col\[1\].pe__2551_/C VGND VGND VPWR VPWR g_row\[0\].g_col\[1\].pe__2551_/Y
+ sky130_fd_sc_hd__nand3_2
XFILLER_24_569 VGND VGND VPWR VPWR sky130_fd_sc_hd__decap_3
XFILLER_51_333 VGND VGND VPWR VPWR sky130_fd_sc_hd__decap_3
Xg_row\[0\].g_col\[1\].pe__1502_ g_row\[0\].g_col\[1\].pe__2735_/Q g_row\[0\].g_col\[1\].pe__2734_/Q
+ VGND VGND VPWR VPWR g_row\[0\].g_col\[1\].pe__1504_/A sky130_fd_sc_hd__and2_2
Xg_row\[0\].g_col\[1\].pe__2482_ g_row\[0\].g_col\[1\].pe__2494_/A g_row\[0\].g_col\[1\].pe__2482_/B
+ VGND VGND VPWR VPWR g_row\[0\].g_col\[1\].pe__2508_/B sky130_fd_sc_hd__nor2_2
Xg_row\[0\].g_col\[0\].pe__2466_ g_row\[0\].g_col\[0\].pe__2452_/B g_row\[0\].g_col\[0\].pe__2760_/Q
+ VGND VGND VPWR VPWR g_row\[0\].g_col\[0\].pe__2466_/X sky130_fd_sc_hd__and2b_2
Xg_row\[0\].g_col\[0\].pe__2397_ g_row\[0\].g_col\[0\].pe__2398_/A hold1929/X VGND
+ VGND VPWR VPWR g_row\[0\].g_col\[0\].pe__2397_/Y sky130_fd_sc_hd__nor2_2
Xg_row\[0\].g_col\[0\].pe_hold2890 g_row\[0\].g_col\[0\].pe_hold2890/A VGND VGND VPWR
+ VPWR g_row\[0\].g_col\[0\].pe__2617_/A2 sky130_fd_sc_hd__clkbuf_2
XFILLER_20_786 VGND VGND VPWR VPWR sky130_fd_sc_hd__decap_3
Xclkload6 clkload6/A VGND VGND VPWR VPWR clkload6/X sky130_fd_sc_hd__clkbuf_16
Xg_row\[0\].g_col\[0\].pe__1348_ g_row\[0\].g_col\[0\].pe__1348_/A g_row\[0\].g_col\[0\].pe__1348_/B
+ VGND VGND VPWR VPWR g_row\[0\].g_col\[0\].pe__1349_/B sky130_fd_sc_hd__nand2_2
Xg_row\[0\].g_col\[1\].pe__1364_ g_row\[0\].g_col\[1\].pe__2768_/Q VGND VGND VPWR
+ VPWR g_row\[0\].g_col\[1\].pe__2478_/A sky130_fd_sc_hd__inv_2
XFILLER_59_15 VGND VGND VPWR VPWR sky130_fd_sc_hd__decap_3
XFILLER_87_775 VGND VGND VPWR VPWR sky130_fd_sc_hd__decap_3
Xg_row\[0\].g_col\[1\].pe_hold3121 _325_/Q VGND VGND VPWR VPWR g_row\[0\].g_col\[1\].pe_hold3121/X
+ sky130_fd_sc_hd__clkbuf_2
Xg_row\[0\].g_col\[1\].pe_hold3110 g_row\[0\].g_col\[1\].pe__2732_/Q VGND VGND VPWR
+ VPWR g_row\[0\].g_col\[1\].pe_hold3110/X sky130_fd_sc_hd__clkbuf_2
XFILLER_55_661 VGND VGND VPWR VPWR sky130_fd_sc_hd__decap_3
Xg_row\[0\].g_col\[1\].pe__2749_ clkload9/A g_row\[0\].g_col\[1\].pe__2749_/D VGND
+ VGND VPWR VPWR g_row\[0\].g_col\[1\].pe__2749_/Q sky130_fd_sc_hd__dfxtp_2
XTAP_TAPCELL_ROW_83_1448 VGND VPWR sky130_fd_sc_hd__tapvpwrvgnd_1
XTAP_TAPCELL_ROW_83_1459 VGND VPWR sky130_fd_sc_hd__tapvpwrvgnd_1
XFILLER_30_528 VGND VGND VPWR VPWR sky130_fd_sc_hd__decap_3
XFILLER_42_377 VGND VGND VPWR VPWR sky130_fd_sc_hd__fill_1
X_302_ _302_/CLK _302_/D VGND VGND VPWR VPWR _302_/Q sky130_fd_sc_hd__dfxtp_2
XTAP_TAPCELL_ROW_25_586 VGND VPWR sky130_fd_sc_hd__tapvpwrvgnd_1
X_233_ _237_/A _233_/B_N VGND VGND VPWR VPWR _233_/Y sky130_fd_sc_hd__nor2b_4
XFILLER_7_779 VGND VGND VPWR VPWR sky130_fd_sc_hd__decap_3
Xg_row\[1\].g_col\[0\].pe__1690_ g_row\[1\].g_col\[0\].pe__1690_/A g_row\[1\].g_col\[0\].pe__1690_/B
+ VGND VGND VPWR VPWR g_row\[1\].g_col\[0\].pe__1722_/B sky130_fd_sc_hd__xor2_2
XFILLER_2_473 VGND VGND VPWR VPWR sky130_fd_sc_hd__decap_3
XFILLER_49_70 VGND VGND VPWR VPWR sky130_fd_sc_hd__decap_3
XFILLER_38_628 VGND VGND VPWR VPWR sky130_fd_sc_hd__decap_3
Xg_row\[1\].g_col\[0\].pe__2311_ g_row\[1\].g_col\[0\].pe__2311_/A g_row\[1\].g_col\[0\].pe__2311_/B
+ VGND VGND VPWR VPWR g_row\[1\].g_col\[0\].pe__2319_/A sky130_fd_sc_hd__nand2_2
Xg_row\[1\].g_col\[0\].pe__2242_ g_row\[1\].g_col\[0\].pe__1965_/A g_row\[1\].g_col\[0\].pe__2313_/A2
+ g_row\[1\].g_col\[0\].pe__1541_/X g_row\[1\].g_col\[0\].pe__2030_/A VGND VGND VPWR
+ VPWR g_row\[1\].g_col\[0\].pe__2243_/B sky130_fd_sc_hd__a22o_2
XFILLER_46_661 VGND VGND VPWR VPWR sky130_fd_sc_hd__fill_2
XFILLER_93_767 VGND VGND VPWR VPWR sky130_fd_sc_hd__decap_3
XFILLER_61_620 VGND VGND VPWR VPWR sky130_fd_sc_hd__decap_3
Xg_row\[1\].g_col\[0\].pe__2173_ g_row\[1\].g_col\[0\].pe__2222_/A g_row\[1\].g_col\[0\].pe__2253_/A
+ VGND VGND VPWR VPWR g_row\[1\].g_col\[0\].pe__2183_/A sky130_fd_sc_hd__xnor2_2
XANTENNA_170 hold3147/X VGND VGND VPWR VPWR sky130_fd_sc_hd__diode_2
XANTENNA_181 hold3498/X VGND VGND VPWR VPWR sky130_fd_sc_hd__diode_2
XTAP_TAPCELL_ROW_44_873 VGND VPWR sky130_fd_sc_hd__tapvpwrvgnd_1
Xg_row\[0\].g_col\[0\].pe__2320_ g_row\[0\].g_col\[0\].pe__2368_/A g_row\[0\].g_col\[0\].pe__2348_/B
+ VGND VGND VPWR VPWR g_row\[0\].g_col\[0\].pe__2337_/B sky130_fd_sc_hd__nor2_2
Xg_row\[0\].g_col\[0\].pe__2251_ g_row\[0\].g_col\[0\].pe__2283_/A g_row\[0\].g_col\[0\].pe__2251_/B
+ VGND VGND VPWR VPWR g_row\[0\].g_col\[0\].pe__2273_/B sky130_fd_sc_hd__and2_2
Xg_row\[0\].g_col\[0\].pe_hold2153 g_row\[0\].g_col\[0\].pe__2764_/Q VGND VGND VPWR
+ VPWR g_row\[0\].g_col\[0\].pe__2564_/A1 sky130_fd_sc_hd__clkbuf_2
Xg_row\[0\].g_col\[0\].pe__2182_ g_row\[0\].g_col\[0\].pe__2182_/A g_row\[0\].g_col\[0\].pe__2182_/B
+ VGND VGND VPWR VPWR g_row\[0\].g_col\[0\].pe__2183_/B sky130_fd_sc_hd__xor2_2
Xg_row\[1\].g_col\[1\].pe__1973_ g_row\[1\].g_col\[1\].pe__1972_/B g_row\[1\].g_col\[1\].pe__1972_/C
+ g_row\[1\].g_col\[1\].pe__2085_/A VGND VGND VPWR VPWR g_row\[1\].g_col\[1\].pe__1974_/D
+ sky130_fd_sc_hd__a21o_2
Xg_row\[1\].g_col\[0\].pe__1957_ place1098/A g_row\[1\].g_col\[0\].pe__1558_/B g_row\[1\].g_col\[0\].pe__2177_/B1
+ place1100/X VGND VGND VPWR VPWR g_row\[1\].g_col\[0\].pe__1961_/A sky130_fd_sc_hd__a22o_2
XTAP_TAPCELL_ROW_54_1016 VGND VPWR sky130_fd_sc_hd__tapvpwrvgnd_1
XTAP_TAPCELL_ROW_54_1027 VGND VPWR sky130_fd_sc_hd__tapvpwrvgnd_1
Xhold3305 a_inputs_flat[10] VGND VGND VPWR VPWR hold3305/X sky130_fd_sc_hd__clkbuf_2
Xhold3316 hold3316/A VGND VGND VPWR VPWR hold3316/X sky130_fd_sc_hd__clkbuf_2
Xg_row\[1\].g_col\[0\].pe__1888_ g_row\[1\].g_col\[0\].pe__1888_/A g_row\[1\].g_col\[0\].pe__1888_/B
+ g_row\[1\].g_col\[0\].pe__1888_/C VGND VGND VPWR VPWR g_row\[1\].g_col\[0\].pe__1889_/B
+ sky130_fd_sc_hd__nor3_2
Xhold2604 _185_/Y VGND VGND VPWR VPWR hold2604/X sky130_fd_sc_hd__clkbuf_2
Xhold3327 hold3327/A VGND VGND VPWR VPWR hold3327/X sky130_fd_sc_hd__clkbuf_2
Xhold3338 hold3338/A VGND VGND VPWR VPWR hold3338/X sky130_fd_sc_hd__clkbuf_2
Xhold3349 hold3349/A VGND VGND VPWR VPWR hold3349/X sky130_fd_sc_hd__clkbuf_2
XFILLER_29_29 VGND VGND VPWR VPWR sky130_fd_sc_hd__fill_1
Xhold2615 hold3339/X VGND VGND VPWR VPWR _167_/B_N sky130_fd_sc_hd__clkbuf_2
Xhold2626 hold3407/X VGND VGND VPWR VPWR hold3408/A sky130_fd_sc_hd__clkbuf_2
Xhold2637 hold3454/X VGND VGND VPWR VPWR hold3455/A sky130_fd_sc_hd__clkbuf_2
XFILLER_84_712 VGND VGND VPWR VPWR sky130_fd_sc_hd__fill_2
Xg_row\[0\].g_col\[0\].pe__1966_ hold2229/A VGND VGND VPWR VPWR g_row\[0\].g_col\[0\].pe__1966_/Y
+ sky130_fd_sc_hd__inv_2
Xhold1903 hold2047/X VGND VGND VPWR VPWR hold2048/A sky130_fd_sc_hd__clkbuf_2
Xhold2648 hold3368/X VGND VGND VPWR VPWR hold3369/A sky130_fd_sc_hd__clkbuf_2
Xhold2659 hold2659/A VGND VGND VPWR VPWR _281_/D sky130_fd_sc_hd__clkbuf_2
Xg_row\[1\].g_col\[1\].pe__2525_ g_row\[1\].g_col\[1\].pe__2526_/A g_row\[1\].g_col\[1\].pe__2526_/B
+ VGND VGND VPWR VPWR g_row\[1\].g_col\[1\].pe__2525_/Y sky130_fd_sc_hd__nand2_2
Xg_row\[1\].g_col\[0\].pe__2509_ g_row\[1\].g_col\[0\].pe__2503_/B g_row\[1\].g_col\[0\].pe__2486_/B
+ g_row\[1\].g_col\[0\].pe__2509_/S VGND VGND VPWR VPWR g_row\[1\].g_col\[0\].pe__2509_/X
+ sky130_fd_sc_hd__mux2_1
Xg_row\[0\].g_col\[1\].pe__1982_ g_row\[0\].g_col\[1\].pe__2163_/A g_row\[0\].g_col\[1\].pe__1982_/B
+ VGND VGND VPWR VPWR g_row\[0\].g_col\[1\].pe__1985_/B sky130_fd_sc_hd__nand2_2
XTAP_TAPCELL_ROW_3_248 VGND VPWR sky130_fd_sc_hd__tapvpwrvgnd_1
XTAP_TAPCELL_ROW_3_259 VGND VPWR sky130_fd_sc_hd__tapvpwrvgnd_1
Xg_row\[1\].g_col\[1\].pe__2456_ g_row\[1\].g_col\[1\].pe__2457_/B g_row\[1\].g_col\[1\].pe__2758_/Q
+ VGND VGND VPWR VPWR g_row\[1\].g_col\[1\].pe__2458_/A sky130_fd_sc_hd__and2b_2
Xg_row\[0\].g_col\[0\].pe__1897_ g_row\[0\].g_col\[0\].pe__1886_/A g_row\[0\].g_col\[0\].pe__1897_/B
+ VGND VGND VPWR VPWR g_row\[0\].g_col\[0\].pe__1941_/B sky130_fd_sc_hd__nand2b_2
Xg_row\[1\].g_col\[1\].pe__1407_ _274_/Q g_row\[1\].g_col\[1\].pe__2157_/A g_row\[1\].g_col\[1\].pe__2404_/A1
+ g_row\[1\].g_col\[1\].pe__2404_/B1 VGND VGND VPWR VPWR g_row\[1\].g_col\[1\].pe__1408_/B
+ sky130_fd_sc_hd__o2bb2a_2
XFILLER_36_160 VGND VGND VPWR VPWR sky130_fd_sc_hd__fill_2
XFILLER_52_620 VGND VGND VPWR VPWR sky130_fd_sc_hd__decap_3
Xg_row\[1\].g_col\[1\].pe__2387_ g_row\[1\].g_col\[1\].pe__2387_/A g_row\[1\].g_col\[1\].pe__2387_/B
+ VGND VGND VPWR VPWR g_row\[1\].g_col\[1\].pe__2391_/A sky130_fd_sc_hd__nand2_2
Xg_row\[0\].g_col\[1\].pe__2603_ g_row\[0\].g_col\[1\].pe__2669_/A g_row\[0\].g_col\[1\].pe__2603_/B
+ VGND VGND VPWR VPWR g_row\[0\].g_col\[1\].pe__2603_/X sky130_fd_sc_hd__or2_2
XFILLER_52_664 VGND VGND VPWR VPWR sky130_fd_sc_hd__fill_1
XTAP_TAPCELL_ROW_65_1178 VGND VPWR sky130_fd_sc_hd__tapvpwrvgnd_1
XTAP_TAPCELL_ROW_65_1189 VGND VPWR sky130_fd_sc_hd__tapvpwrvgnd_1
Xg_row\[0\].g_col\[1\].pe__2534_ g_row\[0\].g_col\[1\].pe__2559_/A g_row\[0\].g_col\[1\].pe__2534_/B
+ g_row\[0\].g_col\[1\].pe__2534_/C VGND VGND VPWR VPWR g_row\[0\].g_col\[1\].pe__2534_/X
+ sky130_fd_sc_hd__or3_2
XTAP_TAPCELL_ROW_22_534 VGND VPWR sky130_fd_sc_hd__tapvpwrvgnd_1
Xg_row\[0\].g_col\[0\].pe__2449_ g_row\[0\].g_col\[0\].pe__2741_/Q g_row\[0\].g_col\[0\].pe__2455_/B
+ g_row\[0\].g_col\[0\].pe__2399_/Y VGND VGND VPWR VPWR g_row\[0\].g_col\[0\].pe__2453_/B
+ sky130_fd_sc_hd__o21a_2
Xg_row\[0\].g_col\[1\].pe__2465_ g_row\[0\].g_col\[1\].pe__2526_/A g_row\[0\].g_col\[1\].pe__2526_/B
+ g_row\[0\].g_col\[1\].pe__2464_/X g_row\[0\].g_col\[1\].pe__2458_/A VGND VGND VPWR
+ VPWR g_row\[0\].g_col\[1\].pe__2538_/C sky130_fd_sc_hd__a211o_2
XTAP_TAPCELL_ROW_22_545 VGND VPWR sky130_fd_sc_hd__tapvpwrvgnd_1
Xg_row\[0\].g_col\[1\].pe__1416_ g_row\[0\].g_col\[1\].pe__2725_/Q g_row\[0\].g_col\[1\].pe__2724_/Q
+ VGND VGND VPWR VPWR g_row\[0\].g_col\[1\].pe__1416_/X sky130_fd_sc_hd__xor2_2
Xg_row\[0\].g_col\[1\].pe__2396_ _203_/A g_row\[0\].g_col\[1\].pe__2396_/B VGND VGND
+ VPWR VPWR g_row\[0\].g_col\[1\].pe__2753_/D sky130_fd_sc_hd__nor2_8
Xg_row\[0\].g_col\[1\].pe__1347_ g_row\[0\].g_col\[1\].pe__2759_/Q g_row\[0\].g_col\[1\].pe__2758_/Q
+ g_row\[0\].g_col\[1\].pe__2757_/Q g_row\[0\].g_col\[1\].pe__2775_/A VGND VGND VPWR
+ VPWR g_row\[0\].g_col\[1\].pe__1348_/B sky130_fd_sc_hd__or4_2
XFILLER_4_727 VGND VGND VPWR VPWR sky130_fd_sc_hd__decap_3
XFILLER_10_42 VGND VGND VPWR VPWR sky130_fd_sc_hd__fill_1
XFILLER_62_406 VGND VGND VPWR VPWR sky130_fd_sc_hd__fill_2
XFILLER_70_494 VGND VGND VPWR VPWR sky130_fd_sc_hd__fill_1
XTAP_TAPCELL_ROW_41_821 VGND VPWR sky130_fd_sc_hd__tapvpwrvgnd_1
XTAP_TAPCELL_ROW_41_832 VGND VPWR sky130_fd_sc_hd__tapvpwrvgnd_1
XFILLER_11_561 VGND VGND VPWR VPWR sky130_fd_sc_hd__fill_1
X_147_ _199_/A _147_/B_N VGND VGND VPWR VPWR _147_/Y sky130_fd_sc_hd__nor2b_4
Xg_row\[1\].g_col\[0\].pe__1811_ g_row\[1\].g_col\[0\].pe__1811_/A g_row\[1\].g_col\[0\].pe__1811_/B
+ g_row\[1\].g_col\[0\].pe__1811_/C g_row\[1\].g_col\[0\].pe__1780_/A VGND VGND VPWR
+ VPWR g_row\[1\].g_col\[0\].pe__1811_/X sky130_fd_sc_hd__or4b_4
XFILLER_7_598 VGND VGND VPWR VPWR sky130_fd_sc_hd__decap_3
Xplace1209 place1210/X VGND VGND VPWR VPWR place1209/X sky130_fd_sc_hd__buf_6
Xg_row\[0\].g_col\[0\].pe_place990 g_row\[0\].g_col\[0\].pe__1414_/X VGND VGND VPWR
+ VPWR g_row\[0\].g_col\[0\].pe__1784_/A2 sky130_fd_sc_hd__buf_6
Xg_row\[1\].g_col\[0\].pe__1742_ g_row\[1\].g_col\[0\].pe__1719_/Y g_row\[1\].g_col\[0\].pe__1742_/B
+ VGND VGND VPWR VPWR g_row\[1\].g_col\[0\].pe__1743_/A sky130_fd_sc_hd__nand2b_2
XFILLER_3_760 VGND VGND VPWR VPWR sky130_fd_sc_hd__decap_3
XPHY_EDGE_ROW_29_Left_123 VGND VGND VPWR VPWR sky130_fd_sc_hd__decap_3
Xg_row\[1\].g_col\[0\].pe__1673_ g_row\[1\].g_col\[0\].pe__1864_/A g_row\[1\].g_col\[0\].pe__1673_/B
+ VGND VGND VPWR VPWR g_row\[1\].g_col\[0\].pe__1690_/B sky130_fd_sc_hd__xnor2_2
XFILLER_66_701 VGND VGND VPWR VPWR sky130_fd_sc_hd__decap_3
Xg_row\[0\].g_col\[0\].pe__1820_ g_row\[0\].g_col\[0\].pe__1820_/A g_row\[0\].g_col\[0\].pe__1820_/B
+ VGND VGND VPWR VPWR g_row\[0\].g_col\[0\].pe__1821_/D sky130_fd_sc_hd__nor2_2
Xg_row\[1\].g_col\[0\].pe_hold2857 g_row\[1\].g_col\[0\].pe_hold2857/A VGND VGND VPWR
+ VPWR g_row\[1\].g_col\[0\].pe__2718_/D sky130_fd_sc_hd__clkbuf_2
Xg_row\[1\].g_col\[0\].pe_hold2846 g_row\[1\].g_col\[0\].pe__2711_/Q VGND VGND VPWR
+ VPWR g_row\[1\].g_col\[0\].pe__2651_/B sky130_fd_sc_hd__clkbuf_2
Xg_row\[1\].g_col\[0\].pe_hold2835 g_row\[1\].g_col\[0\].pe__2653_/X VGND VGND VPWR
+ VPWR g_row\[1\].g_col\[0\].pe__2654_/C1 sky130_fd_sc_hd__clkbuf_2
XFILLER_18_3 VGND VGND VPWR VPWR sky130_fd_sc_hd__fill_1
XFILLER_66_734 VGND VGND VPWR VPWR sky130_fd_sc_hd__decap_3
XTAP_TAPCELL_ROW_49_943 VGND VPWR sky130_fd_sc_hd__tapvpwrvgnd_1
Xg_row\[0\].g_col\[0\].pe__1751_ place1218/A g_row\[0\].g_col\[0\].pe__1414_/X g_row\[0\].g_col\[0\].pe__1415_/Y
+ g_row\[0\].g_col\[0\].pe__1784_/B1 hold3118/A VGND VGND VPWR VPWR g_row\[0\].g_col\[0\].pe__1752_/B
+ sky130_fd_sc_hd__a32o_2
Xg_row\[1\].g_col\[1\].pe__2310_ g_row\[1\].g_col\[1\].pe__2318_/A g_row\[1\].g_col\[1\].pe__2310_/B
+ g_row\[1\].g_col\[1\].pe__2276_/B VGND VGND VPWR VPWR g_row\[1\].g_col\[1\].pe__2337_/A
+ sky130_fd_sc_hd__or3b_2
XTAP_TAPCELL_ROW_0_207 VGND VPWR sky130_fd_sc_hd__tapvpwrvgnd_1
Xg_row\[1\].g_col\[1\].pe__2241_ g_row\[1\].g_col\[1\].pe__2278_/B2 g_row\[1\].g_col\[1\].pe__2363_/A2
+ g_row\[1\].g_col\[1\].pe__2388_/B g_row\[1\].g_col\[1\].pe__2241_/B2 VGND VGND VPWR
+ VPWR g_row\[1\].g_col\[1\].pe__2277_/A sky130_fd_sc_hd__a22o_2
XFILLER_18_160 VGND VGND VPWR VPWR sky130_fd_sc_hd__decap_3
Xg_row\[0\].g_col\[0\].pe__1682_ g_row\[0\].g_col\[0\].pe__2686_/A g_row\[0\].g_col\[0\].pe__1682_/B
+ VGND VGND VPWR VPWR g_row\[0\].g_col\[0\].pe__1686_/B sky130_fd_sc_hd__xor2_2
Xg_row\[1\].g_col\[0\].pe__2225_ g_row\[1\].g_col\[0\].pe__2174_/A g_row\[1\].g_col\[0\].pe__2174_/B
+ g_row\[1\].g_col\[0\].pe__2182_/B g_row\[1\].g_col\[0\].pe__2181_/B g_row\[1\].g_col\[0\].pe__2181_/A
+ VGND VGND VPWR VPWR g_row\[1\].g_col\[0\].pe__2226_/B sky130_fd_sc_hd__a32o_2
XFILLER_18_193 VGND VGND VPWR VPWR sky130_fd_sc_hd__decap_3
XFILLER_46_480 VGND VGND VPWR VPWR sky130_fd_sc_hd__decap_3
Xg_row\[1\].g_col\[1\].pe__2172_ g_row\[1\].g_col\[1\].pe__2172_/A g_row\[1\].g_col\[1\].pe__2172_/B
+ VGND VGND VPWR VPWR g_row\[1\].g_col\[1\].pe__2253_/A sky130_fd_sc_hd__xor2_2
Xg_row\[1\].g_col\[0\].pe__2156_ g_row\[1\].g_col\[0\].pe__2155_/B g_row\[1\].g_col\[0\].pe__2300_/A
+ g_row\[1\].g_col\[0\].pe__2200_/A VGND VGND VPWR VPWR g_row\[1\].g_col\[0\].pe__2157_/B
+ sky130_fd_sc_hd__a21o_2
XPHY_EDGE_ROW_38_Left_132 VGND VGND VPWR VPWR sky130_fd_sc_hd__decap_3
Xg_row\[0\].g_col\[0\].pe__2303_ g_row\[0\].g_col\[0\].pe__2233_/C g_row\[0\].g_col\[0\].pe__2299_/B
+ g_row\[0\].g_col\[0\].pe__2302_/Y VGND VGND VPWR VPWR g_row\[0\].g_col\[0\].pe__2304_/C
+ sky130_fd_sc_hd__o21a_2
Xg_row\[1\].g_col\[0\].pe__2087_ g_row\[1\].g_col\[0\].pe__2087_/A g_row\[1\].g_col\[0\].pe__2087_/B
+ g_row\[1\].g_col\[0\].pe__2087_/C g_row\[1\].g_col\[0\].pe__2087_/D VGND VGND VPWR
+ VPWR g_row\[1\].g_col\[0\].pe__2091_/A sky130_fd_sc_hd__nand4_2
Xg_row\[0\].g_col\[1\].pe__2250_ g_row\[0\].g_col\[1\].pe__2250_/A g_row\[0\].g_col\[1\].pe__2250_/B
+ VGND VGND VPWR VPWR g_row\[0\].g_col\[1\].pe__2251_/B sky130_fd_sc_hd__nand2_2
Xg_row\[0\].g_col\[0\].pe__2234_ g_row\[0\].g_col\[0\].pe__2233_/A g_row\[0\].g_col\[0\].pe__2233_/C
+ g_row\[0\].g_col\[0\].pe__2298_/A VGND VGND VPWR VPWR g_row\[0\].g_col\[0\].pe__2234_/Y
+ sky130_fd_sc_hd__a21oi_2
Xg_row\[0\].g_col\[0\].pe__2165_ g_row\[0\].g_col\[0\].pe__2165_/A g_row\[0\].g_col\[0\].pe__2165_/B
+ g_row\[0\].g_col\[0\].pe__2165_/C VGND VGND VPWR VPWR g_row\[0\].g_col\[0\].pe__2167_/B
+ sky130_fd_sc_hd__nand3_2
Xg_row\[0\].g_col\[1\].pe__2181_ g_row\[0\].g_col\[1\].pe__2181_/A g_row\[0\].g_col\[1\].pe__2181_/B
+ VGND VGND VPWR VPWR g_row\[0\].g_col\[1\].pe__2182_/B sky130_fd_sc_hd__xor2_2
XPHY_EDGE_ROW_47_Left_141 VGND VGND VPWR VPWR sky130_fd_sc_hd__decap_3
Xg_row\[0\].g_col\[0\].pe__2096_ g_row\[0\].g_col\[0\].pe__2097_/B g_row\[0\].g_col\[0\].pe__2097_/C
+ g_row\[0\].g_col\[0\].pe__2097_/A VGND VGND VPWR VPWR g_row\[0\].g_col\[0\].pe__2099_/A
+ sky130_fd_sc_hd__o21ai_2
Xg_row\[1\].g_col\[1\].pe_hold1708 g_row\[1\].g_col\[1\].pe__2436_/A VGND VGND VPWR
+ VPWR g_row\[1\].g_col\[1\].pe__2236_/B1 sky130_fd_sc_hd__clkbuf_2
Xg_row\[1\].g_col\[1\].pe__1956_ g_row\[1\].g_col\[1\].pe__1916_/A g_row\[1\].g_col\[1\].pe__1916_/B
+ g_row\[1\].g_col\[1\].pe__1955_/X VGND VGND VPWR VPWR g_row\[1\].g_col\[1\].pe__1963_/A
+ sky130_fd_sc_hd__a21o_2
XTAP_TAPCELL_ROW_8_329 VGND VPWR sky130_fd_sc_hd__tapvpwrvgnd_1
Xg_row\[1\].g_col\[1\].pe__1887_ g_row\[1\].g_col\[1\].pe__1888_/A g_row\[1\].g_col\[1\].pe__1888_/B
+ g_row\[1\].g_col\[1\].pe__1888_/C VGND VGND VPWR VPWR g_row\[1\].g_col\[1\].pe__1951_/A
+ sky130_fd_sc_hd__o21a_2
Xhold2412 _265_/Y VGND VGND VPWR VPWR hold2412/X sky130_fd_sc_hd__clkbuf_2
Xhold3135 hold3135/A VGND VGND VPWR VPWR hold3135/X sky130_fd_sc_hd__clkbuf_2
Xhold3146 hold3146/A VGND VGND VPWR VPWR hold3146/X sky130_fd_sc_hd__clkbuf_2
Xhold3157 hold3157/A VGND VGND VPWR VPWR hold3157/X sky130_fd_sc_hd__clkbuf_2
XFILLER_69_572 VGND VGND VPWR VPWR sky130_fd_sc_hd__decap_3
XFILLER_76_509 VGND VGND VPWR VPWR sky130_fd_sc_hd__decap_3
Xhold2423 hold3150/X VGND VGND VPWR VPWR _171_/B_N sky130_fd_sc_hd__clkbuf_2
Xhold2434 hold3169/X VGND VGND VPWR VPWR hold3170/A sky130_fd_sc_hd__clkbuf_2
Xhold2445 hold3153/X VGND VGND VPWR VPWR hold3154/A sky130_fd_sc_hd__clkbuf_2
Xhold3168 hold3168/A VGND VGND VPWR VPWR hold3168/X sky130_fd_sc_hd__clkbuf_2
Xhold3179 b_inputs_flat[19] VGND VGND VPWR VPWR hold3179/X sky130_fd_sc_hd__clkbuf_2
Xhold2456 hold3186/X VGND VGND VPWR VPWR hold3187/A sky130_fd_sc_hd__clkbuf_2
Xhold2467 hold2467/A VGND VGND VPWR VPWR _284_/D sky130_fd_sc_hd__clkbuf_2
Xhold2478 _221_/Y VGND VGND VPWR VPWR hold2478/X sky130_fd_sc_hd__clkbuf_2
Xhold2489 hold3199/X VGND VGND VPWR VPWR _255_/B_N sky130_fd_sc_hd__clkbuf_2
Xg_row\[1\].g_col\[1\].pe__2508_ g_row\[1\].g_col\[1\].pe__2508_/A g_row\[1\].g_col\[1\].pe__2508_/B
+ VGND VGND VPWR VPWR g_row\[1\].g_col\[1\].pe__2508_/Y sky130_fd_sc_hd__xnor2_2
Xg_row\[0\].g_col\[1\].pe__1965_ g_row\[0\].g_col\[1\].pe__1965_/A g_row\[0\].g_col\[1\].pe__2026_/B
+ VGND VGND VPWR VPWR g_row\[0\].g_col\[1\].pe__1968_/B sky130_fd_sc_hd__nand2_2
XFILLER_29_458 VGND VGND VPWR VPWR sky130_fd_sc_hd__decap_3
XFILLER_72_704 VGND VGND VPWR VPWR sky130_fd_sc_hd__decap_3
Xhold1766 hold1766/A VGND VGND VPWR VPWR hold1766/X sky130_fd_sc_hd__clkbuf_2
XTAP_TAPCELL_ROW_27_615 VGND VPWR sky130_fd_sc_hd__tapvpwrvgnd_1
XTAP_TAPCELL_ROW_67_1218 VGND VPWR sky130_fd_sc_hd__tapvpwrvgnd_1
Xg_row\[1\].g_col\[1\].pe__2439_ g_row\[1\].g_col\[1\].pe__2439_/A g_row\[1\].g_col\[1\].pe__2439_/B
+ VGND VGND VPWR VPWR g_row\[1\].g_col\[1\].pe__2439_/Y sky130_fd_sc_hd__xnor2_2
Xg_row\[0\].g_col\[1\].pe__1896_ g_row\[0\].g_col\[1\].pe__1896_/A g_row\[0\].g_col\[1\].pe__1885_/A
+ VGND VGND VPWR VPWR g_row\[0\].g_col\[1\].pe__1941_/A sky130_fd_sc_hd__or2b_2
XFILLER_25_620 VGND VGND VPWR VPWR sky130_fd_sc_hd__fill_2
XPHY_EDGE_ROW_56_Left_150 VGND VGND VPWR VPWR sky130_fd_sc_hd__decap_3
XFILLER_72_26 VGND VGND VPWR VPWR sky130_fd_sc_hd__fill_2
XFILLER_72_59 VGND VGND VPWR VPWR sky130_fd_sc_hd__fill_1
XTAP_TAPCELL_ROW_80_1407 VGND VPWR sky130_fd_sc_hd__tapvpwrvgnd_1
XFILLER_12_314 VGND VGND VPWR VPWR sky130_fd_sc_hd__fill_1
Xg_row\[1\].g_col\[0\].pe_place1260 g_row\[1\].g_col\[0\].pe__2669_/A VGND VGND VPWR
+ VPWR g_row\[1\].g_col\[0\].pe__2663_/A sky130_fd_sc_hd__buf_6
Xg_row\[0\].g_col\[1\].pe__2517_ g_row\[0\].g_col\[1\].pe__2590_/A g_row\[0\].g_col\[1\].pe__2516_/X
+ g_row\[0\].g_col\[1\].pe__2403_/Y g_row\[0\].g_col\[1\].pe__2010_/A VGND VGND VPWR
+ VPWR g_row\[0\].g_col\[1\].pe__2517_/Y sky130_fd_sc_hd__a211oi_2
XFILLER_9_819 VGND VGND VPWR VPWR sky130_fd_sc_hd__fill_2
Xg_row\[0\].g_col\[1\].pe__2448_ g_row\[0\].g_col\[1\].pe__2743_/Q VGND VGND VPWR
+ VPWR g_row\[0\].g_col\[1\].pe__2451_/A sky130_fd_sc_hd__inv_2
XANTENNA_70 hold2694/X VGND VGND VPWR VPWR sky130_fd_sc_hd__diode_2
XANTENNA_81 hold3219/X VGND VGND VPWR VPWR sky130_fd_sc_hd__diode_2
XANTENNA_92 hold3329/X VGND VGND VPWR VPWR sky130_fd_sc_hd__diode_2
Xg_row\[0\].g_col\[1\].pe__2379_ g_row\[0\].g_col\[1\].pe__2356_/A g_row\[0\].g_col\[1\].pe__2375_/B
+ g_row\[0\].g_col\[1\].pe__2010_/A VGND VGND VPWR VPWR g_row\[0\].g_col\[1\].pe__2379_/Y
+ sky130_fd_sc_hd__a21oi_2
Xg_row\[1\].g_col\[1\].pe_hold2932 g_row\[1\].g_col\[1\].pe__2723_/Q VGND VGND VPWR
+ VPWR g_row\[1\].g_col\[1\].pe__1340_/A sky130_fd_sc_hd__clkbuf_2
XTAP_TAPCELL_ROW_91_1569 VGND VPWR sky130_fd_sc_hd__tapvpwrvgnd_1
XFILLER_48_701 VGND VGND VPWR VPWR sky130_fd_sc_hd__decap_3
XFILLER_0_785 VGND VGND VPWR VPWR sky130_fd_sc_hd__decap_3
XFILLER_47_211 VGND VGND VPWR VPWR sky130_fd_sc_hd__fill_2
XFILLER_75_564 VGND VGND VPWR VPWR sky130_fd_sc_hd__decap_3
Xhold2990 hold2990/A VGND VGND VPWR VPWR hold2990/X sky130_fd_sc_hd__clkbuf_2
XTAP_TAPCELL_ROW_46_902 VGND VPWR sky130_fd_sc_hd__tapvpwrvgnd_1
XFILLER_28_480 VGND VGND VPWR VPWR sky130_fd_sc_hd__decap_3
Xg_row\[1\].g_col\[0\].pe__2010_ g_row\[1\].g_col\[0\].pe__2010_/A g_row\[1\].g_col\[0\].pe__2010_/B
+ g_row\[1\].g_col\[0\].pe__2062_/A g_row\[1\].g_col\[0\].pe__2010_/D VGND VGND VPWR
+ VPWR g_row\[1\].g_col\[0\].pe__2010_/X sky130_fd_sc_hd__or4_4
XFILLER_15_141 VGND VGND VPWR VPWR sky130_fd_sc_hd__decap_3
XFILLER_90_589 VGND VGND VPWR VPWR sky130_fd_sc_hd__fill_1
XFILLER_71_781 VGND VGND VPWR VPWR sky130_fd_sc_hd__decap_3
XFILLER_30_122 VGND VGND VPWR VPWR sky130_fd_sc_hd__decap_3
XFILLER_62_81 VGND VGND VPWR VPWR sky130_fd_sc_hd__decap_3
XFILLER_30_166 VGND VGND VPWR VPWR sky130_fd_sc_hd__decap_3
XFILLER_31_689 VGND VGND VPWR VPWR sky130_fd_sc_hd__decap_3
Xg_row\[1\].g_col\[1\].pe__1810_ g_row\[1\].g_col\[1\].pe__1811_/A g_row\[1\].g_col\[1\].pe__1811_/B
+ g_row\[1\].g_col\[1\].pe__1803_/Y g_row\[1\].g_col\[1\].pe__1808_/X g_row\[1\].g_col\[1\].pe__1809_/X
+ VGND VGND VPWR VPWR g_row\[1\].g_col\[1\].pe__1810_/X sky130_fd_sc_hd__o41a_2
Xg_row\[1\].g_col\[1\].pe__1741_ g_row\[1\].g_col\[1\].pe__1776_/A g_row\[1\].g_col\[1\].pe__1776_/B
+ g_row\[1\].g_col\[1\].pe__1740_/Y VGND VGND VPWR VPWR g_row\[1\].g_col\[1\].pe__1815_/B
+ sky130_fd_sc_hd__a21oi_2
Xg_row\[1\].g_col\[0\].pe__1725_ g_row\[1\].g_col\[0\].pe__1723_/A g_row\[1\].g_col\[0\].pe__1723_/B
+ g_row\[1\].g_col\[0\].pe__1745_/B g_row\[1\].g_col\[0\].pe__1745_/A VGND VGND VPWR
+ VPWR g_row\[1\].g_col\[0\].pe__1726_/B sky130_fd_sc_hd__a22oi_2
Xg_row\[1\].g_col\[1\].pe__1672_ g_row\[1\].g_col\[1\].pe__1853_/B2 g_row\[1\].g_col\[1\].pe__1715_/B
+ g_row\[1\].g_col\[1\].pe__1863_/B1 g_row\[1\].g_col\[1\].pe__2599_/B VGND VGND VPWR
+ VPWR g_row\[1\].g_col\[1\].pe__1673_/B sky130_fd_sc_hd__a22o_2
XFILLER_86_818 VGND VGND VPWR VPWR sky130_fd_sc_hd__fill_1
Xg_row\[1\].g_col\[0\].pe__1656_ g_row\[1\].g_col\[0\].pe__1656_/A g_row\[1\].g_col\[0\].pe__1656_/B
+ VGND VGND VPWR VPWR g_row\[1\].g_col\[0\].pe__1659_/A sky130_fd_sc_hd__xor2_2
XFILLER_39_734 VGND VGND VPWR VPWR sky130_fd_sc_hd__fill_1
Xg_row\[0\].g_col\[0\].pe__1803_ g_row\[0\].g_col\[0\].pe__1807_/A g_row\[0\].g_col\[0\].pe__1807_/B
+ VGND VGND VPWR VPWR g_row\[0\].g_col\[0\].pe__1803_/Y sky130_fd_sc_hd__nor2_2
Xg_row\[1\].g_col\[0\].pe_hold1920 g_row\[1\].g_col\[0\].pe__2114_/X VGND VGND VPWR
+ VPWR g_row\[1\].g_col\[0\].pe__2115_/B sky130_fd_sc_hd__clkbuf_2
Xg_row\[1\].g_col\[0\].pe__1587_ g_row\[1\].g_col\[0\].pe__1587_/A g_row\[1\].g_col\[0\].pe__1587_/B
+ VGND VGND VPWR VPWR g_row\[1\].g_col\[0\].pe__1594_/A sky130_fd_sc_hd__xor2_2
XFILLER_66_597 VGND VGND VPWR VPWR sky130_fd_sc_hd__decap_3
Xg_row\[0\].g_col\[0\].pe__1734_ g_row\[0\].g_col\[0\].pe__1734_/A g_row\[0\].g_col\[0\].pe__1734_/B
+ VGND VGND VPWR VPWR g_row\[0\].g_col\[0\].pe__1734_/X sky130_fd_sc_hd__and2_2
Xg_row\[0\].g_col\[1\].pe__1750_ g_row\[0\].g_col\[1\].pe__1808_/A g_row\[0\].g_col\[1\].pe__1750_/B
+ VGND VGND VPWR VPWR g_row\[0\].g_col\[1\].pe__1756_/A sky130_fd_sc_hd__xnor2_2
Xg_row\[0\].g_col\[0\].pe__1665_ g_row\[0\].g_col\[0\].pe__1656_/A g_row\[0\].g_col\[0\].pe__1656_/B
+ g_row\[0\].g_col\[0\].pe__1664_/X VGND VGND VPWR VPWR g_row\[0\].g_col\[0\].pe__1697_/A
+ sky130_fd_sc_hd__a21bo_2
Xg_row\[0\].g_col\[1\].pe__1681_ g_row\[0\].g_col\[1\].pe__1749_/A2 g_row\[0\].g_col\[1\].pe__1729_/A2
+ g_row\[0\].g_col\[1\].pe__1729_/A3 g_row\[0\].g_col\[1\].pe__1729_/B1 g_row\[0\].g_col\[1\].pe__1727_/A2
+ VGND VGND VPWR VPWR g_row\[0\].g_col\[1\].pe__1682_/B sky130_fd_sc_hd__a32o_2
Xg_row\[1\].g_col\[1\].pe__2224_ g_row\[1\].g_col\[1\].pe__2258_/A g_row\[1\].g_col\[1\].pe__2258_/B
+ VGND VGND VPWR VPWR g_row\[1\].g_col\[1\].pe__2226_/A sky130_fd_sc_hd__xor2_2
Xg_row\[1\].g_col\[0\].pe__2208_ g_row\[1\].g_col\[0\].pe__2121_/A g_row\[1\].g_col\[0\].pe__1471_/X
+ g_row\[1\].g_col\[0\].pe__1474_/Y g_row\[1\].g_col\[0\].pe__1965_/A VGND VGND VPWR
+ VPWR g_row\[1\].g_col\[0\].pe__2209_/B sky130_fd_sc_hd__a22o_2
XFILLER_53_258 VGND VGND VPWR VPWR sky130_fd_sc_hd__decap_3
Xg_row\[1\].g_col\[1\].pe__2155_ g_row\[1\].g_col\[1\].pe__2200_/A g_row\[1\].g_col\[1\].pe__2155_/B
+ g_row\[1\].g_col\[1\].pe__2300_/A VGND VGND VPWR VPWR g_row\[1\].g_col\[1\].pe__2155_/X
+ sky130_fd_sc_hd__and3_2
XFILLER_22_623 VGND VGND VPWR VPWR sky130_fd_sc_hd__fill_2
XFILLER_34_472 VGND VGND VPWR VPWR sky130_fd_sc_hd__decap_3
XFILLER_34_483 VGND VGND VPWR VPWR sky130_fd_sc_hd__fill_1
XFILLER_62_781 VGND VGND VPWR VPWR sky130_fd_sc_hd__fill_1
XTAP_TAPCELL_ROW_62_1137 VGND VPWR sky130_fd_sc_hd__tapvpwrvgnd_1
Xg_row\[0\].g_col\[0\].pe__1596_ g_row\[0\].g_col\[0\].pe__1596_/A g_row\[0\].g_col\[0\].pe__1596_/B
+ VGND VGND VPWR VPWR g_row\[0\].g_col\[0\].pe__1596_/X sky130_fd_sc_hd__and2_2
Xg_row\[1\].g_col\[0\].pe__2139_ g_row\[1\].g_col\[0\].pe__2241_/B2 g_row\[1\].g_col\[0\].pe__2313_/A2
+ g_row\[1\].g_col\[0\].pe__1541_/X place1090/A VGND VGND VPWR VPWR g_row\[1\].g_col\[0\].pe__2140_/B
+ sky130_fd_sc_hd__a22o_2
XFILLER_22_645 VGND VGND VPWR VPWR sky130_fd_sc_hd__decap_3
Xg_row\[1\].g_col\[1\].pe__2086_ g_row\[1\].g_col\[1\].pe__2085_/B g_row\[1\].g_col\[1\].pe__2085_/C
+ g_row\[1\].g_col\[1\].pe__2085_/A VGND VGND VPWR VPWR g_row\[1\].g_col\[1\].pe__2087_/D
+ sky130_fd_sc_hd__a21o_2
Xg_row\[0\].g_col\[1\].pe__2302_ g_row\[0\].g_col\[1\].pe__2238_/X g_row\[0\].g_col\[1\].pe__2263_/B
+ g_row\[0\].g_col\[1\].pe__2261_/Y VGND VGND VPWR VPWR g_row\[0\].g_col\[1\].pe__2302_/Y
+ sky130_fd_sc_hd__a21oi_2
XFILLER_22_689 VGND VGND VPWR VPWR sky130_fd_sc_hd__decap_3
XTAP_TAPCELL_ROW_32_684 VGND VPWR sky130_fd_sc_hd__tapvpwrvgnd_1
XTAP_TAPCELL_ROW_32_695 VGND VPWR sky130_fd_sc_hd__tapvpwrvgnd_1
Xg_row\[0\].g_col\[0\].pe__2217_ g_row\[0\].g_col\[0\].pe__2217_/A g_row\[0\].g_col\[0\].pe__2217_/B
+ VGND VGND VPWR VPWR g_row\[0\].g_col\[0\].pe__2239_/B sky130_fd_sc_hd__xnor2_2
Xg_row\[0\].g_col\[1\].pe__2233_ g_row\[0\].g_col\[1\].pe__2233_/A g_row\[0\].g_col\[1\].pe__2298_/A
+ g_row\[0\].g_col\[1\].pe__2233_/C VGND VGND VPWR VPWR g_row\[0\].g_col\[1\].pe__2233_/X
+ sky130_fd_sc_hd__and3_2
Xg_row\[0\].g_col\[1\].pe__2164_ g_row\[0\].g_col\[1\].pe__1461_/A g_row\[0\].g_col\[1\].pe__1461_/B
+ g_row\[0\].g_col\[1\].pe__1983_/Y VGND VGND VPWR VPWR g_row\[0\].g_col\[1\].pe__2165_/C
+ sky130_fd_sc_hd__a21o_2
Xg_row\[0\].g_col\[0\].pe__2148_ g_row\[0\].g_col\[0\].pe__2148_/A g_row\[0\].g_col\[0\].pe__2162_/B
+ VGND VGND VPWR VPWR g_row\[0\].g_col\[0\].pe__2161_/B sky130_fd_sc_hd__xnor2_2
Xg_row\[1\].g_col\[1\].pe_hold2206 g_row\[1\].g_col\[1\].pe__2713_/Q VGND VGND VPWR
+ VPWR g_row\[1\].g_col\[1\].pe__2655_/B sky130_fd_sc_hd__clkbuf_2
Xg_row\[0\].g_col\[0\].pe__2079_ g_row\[0\].g_col\[0\].pe__2632_/B g_row\[0\].g_col\[0\].pe__2079_/B
+ VGND VGND VPWR VPWR g_row\[0\].g_col\[0\].pe__2081_/B sky130_fd_sc_hd__nand2_2
Xg_row\[1\].g_col\[1\].pe__1939_ g_row\[1\].g_col\[1\].pe__1939_/A g_row\[1\].g_col\[1\].pe__1939_/B
+ VGND VGND VPWR VPWR g_row\[1\].g_col\[1\].pe__1941_/C sky130_fd_sc_hd__xnor2_2
Xg_row\[0\].g_col\[1\].pe__2095_ g_row\[0\].g_col\[1\].pe__2184_/C g_row\[0\].g_col\[1\].pe__2095_/B
+ VGND VGND VPWR VPWR g_row\[0\].g_col\[1\].pe__2097_/A sky130_fd_sc_hd__nand2_2
XTAP_TAPCELL_ROW_73_1299 VGND VPWR sky130_fd_sc_hd__tapvpwrvgnd_1
XFILLER_76_317 VGND VGND VPWR VPWR sky130_fd_sc_hd__fill_2
XFILLER_57_553 VGND VGND VPWR VPWR sky130_fd_sc_hd__fill_1
Xhold1530 hold2622/X VGND VGND VPWR VPWR hold2623/A sky130_fd_sc_hd__clkbuf_2
Xhold1541 hold3457/X VGND VGND VPWR VPWR hold3458/A sky130_fd_sc_hd__clkbuf_2
Xhold1552 hold3418/X VGND VGND VPWR VPWR hold3419/A sky130_fd_sc_hd__clkbuf_2
Xhold1563 hold2676/X VGND VGND VPWR VPWR hold2677/A sky130_fd_sc_hd__clkbuf_2
Xhold1574 hold3443/X VGND VGND VPWR VPWR hold3444/A sky130_fd_sc_hd__clkbuf_2
Xhold1585 hold3495/X VGND VGND VPWR VPWR hold3496/A sky130_fd_sc_hd__clkbuf_2
Xg_row\[0\].g_col\[1\].pe__1948_ _203_/A g_row\[0\].g_col\[1\].pe__1948_/B VGND VGND
+ VPWR VPWR g_row\[0\].g_col\[1\].pe__2741_/D sky130_fd_sc_hd__nor2_2
Xhold1596 hold2742/X VGND VGND VPWR VPWR hold2743/A sky130_fd_sc_hd__clkbuf_2
Xg_row\[1\].g_col\[0\].pe_place924 g_row\[1\].g_col\[0\].pe__1415_/Y VGND VGND VPWR
+ VPWR g_row\[1\].g_col\[0\].pe__1729_/A3 sky130_fd_sc_hd__buf_6
Xg_row\[1\].g_col\[0\].pe_place913 g_row\[1\].g_col\[0\].pe__2209_/A VGND VGND VPWR
+ VPWR g_row\[1\].g_col\[0\].pe__1676_/A sky130_fd_sc_hd__buf_6
Xg_row\[0\].g_col\[1\].pe__1879_ g_row\[0\].g_col\[1\].pe__1879_/A g_row\[0\].g_col\[1\].pe__1879_/B
+ VGND VGND VPWR VPWR g_row\[0\].g_col\[1\].pe__1879_/Y sky130_fd_sc_hd__nor2_2
XFILLER_13_601 VGND VGND VPWR VPWR sky130_fd_sc_hd__fill_2
Xg_row\[1\].g_col\[0\].pe_place935 g_row\[1\].g_col\[0\].pe__2684_/B VGND VGND VPWR
+ VPWR g_row\[1\].g_col\[0\].pe__2686_/B sky130_fd_sc_hd__buf_6
XFILLER_13_612 VGND VGND VPWR VPWR sky130_fd_sc_hd__decap_3
XFILLER_52_280 VGND VGND VPWR VPWR sky130_fd_sc_hd__decap_3
XPHY_EDGE_ROW_11_Right_11 VGND VGND VPWR VPWR sky130_fd_sc_hd__decap_3
XFILLER_9_649 VGND VGND VPWR VPWR sky130_fd_sc_hd__decap_3
XTAP_TAPCELL_ROW_51_971 VGND VPWR sky130_fd_sc_hd__tapvpwrvgnd_1
XTAP_TAPCELL_ROW_51_982 VGND VPWR sky130_fd_sc_hd__tapvpwrvgnd_1
XTAP_TAPCELL_ROW_10_356 VGND VPWR sky130_fd_sc_hd__tapvpwrvgnd_1
XTAP_TAPCELL_ROW_10_367 VGND VPWR sky130_fd_sc_hd__tapvpwrvgnd_1
XTAP_TAPCELL_ROW_93_1609 VGND VPWR sky130_fd_sc_hd__tapvpwrvgnd_1
Xg_row\[0\].g_col\[0\].pe_place1177 g_row\[0\].g_col\[0\].pe__2734_/Q VGND VGND VPWR
+ VPWR g_row\[0\].g_col\[0\].pe__2368_/A sky130_fd_sc_hd__buf_6
Xg_row\[0\].g_col\[0\].pe_place1188 g_row\[0\].g_col\[0\].pe__2726_/Q VGND VGND VPWR
+ VPWR g_row\[0\].g_col\[0\].pe__1785_/A sky130_fd_sc_hd__buf_6
XFILLER_4_365 VGND VGND VPWR VPWR sky130_fd_sc_hd__fill_2
XPHY_EDGE_ROW_20_Right_20 VGND VGND VPWR VPWR sky130_fd_sc_hd__decap_3
Xg_row\[1\].g_col\[0\].pe__1510_ g_row\[1\].g_col\[0\].pe__1501_/A g_row\[1\].g_col\[0\].pe__1510_/B
+ VGND VGND VPWR VPWR g_row\[1\].g_col\[0\].pe__1510_/X sky130_fd_sc_hd__and2b_2
Xg_row\[1\].g_col\[0\].pe__2490_ g_row\[1\].g_col\[0\].pe__2490_/A g_row\[1\].g_col\[0\].pe__2490_/B
+ VGND VGND VPWR VPWR g_row\[1\].g_col\[0\].pe__2571_/A sky130_fd_sc_hd__nor2_2
Xg_row\[1\].g_col\[0\].pe__1441_ g_row\[1\].g_col\[0\].pe__1733_/A g_row\[1\].g_col\[0\].pe__1441_/B
+ VGND VGND VPWR VPWR g_row\[1\].g_col\[0\].pe__1442_/B sky130_fd_sc_hd__xor2_2
Xg_row\[1\].g_col\[0\].pe__1372_ place1257/X _276_/Q VGND VGND VPWR VPWR g_row\[1\].g_col\[0\].pe__2684_/B
+ sky130_fd_sc_hd__and2_2
XFILLER_91_810 VGND VGND VPWR VPWR sky130_fd_sc_hd__fill_1
XFILLER_63_534 VGND VGND VPWR VPWR sky130_fd_sc_hd__fill_2
XFILLER_16_483 VGND VGND VPWR VPWR sky130_fd_sc_hd__fill_2
XFILLER_44_770 VGND VGND VPWR VPWR sky130_fd_sc_hd__fill_1
XTAP_TAPCELL_ROW_18_478 VGND VPWR sky130_fd_sc_hd__tapvpwrvgnd_1
XFILLER_31_475 VGND VGND VPWR VPWR sky130_fd_sc_hd__fill_1
XFILLER_8_671 VGND VGND VPWR VPWR sky130_fd_sc_hd__decap_3
Xg_row\[0\].g_col\[0\].pe__2002_ g_row\[0\].g_col\[0\].pe__2002_/A g_row\[0\].g_col\[0\].pe__2002_/B
+ VGND VGND VPWR VPWR g_row\[0\].g_col\[0\].pe__2013_/B sky130_fd_sc_hd__xnor2_2
Xg_row\[1\].g_col\[1\].pe__1724_ g_row\[1\].g_col\[1\].pe__1718_/B g_row\[1\].g_col\[1\].pe__2250_/A
+ g_row\[1\].g_col\[1\].pe__1724_/S VGND VGND VPWR VPWR g_row\[1\].g_col\[1\].pe__1745_/A
+ sky130_fd_sc_hd__mux2_1
Xg_row\[1\].g_col\[0\].pe__2757_ clkbuf_leaf_58_clk/X g_row\[1\].g_col\[0\].pe__2757_/D
+ VGND VGND VPWR VPWR g_row\[1\].g_col\[0\].pe__2757_/Q sky130_fd_sc_hd__dfxtp_2
Xg_row\[1\].g_col\[0\].pe__2688_ g_row\[1\].g_col\[0\].pe__2736_/Q g_row\[1\].g_col\[0\].pe__2737_/Q
+ g_row\[1\].g_col\[0\].pe__2688_/CIN VGND VGND VPWR VPWR g_row\[1\].g_col\[0\].pe__2388_/B
+ g_row\[1\].g_col\[0\].pe__1901_/A2 sky130_fd_sc_hd__fa_1
Xg_row\[1\].g_col\[0\].pe__1708_ g_row\[1\].g_col\[0\].pe__1709_/A g_row\[1\].g_col\[0\].pe__1709_/B
+ VGND VGND VPWR VPWR g_row\[1\].g_col\[0\].pe__1714_/A sky130_fd_sc_hd__nand2_2
Xg_row\[1\].g_col\[1\].pe__1655_ g_row\[1\].g_col\[1\].pe__1673_/A g_row\[1\].g_col\[1\].pe__1655_/B
+ VGND VGND VPWR VPWR g_row\[1\].g_col\[1\].pe__1656_/B sky130_fd_sc_hd__xnor2_2
Xg_row\[1\].g_col\[0\].pe__1639_ g_row\[1\].g_col\[0\].pe__1840_/A g_row\[1\].g_col\[0\].pe__1840_/B
+ VGND VGND VPWR VPWR g_row\[1\].g_col\[0\].pe__1834_/A sky130_fd_sc_hd__xnor2_2
Xg_row\[1\].g_col\[1\].pe__1586_ g_row\[1\].g_col\[1\].pe__1634_/A g_row\[1\].g_col\[1\].pe__1634_/B
+ VGND VGND VPWR VPWR g_row\[1\].g_col\[1\].pe__1587_/B sky130_fd_sc_hd__xnor2_2
XFILLER_66_361 VGND VGND VPWR VPWR sky130_fd_sc_hd__decap_3
Xg_row\[0\].g_col\[0\].pe__2766_ clkbuf_leaf_53_clk/X g_row\[0\].g_col\[0\].pe__2766_/D
+ VGND VGND VPWR VPWR g_row\[0\].g_col\[0\].pe__2766_/Q sky130_fd_sc_hd__dfxtp_2
Xg_row\[1\].g_col\[0\].pe_hold1772 g_row\[1\].g_col\[0\].pe__2626_/X VGND VGND VPWR
+ VPWR g_row\[1\].g_col\[0\].pe__2701_/D sky130_fd_sc_hd__clkbuf_2
Xg_row\[1\].g_col\[0\].pe_hold1761 g_row\[1\].g_col\[0\].pe_hold2222/X VGND VGND VPWR
+ VPWR g_row\[1\].g_col\[0\].pe__2398_/A sky130_fd_sc_hd__clkbuf_2
Xg_row\[0\].g_col\[1\].pe__1802_ g_row\[0\].g_col\[1\].pe__2686_/A g_row\[0\].g_col\[1\].pe__1806_/B
+ g_row\[0\].g_col\[1\].pe__1801_/X VGND VGND VPWR VPWR g_row\[0\].g_col\[1\].pe__1807_/B
+ sky130_fd_sc_hd__a21o_2
XFILLER_54_523 VGND VGND VPWR VPWR sky130_fd_sc_hd__decap_3
Xg_row\[0\].g_col\[0\].pe__1717_ g_row\[0\].g_col\[0\].pe__1816_/A g_row\[0\].g_col\[0\].pe__1717_/B
+ VGND VGND VPWR VPWR g_row\[0\].g_col\[0\].pe__1718_/B sky130_fd_sc_hd__xor2_2
Xg_row\[0\].g_col\[1\].pe__1733_ g_row\[0\].g_col\[1\].pe__1789_/A g_row\[0\].g_col\[1\].pe__1733_/B
+ VGND VGND VPWR VPWR g_row\[0\].g_col\[1\].pe__1758_/B sky130_fd_sc_hd__xor2_2
XTAP_TAPCELL_ROW_37_765 VGND VPWR sky130_fd_sc_hd__tapvpwrvgnd_1
Xg_row\[0\].g_col\[0\].pe__2697_ _287_/CLK g_row\[0\].g_col\[0\].pe__2697_/D VGND
+ VGND VPWR VPWR place1208/A sky130_fd_sc_hd__dfxtp_2
Xg_row\[0\].g_col\[0\].pe__1648_ g_row\[0\].g_col\[0\].pe__1648_/A g_row\[0\].g_col\[0\].pe__1648_/B
+ VGND VGND VPWR VPWR g_row\[0\].g_col\[0\].pe__1648_/X sky130_fd_sc_hd__and2_2
Xg_row\[0\].g_col\[1\].pe__1664_ g_row\[0\].g_col\[1\].pe__1664_/A g_row\[0\].g_col\[1\].pe__1659_/A
+ VGND VGND VPWR VPWR g_row\[0\].g_col\[1\].pe__1664_/X sky130_fd_sc_hd__or2b_2
Xg_row\[1\].g_col\[1\].pe__2207_ g_row\[1\].g_col\[1\].pe__2207_/A g_row\[1\].g_col\[1\].pe__2207_/B
+ VGND VGND VPWR VPWR g_row\[1\].g_col\[1\].pe__2210_/A sky130_fd_sc_hd__nand2_2
Xg_row\[0\].g_col\[0\].pe__1579_ g_row\[0\].g_col\[0\].pe__1579_/A g_row\[0\].g_col\[0\].pe__1579_/B
+ VGND VGND VPWR VPWR g_row\[0\].g_col\[0\].pe__1630_/B sky130_fd_sc_hd__xor2_2
Xg_row\[0\].g_col\[1\].pe__1595_ g_row\[0\].g_col\[1\].pe__1591_/A g_row\[0\].g_col\[1\].pe__1593_/Y
+ g_row\[0\].g_col\[1\].pe__1594_/Y VGND VGND VPWR VPWR g_row\[0\].g_col\[1\].pe__1844_/A
+ sky130_fd_sc_hd__o21ai_2
Xg_row\[1\].g_col\[1\].pe__2138_ g_row\[1\].g_col\[1\].pe__2177_/B2 g_row\[1\].g_col\[1\].pe__2177_/A2
+ g_row\[1\].g_col\[1\].pe__2177_/B1 g_row\[1\].g_col\[1\].pe__2138_/B2 VGND VGND
+ VPWR VPWR g_row\[1\].g_col\[1\].pe__2174_/A sky130_fd_sc_hd__a22o_2
XFILLER_50_784 VGND VGND VPWR VPWR sky130_fd_sc_hd__decap_3
Xg_row\[1\].g_col\[1\].pe__2069_ g_row\[1\].g_col\[1\].pe__2058_/A g_row\[1\].g_col\[1\].pe__2058_/B
+ g_row\[1\].g_col\[1\].pe__2068_/Y VGND VGND VPWR VPWR g_row\[1\].g_col\[1\].pe__2117_/A
+ sky130_fd_sc_hd__o21ba_2
Xg_row\[0\].g_col\[1\].pe__2216_ g_row\[0\].g_col\[1\].pe__2625_/B g_row\[0\].g_col\[1\].pe__1504_/Y
+ g_row\[0\].g_col\[1\].pe__2216_/B1 g_row\[0\].g_col\[1\].pe__2241_/A1 VGND VGND
+ VPWR VPWR g_row\[0\].g_col\[1\].pe__2217_/B sky130_fd_sc_hd__a22o_2
XTAP_TAPCELL_ROW_75_1328 VGND VPWR sky130_fd_sc_hd__tapvpwrvgnd_1
XTAP_TAPCELL_ROW_75_1339 VGND VPWR sky130_fd_sc_hd__tapvpwrvgnd_1
Xg_row\[0\].g_col\[1\].pe__2147_ g_row\[0\].g_col\[1\].pe__2147_/A g_row\[0\].g_col\[1\].pe__2147_/B
+ VGND VGND VPWR VPWR g_row\[0\].g_col\[1\].pe__2162_/B sky130_fd_sc_hd__xor2_2
XFILLER_78_25 VGND VGND VPWR VPWR sky130_fd_sc_hd__decap_3
Xg_row\[0\].g_col\[1\].pe__2078_ g_row\[0\].g_col\[1\].pe__2078_/A g_row\[0\].g_col\[1\].pe__2078_/B
+ VGND VGND VPWR VPWR g_row\[0\].g_col\[1\].pe__2101_/A sky130_fd_sc_hd__xnor2_2
XFILLER_78_69 VGND VGND VPWR VPWR sky130_fd_sc_hd__decap_3
XFILLER_89_453 VGND VGND VPWR VPWR sky130_fd_sc_hd__fill_1
XFILLER_18_704 VGND VGND VPWR VPWR sky130_fd_sc_hd__decap_3
XFILLER_18_726 VGND VGND VPWR VPWR sky130_fd_sc_hd__decap_3
XFILLER_57_372 VGND VGND VPWR VPWR sky130_fd_sc_hd__fill_1
XTAP_TAPCELL_ROW_15_437 VGND VPWR sky130_fd_sc_hd__tapvpwrvgnd_1
Xg_row\[0\].g_col\[0\].pe_hold1804 g_row\[0\].g_col\[0\].pe_hold2961/X VGND VGND VPWR
+ VPWR g_row\[0\].g_col\[0\].pe__2398_/A sky130_fd_sc_hd__clkbuf_2
Xg_row\[0\].g_col\[0\].pe_hold1837 g_row\[0\].g_col\[0\].pe__2011_/Y VGND VGND VPWR
+ VPWR g_row\[0\].g_col\[0\].pe__2742_/D sky130_fd_sc_hd__clkbuf_2
Xg_row\[1\].g_col\[0\].pe__1990_ g_row\[1\].g_col\[0\].pe__1988_/X g_row\[1\].g_col\[0\].pe__1987_/Y
+ g_row\[1\].g_col\[0\].pe__1981_/Y g_row\[1\].g_col\[0\].pe__1980_/X g_row\[1\].g_col\[0\].pe__1919_/B
+ VGND VGND VPWR VPWR g_row\[1\].g_col\[0\].pe__1991_/D sky130_fd_sc_hd__o2111ai_2
XFILLER_9_479 VGND VGND VPWR VPWR sky130_fd_sc_hd__fill_1
XFILLER_5_641 VGND VGND VPWR VPWR sky130_fd_sc_hd__decap_3
Xinput1292 hold3469/X VGND VGND VPWR VPWR hold3470/A sky130_fd_sc_hd__buf_2
Xg_row\[1\].g_col\[0\].pe__2611_ g_row\[1\].g_col\[0\].pe__2626_/A1 g_row\[1\].g_col\[0\].pe__2611_/A2
+ g_row\[1\].g_col\[0\].pe__2626_/B1 g_row\[1\].g_col\[0\].pe__2610_/X VGND VGND VPWR
+ VPWR g_row\[1\].g_col\[0\].pe__2611_/X sky130_fd_sc_hd__o211a_2
XFILLER_4_44 VGND VGND VPWR VPWR sky130_fd_sc_hd__fill_1
Xg_row\[1\].g_col\[0\].pe__2542_ g_row\[1\].g_col\[0\].pe__2561_/A g_row\[1\].g_col\[0\].pe__2542_/B
+ VGND VGND VPWR VPWR g_row\[1\].g_col\[0\].pe__2760_/D sky130_fd_sc_hd__and2_2
Xg_row\[1\].g_col\[0\].pe__2473_ g_row\[1\].g_col\[0\].pe__2491_/B g_row\[1\].g_col\[0\].pe__2505_/A
+ g_row\[1\].g_col\[0\].pe__2491_/A VGND VGND VPWR VPWR g_row\[1\].g_col\[0\].pe__2492_/A
+ sky130_fd_sc_hd__o21ai_2
XFILLER_67_147 VGND VGND VPWR VPWR sky130_fd_sc_hd__fill_1
Xg_row\[1\].g_col\[1\].pe__1440_ g_row\[1\].g_col\[1\].pe__1704_/A2 g_row\[1\].g_col\[1\].pe__1732_/A2
+ g_row\[1\].g_col\[1\].pe__1732_/B1 g_row\[1\].g_col\[1\].pe__2614_/B VGND VGND VPWR
+ VPWR g_row\[1\].g_col\[1\].pe__1441_/B sky130_fd_sc_hd__a22o_2
Xg_row\[1\].g_col\[0\].pe__1424_ g_row\[1\].g_col\[0\].pe__1424_/A g_row\[1\].g_col\[0\].pe__1424_/B
+ VGND VGND VPWR VPWR g_row\[1\].g_col\[0\].pe__1424_/Y sky130_fd_sc_hd__nand2_2
XFILLER_67_169 VGND VGND VPWR VPWR sky130_fd_sc_hd__fill_1
Xg_row\[1\].g_col\[1\].pe__1371_ g_row\[1\].g_col\[1\].pe__2424_/A g_row\[1\].g_col\[1\].pe__1371_/B
+ VGND VGND VPWR VPWR output1413/A sky130_fd_sc_hd__xnor2_2
XFILLER_48_383 VGND VGND VPWR VPWR sky130_fd_sc_hd__decap_3
XFILLER_76_681 VGND VGND VPWR VPWR sky130_fd_sc_hd__decap_3
XFILLER_91_640 VGND VGND VPWR VPWR sky130_fd_sc_hd__decap_3
Xg_row\[1\].g_col\[0\].pe__1355_ g_row\[1\].g_col\[0\].pe__2763_/Q g_row\[1\].g_col\[0\].pe__1355_/B
+ VGND VGND VPWR VPWR output1387/A sky130_fd_sc_hd__xor2_2
XFILLER_24_707 VGND VGND VPWR VPWR sky130_fd_sc_hd__decap_3
Xg_row\[0\].g_col\[0\].pe__2551_ g_row\[0\].g_col\[0\].pe__2551_/A g_row\[0\].g_col\[0\].pe__2551_/B
+ g_row\[0\].g_col\[0\].pe__2551_/C VGND VGND VPWR VPWR g_row\[0\].g_col\[0\].pe__2551_/Y
+ sky130_fd_sc_hd__nand3_2
XTAP_TAPCELL_ROW_34_713 VGND VPWR sky130_fd_sc_hd__tapvpwrvgnd_1
XTAP_TAPCELL_ROW_34_724 VGND VPWR sky130_fd_sc_hd__tapvpwrvgnd_1
Xg_row\[0\].g_col\[0\].pe__1502_ g_row\[0\].g_col\[0\].pe__2735_/Q g_row\[0\].g_col\[0\].pe__2734_/Q
+ VGND VGND VPWR VPWR g_row\[0\].g_col\[0\].pe__1504_/A sky130_fd_sc_hd__and2_2
Xg_row\[0\].g_col\[0\].pe__2482_ g_row\[0\].g_col\[0\].pe__2494_/A g_row\[0\].g_col\[0\].pe__2482_/B
+ VGND VGND VPWR VPWR g_row\[0\].g_col\[0\].pe__2508_/B sky130_fd_sc_hd__nor2_2
Xg_row\[0\].g_col\[1\].pe__1380_ g_row\[0\].g_col\[1\].pe__1380_/A1 g_row\[0\].g_col\[1\].pe__2686_/B
+ g_row\[0\].g_col\[1\].pe__1376_/X g_row\[0\].g_col\[1\].pe__2687_/C1 VGND VGND VPWR
+ VPWR g_row\[0\].g_col\[1\].pe__1380_/X sky130_fd_sc_hd__o211a_2
Xg_row\[0\].g_col\[0\].pe__1364_ g_row\[0\].g_col\[0\].pe__2768_/Q VGND VGND VPWR
+ VPWR g_row\[0\].g_col\[0\].pe__2478_/A sky130_fd_sc_hd__inv_2
Xg_row\[0\].g_col\[0\].pe_place819 g_row\[0\].g_col\[0\].pe__2517_/Y VGND VGND VPWR
+ VPWR g_row\[0\].g_col\[0\].pe__2591_/B1 sky130_fd_sc_hd__buf_6
Xg_row\[0\].g_col\[1\].pe__2001_ g_row\[0\].g_col\[1\].pe__2014_/B g_row\[0\].g_col\[1\].pe__2001_/B
+ VGND VGND VPWR VPWR g_row\[0\].g_col\[1\].pe__2002_/B sky130_fd_sc_hd__xnor2_2
XTAP_TAPCELL_ROW_57_1058 VGND VPWR sky130_fd_sc_hd__tapvpwrvgnd_1
XTAP_TAPCELL_ROW_57_1069 VGND VPWR sky130_fd_sc_hd__tapvpwrvgnd_1
XFILLER_59_604 VGND VGND VPWR VPWR sky130_fd_sc_hd__decap_3
Xg_row\[1\].g_col\[1\].pe__2756_ _303_/CLK g_row\[1\].g_col\[1\].pe__2756_/D VGND
+ VGND VPWR VPWR g_row\[1\].g_col\[1\].pe__2775_/A sky130_fd_sc_hd__dfxtp_2
XFILLER_59_626 VGND VGND VPWR VPWR sky130_fd_sc_hd__decap_3
Xg_row\[1\].g_col\[1\].pe__2687_ hold2139/X g_row\[1\].g_col\[1\].pe__2680_/B g_row\[1\].g_col\[1\].pe__2686_/X
+ g_row\[1\].g_col\[1\].pe__2687_/C1 VGND VGND VPWR VPWR g_row\[1\].g_col\[1\].pe__2687_/X
+ sky130_fd_sc_hd__o211a_2
Xg_row\[1\].g_col\[1\].pe__1707_ g_row\[1\].g_col\[1\].pe__1730_/A g_row\[1\].g_col\[1\].pe__1707_/B
+ VGND VGND VPWR VPWR g_row\[1\].g_col\[1\].pe__1709_/B sky130_fd_sc_hd__xor2_2
XTAP_TAPCELL_ROW_70_1258 VGND VPWR sky130_fd_sc_hd__tapvpwrvgnd_1
Xg_row\[1\].g_col\[1\].pe__1638_ g_row\[1\].g_col\[1\].pe__1844_/A g_row\[1\].g_col\[1\].pe__1844_/B
+ VGND VGND VPWR VPWR g_row\[1\].g_col\[1\].pe__1840_/B sky130_fd_sc_hd__xnor2_2
XFILLER_39_361 VGND VGND VPWR VPWR sky130_fd_sc_hd__decap_3
XFILLER_67_692 VGND VGND VPWR VPWR sky130_fd_sc_hd__fill_1
Xg_row\[1\].g_col\[1\].pe_place884 g_row\[1\].g_col\[1\].pe__2163_/B VGND VGND VPWR
+ VPWR g_row\[1\].g_col\[1\].pe__1715_/B sky130_fd_sc_hd__buf_6
Xg_row\[1\].g_col\[1\].pe__1569_ g_row\[1\].g_col\[1\].pe__2019_/B2 g_row\[1\].g_col\[1\].pe__1657_/B
+ g_row\[1\].g_col\[1\].pe__1613_/B1 g_row\[1\].g_col\[1\].pe__1957_/B2 VGND VGND
+ VPWR VPWR g_row\[1\].g_col\[1\].pe__1570_/B sky130_fd_sc_hd__a22o_2
XFILLER_70_813 VGND VGND VPWR VPWR sky130_fd_sc_hd__fill_1
Xg_row\[0\].g_col\[0\].pe__2749_ _314_/CLK g_row\[0\].g_col\[0\].pe__2749_/D VGND
+ VGND VPWR VPWR g_row\[0\].g_col\[0\].pe__2749_/Q sky130_fd_sc_hd__dfxtp_2
Xg_row\[1\].g_col\[1\].pe_place895 g_row\[1\].g_col\[1\].pe__1808_/A VGND VGND VPWR
+ VPWR g_row\[1\].g_col\[1\].pe__1728_/A sky130_fd_sc_hd__buf_6
Xg_row\[0\].g_col\[1\].pe__2765_ clkbuf_leaf_3_clk/X g_row\[0\].g_col\[1\].pe__2765_/D
+ VGND VGND VPWR VPWR g_row\[0\].g_col\[1\].pe__2765_/Q sky130_fd_sc_hd__dfxtp_2
XFILLER_27_589 VGND VGND VPWR VPWR sky130_fd_sc_hd__decap_3
Xg_row\[0\].g_col\[1\].pe__1716_ g_row\[0\].g_col\[1\].pe__1799_/A2 g_row\[0\].g_col\[1\].pe__1748_/B
+ g_row\[0\].g_col\[1\].pe__1738_/B1 g_row\[0\].g_col\[1\].pe__1805_/A2 VGND VGND
+ VPWR VPWR g_row\[0\].g_col\[1\].pe__1717_/B sky130_fd_sc_hd__a22o_2
Xg_row\[0\].g_col\[1\].pe__2696_ clkbuf_leaf_6_clk/X g_row\[0\].g_col\[1\].pe__2696_/D
+ VGND VGND VPWR VPWR g_row\[0\].g_col\[1\].pe__2696_/Q sky130_fd_sc_hd__dfxtp_2
XTAP_TAPCELL_ROW_85_1490 VGND VPWR sky130_fd_sc_hd__tapvpwrvgnd_1
Xg_row\[0\].g_col\[1\].pe__1647_ g_row\[0\].g_col\[1\].pe__1789_/A g_row\[0\].g_col\[1\].pe__1647_/B
+ VGND VGND VPWR VPWR g_row\[0\].g_col\[1\].pe__1688_/B sky130_fd_sc_hd__xor2_2
Xg_row\[0\].g_col\[1\].pe_hold1978 _332_/Q VGND VGND VPWR VPWR g_row\[0\].g_col\[1\].pe__1387_/A
+ sky130_fd_sc_hd__clkbuf_2
Xg_row\[0\].g_col\[1\].pe__1578_ g_row\[0\].g_col\[1\].pe__1624_/A g_row\[0\].g_col\[1\].pe__1578_/B
+ VGND VGND VPWR VPWR g_row\[0\].g_col\[1\].pe__1579_/B sky130_fd_sc_hd__xor2_2
XFILLER_10_445 VGND VGND VPWR VPWR sky130_fd_sc_hd__decap_3
XFILLER_2_633 VGND VGND VPWR VPWR sky130_fd_sc_hd__fill_1
XFILLER_37_309 VGND VGND VPWR VPWR sky130_fd_sc_hd__decap_3
XFILLER_49_169 VGND VGND VPWR VPWR sky130_fd_sc_hd__fill_1
XFILLER_65_607 VGND VGND VPWR VPWR sky130_fd_sc_hd__decap_3
XFILLER_65_629 VGND VGND VPWR VPWR sky130_fd_sc_hd__decap_3
XFILLER_18_578 VGND VGND VPWR VPWR sky130_fd_sc_hd__fill_2
XFILLER_18_589 VGND VGND VPWR VPWR sky130_fd_sc_hd__decap_3
XFILLER_73_673 VGND VGND VPWR VPWR sky130_fd_sc_hd__decap_3
Xg_row\[0\].g_col\[0\].pe_hold3014 g_row\[0\].g_col\[0\].pe__2737_/Q VGND VGND VPWR
+ VPWR g_row\[0\].g_col\[0\].pe_hold3014/X sky130_fd_sc_hd__clkbuf_2
XFILLER_33_548 VGND VGND VPWR VPWR sky130_fd_sc_hd__decap_3
Xg_row\[0\].g_col\[0\].pe_hold2302 g_row\[0\].g_col\[0\].pe_hold2897/X VGND VGND VPWR
+ VPWR g_row\[0\].g_col\[0\].pe_hold2898/A sky130_fd_sc_hd__clkbuf_2
Xg_row\[0\].g_col\[0\].pe_hold2313 g_row\[0\].g_col\[0\].pe__1387_/A VGND VGND VPWR
+ VPWR g_row\[0\].g_col\[0\].pe__2656_/A2 sky130_fd_sc_hd__clkbuf_2
Xg_row\[0\].g_col\[0\].pe_hold2324 g_row\[0\].g_col\[0\].pe__2631_/X VGND VGND VPWR
+ VPWR g_row\[0\].g_col\[0\].pe__2703_/D sky130_fd_sc_hd__clkbuf_2
Xg_row\[0\].g_col\[0\].pe_hold2368 g_row\[0\].g_col\[0\].pe__2514_/Y VGND VGND VPWR
+ VPWR g_row\[0\].g_col\[0\].pe__2756_/D sky130_fd_sc_hd__clkbuf_2
Xg_row\[0\].g_col\[1\].pe_place938 g_row\[0\].g_col\[1\].pe__2215_/B1 VGND VGND VPWR
+ VPWR g_row\[0\].g_col\[1\].pe__2388_/B sky130_fd_sc_hd__buf_6
Xg_row\[0\].g_col\[1\].pe_place949 g_row\[0\].g_col\[1\].pe__2165_/A VGND VGND VPWR
+ VPWR g_row\[0\].g_col\[1\].pe__2123_/A sky130_fd_sc_hd__buf_6
Xclkload13 _288_/CLK VGND VGND VPWR VPWR clkload13/X sky130_fd_sc_hd__clkbuf_8
Xg_row\[1\].g_col\[0\].pe__1973_ g_row\[1\].g_col\[0\].pe__1972_/B g_row\[1\].g_col\[0\].pe__1972_/C
+ g_row\[1\].g_col\[0\].pe__2085_/A VGND VGND VPWR VPWR g_row\[1\].g_col\[0\].pe__1974_/D
+ sky130_fd_sc_hd__a21o_2
XPHY_EDGE_ROW_10_Left_104 VGND VGND VPWR VPWR sky130_fd_sc_hd__decap_3
Xoutput1404 output1404/A VGND VGND VPWR VPWR results_flat[54] sky130_fd_sc_hd__buf_2
Xoutput1415 output1415/A VGND VGND VPWR VPWR results_flat[6] sky130_fd_sc_hd__buf_2
XFILLER_48_3 VGND VGND VPWR VPWR sky130_fd_sc_hd__decap_3
Xhold3509 hold3509/A VGND VGND VPWR VPWR hold3509/X sky130_fd_sc_hd__clkbuf_2
Xg_row\[1\].g_col\[1\].pe__2610_ g_row\[1\].g_col\[1\].pe__2639_/A g_row\[1\].g_col\[1\].pe__2610_/B
+ VGND VGND VPWR VPWR g_row\[1\].g_col\[1\].pe__2610_/X sky130_fd_sc_hd__or2_2
Xg_row\[0\].g_col\[0\].pe__1982_ g_row\[0\].g_col\[0\].pe__2632_/B g_row\[0\].g_col\[0\].pe__1982_/B
+ VGND VGND VPWR VPWR g_row\[0\].g_col\[0\].pe__1985_/B sky130_fd_sc_hd__nand2_2
Xhold2808 _201_/Y VGND VGND VPWR VPWR hold2808/X sky130_fd_sc_hd__clkbuf_2
Xg_row\[1\].g_col\[1\].pe__2541_ g_row\[1\].g_col\[1\].pe__2541_/A1 g_row\[1\].g_col\[1\].pe__2591_/A2
+ g_row\[1\].g_col\[1\].pe__2517_/Y g_row\[1\].g_col\[1\].pe__2540_/X VGND VGND VPWR
+ VPWR g_row\[1\].g_col\[1\].pe__2542_/B sky130_fd_sc_hd__a22o_2
Xg_row\[1\].g_col\[0\].pe__2525_ g_row\[1\].g_col\[0\].pe__2526_/A g_row\[1\].g_col\[0\].pe__2526_/B
+ VGND VGND VPWR VPWR g_row\[1\].g_col\[0\].pe__2525_/Y sky130_fd_sc_hd__nand2_2
XFILLER_28_309 VGND VGND VPWR VPWR sky130_fd_sc_hd__fill_2
Xg_row\[1\].g_col\[1\].pe__2472_ g_row\[1\].g_col\[1\].pe__2765_/Q g_row\[1\].g_col\[1\].pe__2472_/B
+ VGND VGND VPWR VPWR g_row\[1\].g_col\[1\].pe__2491_/A sky130_fd_sc_hd__xnor2_2
Xg_row\[1\].g_col\[0\].pe__2456_ g_row\[1\].g_col\[0\].pe__2457_/B g_row\[1\].g_col\[0\].pe__2758_/Q
+ VGND VGND VPWR VPWR g_row\[1\].g_col\[0\].pe__2458_/A sky130_fd_sc_hd__and2b_2
XFILLER_37_821 VGND VGND VPWR VPWR sky130_fd_sc_hd__decap_3
Xg_row\[1\].g_col\[1\].pe_place1001 g_row\[1\].g_col\[1\].pe__1348_/A VGND VGND VPWR
+ VPWR g_row\[1\].g_col\[1\].pe__2776_/A sky130_fd_sc_hd__buf_6
Xg_row\[1\].g_col\[1\].pe_place1012 g_row\[1\].g_col\[1\].pe__2728_/Q VGND VGND VPWR
+ VPWR g_row\[1\].g_col\[1\].pe__2094_/A sky130_fd_sc_hd__buf_6
Xg_row\[1\].g_col\[1\].pe__1423_ g_row\[1\].g_col\[1\].pe__2726_/Q g_row\[1\].g_col\[1\].pe__2727_/Q
+ g_row\[1\].g_col\[1\].pe__2094_/A VGND VGND VPWR VPWR g_row\[1\].g_col\[1\].pe__1424_/B
+ sky130_fd_sc_hd__or3b_4
Xg_row\[1\].g_col\[0\].pe__2387_ g_row\[1\].g_col\[0\].pe__2387_/A g_row\[1\].g_col\[0\].pe__2387_/B
+ VGND VGND VPWR VPWR g_row\[1\].g_col\[0\].pe__2391_/A sky130_fd_sc_hd__nand2_2
Xg_row\[1\].g_col\[0\].pe__1407_ _274_/Q g_row\[1\].g_col\[0\].pe__2157_/A g_row\[1\].g_col\[0\].pe__2404_/A1
+ g_row\[1\].g_col\[0\].pe__2404_/B1 VGND VGND VPWR VPWR g_row\[1\].g_col\[0\].pe__1407_/X
+ sky130_fd_sc_hd__o2bb2a_2
XFILLER_36_353 VGND VGND VPWR VPWR sky130_fd_sc_hd__fill_2
Xg_row\[0\].g_col\[0\].pe__2603_ g_row\[0\].g_col\[0\].pe__2639_/A hold2363/X VGND
+ VGND VPWR VPWR g_row\[0\].g_col\[0\].pe__2603_/X sky130_fd_sc_hd__or2_2
Xg_row\[1\].g_col\[1\].pe_place1023 g_row\[1\].g_col\[1\].pe__2083_/A VGND VGND VPWR
+ VPWR g_row\[1\].g_col\[1\].pe__2340_/B2 sky130_fd_sc_hd__buf_6
Xg_row\[1\].g_col\[1\].pe_place1034 g_row\[1\].g_col\[1\].pe__2697_/Q VGND VGND VPWR
+ VPWR g_row\[1\].g_col\[1\].pe__1704_/A2 sky130_fd_sc_hd__buf_6
Xg_row\[1\].g_col\[1\].pe_place1045 g_row\[1\].g_col\[1\].pe__1805_/A2 VGND VGND VPWR
+ VPWR g_row\[1\].g_col\[1\].pe__1853_/B2 sky130_fd_sc_hd__buf_6
Xg_row\[1\].g_col\[1\].pe__1354_ g_row\[1\].g_col\[1\].pe__2771_/Q g_row\[1\].g_col\[1\].pe__2762_/Q
+ g_row\[1\].g_col\[1\].pe__1353_/B VGND VGND VPWR VPWR g_row\[1\].g_col\[1\].pe__1355_/B
+ sky130_fd_sc_hd__a21o_2
XFILLER_52_813 VGND VGND VPWR VPWR sky130_fd_sc_hd__fill_1
Xg_row\[0\].g_col\[0\].pe__2534_ g_row\[0\].g_col\[0\].pe__2559_/A g_row\[0\].g_col\[0\].pe__2534_/B
+ g_row\[0\].g_col\[0\].pe__2534_/C VGND VGND VPWR VPWR g_row\[0\].g_col\[0\].pe__2534_/X
+ sky130_fd_sc_hd__or3_2
Xg_row\[1\].g_col\[1\].pe_place1056 g_row\[1\].g_col\[1\].pe__2592_/A VGND VGND VPWR
+ VPWR g_row\[1\].g_col\[1\].pe__2569_/A sky130_fd_sc_hd__buf_6
XFILLER_51_356 VGND VGND VPWR VPWR sky130_fd_sc_hd__decap_3
Xg_row\[0\].g_col\[1\].pe__1501_ g_row\[0\].g_col\[1\].pe__1501_/A g_row\[0\].g_col\[1\].pe__1510_/B
+ VGND VGND VPWR VPWR g_row\[0\].g_col\[1\].pe__1640_/A sky130_fd_sc_hd__xnor2_2
Xg_row\[0\].g_col\[1\].pe__2481_ g_row\[0\].g_col\[1\].pe__2494_/B g_row\[0\].g_col\[1\].pe__2585_/A
+ VGND VGND VPWR VPWR g_row\[0\].g_col\[1\].pe__2482_/B sky130_fd_sc_hd__nor2_2
XFILLER_51_367 VGND VGND VPWR VPWR sky130_fd_sc_hd__decap_3
Xg_row\[0\].g_col\[0\].pe__2465_ g_row\[0\].g_col\[0\].pe__2526_/A g_row\[0\].g_col\[0\].pe__2526_/B
+ g_row\[0\].g_col\[0\].pe__2464_/X g_row\[0\].g_col\[0\].pe__2458_/A VGND VGND VPWR
+ VPWR g_row\[0\].g_col\[0\].pe__2538_/C sky130_fd_sc_hd__a211o_2
Xg_row\[0\].g_col\[1\].pe__1432_ g_row\[0\].g_col\[1\].pe__1728_/A g_row\[0\].g_col\[1\].pe__1432_/B
+ VGND VGND VPWR VPWR g_row\[0\].g_col\[1\].pe__1481_/A sky130_fd_sc_hd__xnor2_2
XFILLER_32_581 VGND VGND VPWR VPWR sky130_fd_sc_hd__fill_2
Xg_row\[0\].g_col\[0\].pe__1416_ g_row\[0\].g_col\[0\].pe__2725_/Q g_row\[0\].g_col\[0\].pe__2045_/B
+ VGND VGND VPWR VPWR g_row\[0\].g_col\[0\].pe__1416_/X sky130_fd_sc_hd__xor2_2
Xg_row\[0\].g_col\[0\].pe__2396_ _165_/A g_row\[0\].g_col\[0\].pe__2396_/B VGND VGND
+ VPWR VPWR g_row\[0\].g_col\[0\].pe__2396_/Y sky130_fd_sc_hd__nor2_8
XFILLER_50_29 VGND VGND VPWR VPWR sky130_fd_sc_hd__decap_3
Xclkload7 clkload7/A VGND VGND VPWR VPWR clkload7/Y sky130_fd_sc_hd__inv_6
Xg_row\[0\].g_col\[0\].pe__1347_ g_row\[0\].g_col\[0\].pe__2759_/Q g_row\[0\].g_col\[0\].pe__2758_/Q
+ g_row\[0\].g_col\[0\].pe__2757_/Q g_row\[0\].g_col\[0\].pe__2775_/A VGND VGND VPWR
+ VPWR g_row\[0\].g_col\[0\].pe__1348_/B sky130_fd_sc_hd__or4_2
Xg_row\[0\].g_col\[0\].pe_hold2891 g_row\[0\].g_col\[0\].pe__2617_/X VGND VGND VPWR
+ VPWR g_row\[0\].g_col\[0\].pe_hold2891/X sky130_fd_sc_hd__clkbuf_2
Xg_row\[0\].g_col\[1\].pe__1363_ g_row\[0\].g_col\[1\].pe__2767_/Q g_row\[0\].g_col\[1\].pe__1363_/B
+ VGND VGND VPWR VPWR output1374/A sky130_fd_sc_hd__xnor2_2
XFILLER_59_27 VGND VGND VPWR VPWR sky130_fd_sc_hd__fill_2
Xg_row\[1\].g_col\[1\].pe__2739_ clkbuf_leaf_72_clk/X g_row\[1\].g_col\[1\].pe__2739_/D
+ VGND VGND VPWR VPWR g_row\[1\].g_col\[1\].pe__2739_/Q sky130_fd_sc_hd__dfxtp_2
XFILLER_86_253 VGND VGND VPWR VPWR sky130_fd_sc_hd__fill_1
Xg_row\[0\].g_col\[1\].pe_hold3111 g_row\[0\].g_col\[1\].pe__2742_/Q VGND VGND VPWR
+ VPWR g_row\[0\].g_col\[1\].pe_hold3111/X sky130_fd_sc_hd__clkbuf_2
XFILLER_55_673 VGND VGND VPWR VPWR sky130_fd_sc_hd__decap_3
Xg_row\[0\].g_col\[1\].pe__2748_ clkbuf_leaf_4_clk/X g_row\[0\].g_col\[1\].pe__2748_/D
+ VGND VGND VPWR VPWR g_row\[0\].g_col\[1\].pe__2748_/Q sky130_fd_sc_hd__dfxtp_2
XFILLER_15_548 VGND VGND VPWR VPWR sky130_fd_sc_hd__fill_2
XFILLER_15_559 VGND VGND VPWR VPWR sky130_fd_sc_hd__fill_1
XFILLER_70_654 VGND VGND VPWR VPWR sky130_fd_sc_hd__fill_1
XTAP_TAPCELL_ROW_83_1449 VGND VPWR sky130_fd_sc_hd__tapvpwrvgnd_1
X_301_ _301_/CLK _301_/D VGND VGND VPWR VPWR _301_/Q sky130_fd_sc_hd__dfxtp_2
Xg_row\[0\].g_col\[1\].pe__2679_ g_row\[0\].g_col\[1\].pe__2679_/A1 g_row\[0\].g_col\[1\].pe__2678_/A
+ g_row\[0\].g_col\[1\].pe__2678_/Y g_row\[0\].g_col\[1\].pe__2679_/C1 VGND VGND VPWR
+ VPWR g_row\[0\].g_col\[1\].pe__2679_/X sky130_fd_sc_hd__o211a_2
XFILLER_11_732 VGND VGND VPWR VPWR sky130_fd_sc_hd__decap_3
XFILLER_11_743 VGND VGND VPWR VPWR sky130_fd_sc_hd__decap_3
XTAP_TAPCELL_ROW_25_587 VGND VPWR sky130_fd_sc_hd__tapvpwrvgnd_1
XFILLER_10_242 VGND VGND VPWR VPWR sky130_fd_sc_hd__fill_2
XFILLER_7_703 VGND VGND VPWR VPWR sky130_fd_sc_hd__decap_3
XFILLER_7_725 VGND VGND VPWR VPWR sky130_fd_sc_hd__decap_3
X_163_ _171_/A _163_/B_N VGND VGND VPWR VPWR _163_/Y sky130_fd_sc_hd__nor2b_4
XFILLER_6_224 VGND VGND VPWR VPWR sky130_fd_sc_hd__fill_1
XFILLER_40_40 VGND VGND VPWR VPWR sky130_fd_sc_hd__decap_3
XFILLER_78_732 VGND VGND VPWR VPWR sky130_fd_sc_hd__decap_3
XFILLER_78_754 VGND VGND VPWR VPWR sky130_fd_sc_hd__fill_2
Xg_row\[1\].g_col\[0\].pe__2310_ g_row\[1\].g_col\[0\].pe__2318_/A g_row\[1\].g_col\[0\].pe__2310_/B
+ g_row\[1\].g_col\[0\].pe__2276_/B VGND VGND VPWR VPWR g_row\[1\].g_col\[0\].pe__2337_/A
+ sky130_fd_sc_hd__or3b_2
XFILLER_37_117 VGND VGND VPWR VPWR sky130_fd_sc_hd__fill_1
XFILLER_77_275 VGND VGND VPWR VPWR sky130_fd_sc_hd__fill_1
XFILLER_93_735 VGND VGND VPWR VPWR sky130_fd_sc_hd__decap_3
XFILLER_93_757 VGND VGND VPWR VPWR sky130_fd_sc_hd__decap_3
XTAP_TAPCELL_ROW_5_290 VGND VPWR sky130_fd_sc_hd__tapvpwrvgnd_1
Xg_row\[1\].g_col\[0\].pe__2241_ place1086/X g_row\[1\].g_col\[0\].pe__2363_/A2 g_row\[1\].g_col\[0\].pe__2388_/B
+ g_row\[1\].g_col\[0\].pe__2241_/B2 VGND VGND VPWR VPWR g_row\[1\].g_col\[0\].pe__2277_/A
+ sky130_fd_sc_hd__a22o_2
Xg_row\[1\].g_col\[0\].pe__2172_ g_row\[1\].g_col\[0\].pe__2172_/A g_row\[1\].g_col\[0\].pe__2172_/B
+ VGND VGND VPWR VPWR g_row\[1\].g_col\[0\].pe__2253_/A sky130_fd_sc_hd__xor2_2
XANTENNA_160 hold2544/X VGND VGND VPWR VPWR sky130_fd_sc_hd__diode_2
XFILLER_45_194 VGND VGND VPWR VPWR sky130_fd_sc_hd__decap_3
Xg_row\[0\].g_col\[0\].pe_hold2110 g_row\[0\].g_col\[0\].pe__2766_/Q VGND VGND VPWR
+ VPWR g_row\[0\].g_col\[0\].pe__2572_/A1 sky130_fd_sc_hd__clkbuf_2
XANTENNA_171 hold3252/X VGND VGND VPWR VPWR sky130_fd_sc_hd__diode_2
XANTENNA_182 ANTENNA_182/DIODE VGND VGND VPWR VPWR sky130_fd_sc_hd__diode_2
XFILLER_21_518 VGND VGND VPWR VPWR sky130_fd_sc_hd__decap_3
XFILLER_61_676 VGND VGND VPWR VPWR sky130_fd_sc_hd__fill_1
XTAP_TAPCELL_ROW_44_863 VGND VPWR sky130_fd_sc_hd__tapvpwrvgnd_1
XTAP_TAPCELL_ROW_44_874 VGND VPWR sky130_fd_sc_hd__tapvpwrvgnd_1
Xg_row\[0\].g_col\[0\].pe_hold2121 g_row\[0\].g_col\[0\].pe__2761_/Q VGND VGND VPWR
+ VPWR g_row\[0\].g_col\[0\].pe__2548_/A1 sky130_fd_sc_hd__clkbuf_2
XFILLER_60_197 VGND VGND VPWR VPWR sky130_fd_sc_hd__fill_2
Xg_row\[0\].g_col\[0\].pe__2250_ ANTENNA_182/DIODE g_row\[0\].g_col\[0\].pe__2250_/B
+ VGND VGND VPWR VPWR g_row\[0\].g_col\[0\].pe__2251_/B sky130_fd_sc_hd__nand2_2
Xg_row\[0\].g_col\[0\].pe_hold2154 g_row\[0\].g_col\[0\].pe__2564_/X VGND VGND VPWR
+ VPWR g_row\[0\].g_col\[0\].pe__2565_/B sky130_fd_sc_hd__clkbuf_2
Xg_row\[0\].g_col\[0\].pe_hold2165 g_row\[0\].g_col\[0\].pe_hold2981/X VGND VGND VPWR
+ VPWR g_row\[0\].g_col\[0\].pe__1396_/A sky130_fd_sc_hd__clkbuf_2
Xg_row\[0\].g_col\[0\].pe__2181_ g_row\[0\].g_col\[0\].pe__2181_/A g_row\[0\].g_col\[0\].pe__2181_/B
+ VGND VGND VPWR VPWR g_row\[0\].g_col\[0\].pe__2182_/B sky130_fd_sc_hd__xor2_2
Xg_row\[1\].g_col\[1\].pe__1972_ g_row\[1\].g_col\[1\].pe__2085_/A g_row\[1\].g_col\[1\].pe__1972_/B
+ g_row\[1\].g_col\[1\].pe__1972_/C VGND VGND VPWR VPWR g_row\[1\].g_col\[1\].pe__1974_/C
+ sky130_fd_sc_hd__nand3_2
Xg_row\[1\].g_col\[0\].pe__1956_ g_row\[1\].g_col\[0\].pe__1916_/A g_row\[1\].g_col\[0\].pe__1916_/B
+ g_row\[1\].g_col\[0\].pe__1955_/X VGND VGND VPWR VPWR g_row\[1\].g_col\[0\].pe__1963_/A
+ sky130_fd_sc_hd__a21o_2
XPHY_EDGE_ROW_49_Right_49 VGND VGND VPWR VPWR sky130_fd_sc_hd__decap_3
XTAP_TAPCELL_ROW_54_1017 VGND VPWR sky130_fd_sc_hd__tapvpwrvgnd_1
Xhold3306 hold3306/A VGND VGND VPWR VPWR hold3306/X sky130_fd_sc_hd__clkbuf_2
Xg_row\[1\].g_col\[0\].pe__1887_ g_row\[1\].g_col\[0\].pe__1888_/A g_row\[1\].g_col\[0\].pe__1888_/B
+ g_row\[1\].g_col\[0\].pe__1888_/C VGND VGND VPWR VPWR g_row\[1\].g_col\[0\].pe__1951_/A
+ sky130_fd_sc_hd__o21a_2
Xhold3317 hold3317/A VGND VGND VPWR VPWR hold3317/X sky130_fd_sc_hd__clkbuf_2
Xhold3328 hold3328/A VGND VGND VPWR VPWR hold3328/X sky130_fd_sc_hd__clkbuf_2
Xhold3339 hold3339/A VGND VGND VPWR VPWR hold3339/X sky130_fd_sc_hd__clkbuf_2
Xhold2605 hold2605/A VGND VGND VPWR VPWR _298_/D sky130_fd_sc_hd__clkbuf_2
Xhold2616 _167_/Y VGND VGND VPWR VPWR hold2616/X sky130_fd_sc_hd__clkbuf_2
Xhold2627 hold3409/X VGND VGND VPWR VPWR _227_/B_N sky130_fd_sc_hd__clkbuf_2
Xhold2638 hold3456/X VGND VGND VPWR VPWR hold3457/A sky130_fd_sc_hd__clkbuf_2
XFILLER_68_253 VGND VGND VPWR VPWR sky130_fd_sc_hd__fill_1
Xg_row\[0\].g_col\[0\].pe__1965_ hold2359/A g_row\[0\].g_col\[0\].pe__2026_/B VGND
+ VGND VPWR VPWR g_row\[0\].g_col\[0\].pe__1968_/B sky130_fd_sc_hd__nand2_2
Xhold2649 hold3370/X VGND VGND VPWR VPWR hold3371/A sky130_fd_sc_hd__clkbuf_2
Xg_row\[1\].g_col\[0\].pe__2508_ g_row\[1\].g_col\[0\].pe__2508_/A g_row\[1\].g_col\[0\].pe__2508_/B
+ VGND VGND VPWR VPWR g_row\[1\].g_col\[0\].pe__2508_/Y sky130_fd_sc_hd__xnor2_2
Xg_row\[0\].g_col\[1\].pe__1981_ g_row\[0\].g_col\[1\].pe__2725_/Q g_row\[0\].g_col\[1\].pe__2045_/B
+ g_row\[0\].g_col\[1\].pe__2163_/A VGND VGND VPWR VPWR g_row\[0\].g_col\[1\].pe__1981_/Y
+ sky130_fd_sc_hd__nand3_2
XFILLER_83_223 VGND VGND VPWR VPWR sky130_fd_sc_hd__fill_1
XTAP_TAPCELL_ROW_3_249 VGND VPWR sky130_fd_sc_hd__tapvpwrvgnd_1
Xg_row\[0\].g_col\[0\].pe__1896_ g_row\[0\].g_col\[0\].pe__1896_/A g_row\[0\].g_col\[0\].pe__1885_/A
+ VGND VGND VPWR VPWR g_row\[0\].g_col\[0\].pe__1941_/A sky130_fd_sc_hd__or2b_2
Xg_row\[1\].g_col\[1\].pe__2455_ g_row\[1\].g_col\[1\].pe__2455_/A g_row\[1\].g_col\[1\].pe__2455_/B
+ VGND VGND VPWR VPWR g_row\[1\].g_col\[1\].pe__2457_/B sky130_fd_sc_hd__xnor2_2
Xg_row\[1\].g_col\[0\].pe__2439_ g_row\[1\].g_col\[0\].pe__2439_/A g_row\[1\].g_col\[0\].pe__2439_/B
+ VGND VGND VPWR VPWR g_row\[1\].g_col\[0\].pe__2439_/Y sky130_fd_sc_hd__xnor2_2
XPHY_EDGE_ROW_58_Right_58 VGND VGND VPWR VPWR sky130_fd_sc_hd__decap_3
Xg_row\[1\].g_col\[1\].pe__1406_ g_row\[1\].g_col\[1\].pe__1406_/A VGND VGND VPWR
+ VPWR g_row\[1\].g_col\[1\].pe__1406_/Y sky130_fd_sc_hd__inv_2
Xg_row\[1\].g_col\[1\].pe__2386_ g_row\[1\].g_col\[1\].pe__2386_/A g_row\[1\].g_col\[1\].pe__2372_/A
+ VGND VGND VPWR VPWR g_row\[1\].g_col\[1\].pe__2387_/B sky130_fd_sc_hd__or2b_2
XFILLER_36_194 VGND VGND VPWR VPWR sky130_fd_sc_hd__fill_2
XFILLER_52_632 VGND VGND VPWR VPWR sky130_fd_sc_hd__decap_3
XFILLER_64_481 VGND VGND VPWR VPWR sky130_fd_sc_hd__fill_2
Xg_row\[0\].g_col\[1\].pe__2533_ g_row\[0\].g_col\[1\].pe__2533_/A g_row\[0\].g_col\[1\].pe__2533_/B
+ VGND VGND VPWR VPWR g_row\[0\].g_col\[1\].pe__2534_/C sky130_fd_sc_hd__and2_2
XTAP_TAPCELL_ROW_65_1179 VGND VPWR sky130_fd_sc_hd__tapvpwrvgnd_1
Xg_row\[0\].g_col\[0\].pe__2517_ g_row\[0\].g_col\[0\].pe__2510_/X g_row\[0\].g_col\[0\].pe__2516_/X
+ g_row\[0\].g_col\[0\].pe__2403_/Y g_row\[0\].g_col\[0\].pe__2010_/A VGND VGND VPWR
+ VPWR g_row\[0\].g_col\[0\].pe__2517_/Y sky130_fd_sc_hd__a211oi_2
Xg_row\[0\].g_col\[0\].pe__2448_ g_row\[0\].g_col\[0\].pe__2743_/Q VGND VGND VPWR
+ VPWR g_row\[0\].g_col\[0\].pe__2451_/A sky130_fd_sc_hd__inv_2
Xg_row\[0\].g_col\[1\].pe__2464_ g_row\[0\].g_col\[1\].pe__2759_/Q g_row\[0\].g_col\[1\].pe__2464_/B
+ VGND VGND VPWR VPWR g_row\[0\].g_col\[1\].pe__2464_/X sky130_fd_sc_hd__and2_2
XTAP_TAPCELL_ROW_22_535 VGND VPWR sky130_fd_sc_hd__tapvpwrvgnd_1
XTAP_TAPCELL_ROW_22_546 VGND VPWR sky130_fd_sc_hd__tapvpwrvgnd_1
Xg_row\[0\].g_col\[1\].pe__1415_ g_row\[0\].g_col\[1\].pe__2725_/Q g_row\[0\].g_col\[1\].pe__2724_/Q
+ g_row\[0\].g_col\[1\].pe__2686_/A VGND VGND VPWR VPWR g_row\[0\].g_col\[1\].pe__1415_/Y
+ sky130_fd_sc_hd__o21ai_2
Xg_row\[0\].g_col\[1\].pe__2395_ place1248/X g_row\[0\].g_col\[1\].pe__2395_/A2 g_row\[0\].g_col\[1\].pe__2393_/Y
+ g_row\[0\].g_col\[1\].pe__2394_/X VGND VGND VPWR VPWR g_row\[0\].g_col\[1\].pe__2396_/B
+ sky130_fd_sc_hd__o22a_4
XFILLER_20_584 VGND VGND VPWR VPWR sky130_fd_sc_hd__decap_3
Xg_row\[0\].g_col\[0\].pe__2379_ g_row\[0\].g_col\[0\].pe__2356_/A g_row\[0\].g_col\[0\].pe__2375_/B
+ g_row\[0\].g_col\[0\].pe__2394_/B1 VGND VGND VPWR VPWR g_row\[0\].g_col\[0\].pe__2379_/Y
+ sky130_fd_sc_hd__a21oi_2
Xg_row\[0\].g_col\[1\].pe__1346_ g_row\[0\].g_col\[1\].pe__2759_/Q g_row\[0\].g_col\[1\].pe__1346_/B
+ VGND VGND VPWR VPWR output1365/A sky130_fd_sc_hd__xor2_2
XPHY_EDGE_ROW_67_Right_67 VGND VGND VPWR VPWR sky130_fd_sc_hd__decap_3
XFILLER_10_98 VGND VGND VPWR VPWR sky130_fd_sc_hd__fill_1
XFILLER_59_286 VGND VGND VPWR VPWR sky130_fd_sc_hd__fill_1
XFILLER_74_212 VGND VGND VPWR VPWR sky130_fd_sc_hd__fill_1
XPHY_EDGE_ROW_76_Right_76 VGND VGND VPWR VPWR sky130_fd_sc_hd__decap_3
XFILLER_28_673 VGND VGND VPWR VPWR sky130_fd_sc_hd__fill_2
XFILLER_34_109 VGND VGND VPWR VPWR sky130_fd_sc_hd__fill_1
XFILLER_55_470 VGND VGND VPWR VPWR sky130_fd_sc_hd__decap_3
XFILLER_43_643 VGND VGND VPWR VPWR sky130_fd_sc_hd__fill_1
XFILLER_42_197 VGND VGND VPWR VPWR sky130_fd_sc_hd__fill_2
XTAP_TAPCELL_ROW_41_822 VGND VPWR sky130_fd_sc_hd__tapvpwrvgnd_1
XPHY_EDGE_ROW_85_Right_85 VGND VGND VPWR VPWR sky130_fd_sc_hd__decap_3
X_215_ _235_/A _215_/B_N VGND VGND VPWR VPWR _215_/Y sky130_fd_sc_hd__nor2b_4
XFILLER_51_94 VGND VGND VPWR VPWR sky130_fd_sc_hd__fill_1
Xg_row\[1\].g_col\[0\].pe__1810_ g_row\[1\].g_col\[0\].pe__1811_/A g_row\[1\].g_col\[0\].pe__1811_/B
+ g_row\[1\].g_col\[0\].pe__1803_/Y g_row\[1\].g_col\[0\].pe__1808_/X g_row\[1\].g_col\[0\].pe__1809_/X
+ VGND VGND VPWR VPWR g_row\[1\].g_col\[0\].pe__1810_/X sky130_fd_sc_hd__o41a_2
Xg_row\[1\].g_col\[0\].pe__1741_ g_row\[1\].g_col\[0\].pe__1776_/A g_row\[1\].g_col\[0\].pe__1776_/B
+ g_row\[1\].g_col\[0\].pe__1740_/Y VGND VGND VPWR VPWR g_row\[1\].g_col\[0\].pe__1815_/B
+ sky130_fd_sc_hd__a21oi_2
Xg_row\[0\].g_col\[0\].pe_place980 g_row\[0\].g_col\[0\].pe__2163_/B VGND VGND VPWR
+ VPWR g_row\[0\].g_col\[0\].pe__1715_/B sky130_fd_sc_hd__buf_6
Xg_row\[0\].g_col\[0\].pe_place991 g_row\[0\].g_col\[0\].pe__1808_/A VGND VGND VPWR
+ VPWR g_row\[0\].g_col\[0\].pe__1705_/A sky130_fd_sc_hd__buf_6
Xg_row\[1\].g_col\[0\].pe__1672_ place1104/A g_row\[1\].g_col\[0\].pe__1715_/B g_row\[1\].g_col\[0\].pe__1863_/B1
+ place1106/X VGND VGND VPWR VPWR g_row\[1\].g_col\[0\].pe__1673_/B sky130_fd_sc_hd__a22o_2
XFILLER_3_783 VGND VGND VPWR VPWR sky130_fd_sc_hd__fill_1
XFILLER_3_794 VGND VGND VPWR VPWR sky130_fd_sc_hd__fill_2
XFILLER_78_551 VGND VGND VPWR VPWR sky130_fd_sc_hd__decap_3
Xg_row\[1\].g_col\[0\].pe_hold2847 g_row\[1\].g_col\[0\].pe__2651_/X VGND VGND VPWR
+ VPWR g_row\[1\].g_col\[0\].pe__2652_/C1 sky130_fd_sc_hd__clkbuf_2
Xg_row\[1\].g_col\[0\].pe_hold2836 g_row\[1\].g_col\[0\].pe__2654_/X VGND VGND VPWR
+ VPWR g_row\[1\].g_col\[0\].pe_hold2836/X sky130_fd_sc_hd__clkbuf_2
Xg_row\[0\].g_col\[0\].pe__1750_ g_row\[0\].g_col\[0\].pe__1808_/A g_row\[0\].g_col\[0\].pe__1750_/B
+ VGND VGND VPWR VPWR g_row\[0\].g_col\[0\].pe__1756_/A sky130_fd_sc_hd__xnor2_2
Xg_row\[1\].g_col\[0\].pe_hold2858 g_row\[1\].g_col\[0\].pe__2720_/Q VGND VGND VPWR
+ VPWR g_row\[1\].g_col\[0\].pe__2669_/B sky130_fd_sc_hd__clkbuf_2
XFILLER_19_651 VGND VGND VPWR VPWR sky130_fd_sc_hd__decap_3
XFILLER_66_757 VGND VGND VPWR VPWR sky130_fd_sc_hd__fill_1
XTAP_TAPCELL_ROW_0_208 VGND VPWR sky130_fd_sc_hd__tapvpwrvgnd_1
XTAP_TAPCELL_ROW_49_944 VGND VPWR sky130_fd_sc_hd__tapvpwrvgnd_1
Xg_row\[1\].g_col\[1\].pe__2240_ g_row\[1\].g_col\[1\].pe__2207_/B g_row\[1\].g_col\[1\].pe__2210_/B
+ g_row\[1\].g_col\[1\].pe__2207_/A VGND VGND VPWR VPWR g_row\[1\].g_col\[1\].pe__2288_/A
+ sky130_fd_sc_hd__a21bo_2
XFILLER_34_610 VGND VGND VPWR VPWR sky130_fd_sc_hd__fill_1
XFILLER_93_576 VGND VGND VPWR VPWR sky130_fd_sc_hd__fill_2
Xg_row\[0\].g_col\[0\].pe__1681_ place1212/X g_row\[0\].g_col\[0\].pe__1784_/A2 g_row\[0\].g_col\[0\].pe__1784_/A3
+ g_row\[0\].g_col\[0\].pe__1801_/B place1209/X VGND VGND VPWR VPWR g_row\[0\].g_col\[0\].pe__1682_/B
+ sky130_fd_sc_hd__a32o_2
Xg_row\[1\].g_col\[0\].pe__2224_ g_row\[1\].g_col\[0\].pe__2258_/A g_row\[1\].g_col\[0\].pe__2258_/B
+ VGND VGND VPWR VPWR g_row\[1\].g_col\[0\].pe__2226_/A sky130_fd_sc_hd__xor2_2
XFILLER_34_621 VGND VGND VPWR VPWR sky130_fd_sc_hd__decap_3
XFILLER_46_492 VGND VGND VPWR VPWR sky130_fd_sc_hd__decap_3
Xg_row\[1\].g_col\[1\].pe__2171_ g_row\[1\].g_col\[1\].pe__2209_/A g_row\[1\].g_col\[1\].pe__2171_/B
+ VGND VGND VPWR VPWR g_row\[1\].g_col\[1\].pe__2172_/B sky130_fd_sc_hd__xnor2_2
Xg_row\[1\].g_col\[0\].pe__2155_ g_row\[1\].g_col\[0\].pe__2200_/A g_row\[1\].g_col\[0\].pe__2155_/B
+ g_row\[1\].g_col\[0\].pe__2300_/A VGND VGND VPWR VPWR g_row\[1\].g_col\[0\].pe__2155_/X
+ sky130_fd_sc_hd__and3_2
XFILLER_21_337 VGND VGND VPWR VPWR sky130_fd_sc_hd__fill_2
Xg_row\[0\].g_col\[0\].pe__2302_ g_row\[0\].g_col\[0\].pe__2238_/X g_row\[0\].g_col\[0\].pe__2263_/B
+ g_row\[0\].g_col\[0\].pe__2261_/Y VGND VGND VPWR VPWR g_row\[0\].g_col\[0\].pe__2302_/Y
+ sky130_fd_sc_hd__a21oi_2
Xg_row\[1\].g_col\[0\].pe__2086_ g_row\[1\].g_col\[0\].pe__2085_/B g_row\[1\].g_col\[0\].pe__2085_/C
+ g_row\[1\].g_col\[0\].pe__2085_/A VGND VGND VPWR VPWR g_row\[1\].g_col\[0\].pe__2087_/D
+ sky130_fd_sc_hd__a21o_2
Xg_row\[0\].g_col\[0\].pe__2233_ g_row\[0\].g_col\[0\].pe__2233_/A g_row\[0\].g_col\[0\].pe__2298_/A
+ g_row\[0\].g_col\[0\].pe__2233_/C VGND VGND VPWR VPWR g_row\[0\].g_col\[0\].pe__2233_/X
+ sky130_fd_sc_hd__and3_2
Xg_row\[0\].g_col\[0\].pe__2164_ g_row\[0\].g_col\[0\].pe__1461_/A g_row\[0\].g_col\[0\].pe__1461_/B
+ g_row\[0\].g_col\[0\].pe__1983_/Y VGND VGND VPWR VPWR g_row\[0\].g_col\[0\].pe__2165_/C
+ sky130_fd_sc_hd__a21o_2
Xg_row\[0\].g_col\[1\].pe__2180_ g_row\[0\].g_col\[1\].pe__2213_/A g_row\[0\].g_col\[1\].pe__2213_/B
+ VGND VGND VPWR VPWR g_row\[0\].g_col\[1\].pe__2181_/B sky130_fd_sc_hd__xor2_2
Xg_row\[0\].g_col\[0\].pe__2095_ g_row\[0\].g_col\[0\].pe__2184_/C g_row\[0\].g_col\[0\].pe__2095_/B
+ VGND VGND VPWR VPWR g_row\[0\].g_col\[0\].pe__2097_/A sky130_fd_sc_hd__nand2_2
Xg_row\[1\].g_col\[1\].pe__1955_ g_row\[1\].g_col\[1\].pe__1955_/A g_row\[1\].g_col\[1\].pe__1955_/B
+ VGND VGND VPWR VPWR g_row\[1\].g_col\[1\].pe__1955_/X sky130_fd_sc_hd__and2_2
Xg_row\[1\].g_col\[1\].pe_hold1709 g_row\[1\].g_col\[1\].pe__2236_/X VGND VGND VPWR
+ VPWR g_row\[1\].g_col\[1\].pe__2237_/B sky130_fd_sc_hd__clkbuf_2
Xg_row\[1\].g_col\[0\].pe__1939_ g_row\[1\].g_col\[0\].pe__1939_/A g_row\[1\].g_col\[0\].pe__1939_/B
+ VGND VGND VPWR VPWR g_row\[1\].g_col\[0\].pe__1941_/C sky130_fd_sc_hd__xnor2_2
Xhold3114 hold3114/A VGND VGND VPWR VPWR hold3114/X sky130_fd_sc_hd__clkbuf_2
Xg_row\[1\].g_col\[1\].pe__1886_ g_row\[1\].g_col\[1\].pe__1886_/A g_row\[1\].g_col\[1\].pe__1897_/B
+ VGND VGND VPWR VPWR g_row\[1\].g_col\[1\].pe__1888_/C sky130_fd_sc_hd__xnor2_2
Xhold2413 hold2413/A VGND VGND VPWR VPWR _338_/D sky130_fd_sc_hd__clkbuf_2
Xhold3136 hold3136/A VGND VGND VPWR VPWR hold3136/X sky130_fd_sc_hd__clkbuf_2
Xhold3147 hold3147/A VGND VGND VPWR VPWR hold3147/X sky130_fd_sc_hd__clkbuf_2
Xhold3158 a_inputs_flat[7] VGND VGND VPWR VPWR hold3158/X sky130_fd_sc_hd__clkbuf_2
Xhold2424 _171_/Y VGND VGND VPWR VPWR hold2424/X sky130_fd_sc_hd__clkbuf_2
Xhold2435 hold3171/X VGND VGND VPWR VPWR _249_/B_N sky130_fd_sc_hd__clkbuf_2
Xhold2446 hold3155/X VGND VGND VPWR VPWR hold3156/A sky130_fd_sc_hd__clkbuf_2
Xhold3169 hold3169/A VGND VGND VPWR VPWR hold3169/X sky130_fd_sc_hd__clkbuf_2
XFILLER_69_595 VGND VGND VPWR VPWR sky130_fd_sc_hd__decap_3
XFILLER_84_510 VGND VGND VPWR VPWR sky130_fd_sc_hd__decap_3
Xhold2457 hold3188/X VGND VGND VPWR VPWR hold3189/A sky130_fd_sc_hd__clkbuf_2
Xhold2468 hold3200/X VGND VGND VPWR VPWR hold3201/A sky130_fd_sc_hd__clkbuf_2
Xhold2479 hold2479/A VGND VGND VPWR VPWR _316_/D sky130_fd_sc_hd__clkbuf_2
Xg_row\[1\].g_col\[1\].pe__2507_ g_row\[1\].g_col\[1\].pe__2575_/A g_row\[1\].g_col\[1\].pe__2507_/B
+ VGND VGND VPWR VPWR g_row\[1\].g_col\[1\].pe__2507_/Y sky130_fd_sc_hd__nor2_2
Xg_row\[0\].g_col\[1\].pe__1964_ g_row\[0\].g_col\[1\].pe__1964_/A g_row\[0\].g_col\[1\].pe__1964_/B
+ VGND VGND VPWR VPWR g_row\[0\].g_col\[1\].pe__1997_/A sky130_fd_sc_hd__xnor2_2
Xg_row\[0\].g_col\[0\].pe__1948_ place1269/X g_row\[0\].g_col\[0\].pe__1948_/B VGND
+ VGND VPWR VPWR g_row\[0\].g_col\[0\].pe__2741_/D sky130_fd_sc_hd__nor2_2
Xhold1778 hold2978/X VGND VGND VPWR VPWR hold1778/X sky130_fd_sc_hd__clkbuf_2
XFILLER_72_727 VGND VGND VPWR VPWR sky130_fd_sc_hd__fill_2
XTAP_TAPCELL_ROW_27_616 VGND VPWR sky130_fd_sc_hd__tapvpwrvgnd_1
XTAP_TAPCELL_ROW_67_1208 VGND VPWR sky130_fd_sc_hd__tapvpwrvgnd_1
XTAP_TAPCELL_ROW_67_1219 VGND VPWR sky130_fd_sc_hd__tapvpwrvgnd_1
Xg_row\[0\].g_col\[0\].pe__1879_ g_row\[0\].g_col\[0\].pe__1879_/A g_row\[0\].g_col\[0\].pe__1879_/B
+ VGND VGND VPWR VPWR g_row\[0\].g_col\[0\].pe__1879_/Y sky130_fd_sc_hd__nor2_2
Xg_row\[1\].g_col\[1\].pe__2438_ g_row\[1\].g_col\[1\].pe__2764_/Q g_row\[1\].g_col\[1\].pe__2438_/B
+ VGND VGND VPWR VPWR g_row\[1\].g_col\[1\].pe__2471_/A sky130_fd_sc_hd__xnor2_2
Xg_row\[0\].g_col\[1\].pe__1895_ g_row\[0\].g_col\[1\].pe__1843_/A g_row\[0\].g_col\[1\].pe__1843_/B
+ g_row\[0\].g_col\[1\].pe__1891_/B VGND VGND VPWR VPWR g_row\[0\].g_col\[1\].pe__1895_/X
+ sky130_fd_sc_hd__a21bo_2
XFILLER_25_643 VGND VGND VPWR VPWR sky130_fd_sc_hd__decap_3
Xg_row\[1\].g_col\[1\].pe__2369_ g_row\[1\].g_col\[1\].pe__2368_/A g_row\[1\].g_col\[1\].pe__2368_/B
+ g_row\[1\].g_col\[1\].pe__2367_/X VGND VGND VPWR VPWR g_row\[1\].g_col\[1\].pe__2370_/B
+ sky130_fd_sc_hd__o21bai_2
XFILLER_24_131 VGND VGND VPWR VPWR sky130_fd_sc_hd__fill_1
XFILLER_25_665 VGND VGND VPWR VPWR sky130_fd_sc_hd__fill_2
XFILLER_52_462 VGND VGND VPWR VPWR sky130_fd_sc_hd__fill_2
XTAP_TAPCELL_ROW_80_1408 VGND VPWR sky130_fd_sc_hd__tapvpwrvgnd_1
XFILLER_52_473 VGND VGND VPWR VPWR sky130_fd_sc_hd__decap_3
XFILLER_52_495 VGND VGND VPWR VPWR sky130_fd_sc_hd__fill_1
Xg_row\[1\].g_col\[0\].pe_place1261 place1262/X VGND VGND VPWR VPWR g_row\[1\].g_col\[0\].pe__2669_/A
+ sky130_fd_sc_hd__buf_6
Xg_row\[0\].g_col\[1\].pe__2516_ g_row\[0\].g_col\[1\].pe__2503_/B g_row\[0\].g_col\[1\].pe__2516_/B
+ VGND VGND VPWR VPWR g_row\[0\].g_col\[1\].pe__2516_/X sky130_fd_sc_hd__and2b_2
XFILLER_24_197 VGND VGND VPWR VPWR sky130_fd_sc_hd__decap_3
Xg_row\[0\].g_col\[1\].pe__2447_ g_row\[0\].g_col\[1\].pe__2497_/B VGND VGND VPWR
+ VPWR g_row\[0\].g_col\[1\].pe__2551_/B sky130_fd_sc_hd__inv_2
XANTENNA_60 hold3194/A VGND VGND VPWR VPWR sky130_fd_sc_hd__diode_2
XANTENNA_71 _143_/B_N VGND VGND VPWR VPWR sky130_fd_sc_hd__diode_2
XANTENNA_82 hold3238/X VGND VGND VPWR VPWR sky130_fd_sc_hd__diode_2
XANTENNA_93 hold3345/X VGND VGND VPWR VPWR sky130_fd_sc_hd__diode_2
Xg_row\[0\].g_col\[1\].pe__2378_ g_row\[0\].g_col\[1\].pe__2358_/A g_row\[0\].g_col\[1\].pe__2358_/B
+ g_row\[0\].g_col\[1\].pe__2377_/Y VGND VGND VPWR VPWR g_row\[0\].g_col\[1\].pe__2378_/X
+ sky130_fd_sc_hd__a21o_2
Xg_row\[1\].g_col\[1\].pe_hold2933 g_row\[1\].g_col\[1\].pe__2689_/A VGND VGND VPWR
+ VPWR g_row\[1\].g_col\[1\].pe__2680_/A sky130_fd_sc_hd__clkbuf_2
XFILLER_0_753 VGND VGND VPWR VPWR sky130_fd_sc_hd__decap_3
XFILLER_87_370 VGND VGND VPWR VPWR sky130_fd_sc_hd__fill_2
XFILLER_47_234 VGND VGND VPWR VPWR sky130_fd_sc_hd__decap_3
XFILLER_75_587 VGND VGND VPWR VPWR sky130_fd_sc_hd__decap_3
XTAP_TAPCELL_ROW_46_903 VGND VPWR sky130_fd_sc_hd__tapvpwrvgnd_1
XFILLER_56_790 VGND VGND VPWR VPWR sky130_fd_sc_hd__fill_1
XFILLER_30_112 VGND VGND VPWR VPWR sky130_fd_sc_hd__fill_2
XTAP_TAPCELL_ROW_13_398 VGND VPWR sky130_fd_sc_hd__tapvpwrvgnd_1
Xg_row\[1\].g_col\[1\].pe__1740_ g_row\[1\].g_col\[1\].pe__1740_/A g_row\[1\].g_col\[1\].pe__1740_/B
+ VGND VGND VPWR VPWR g_row\[1\].g_col\[1\].pe__1740_/Y sky130_fd_sc_hd__nor2_2
Xg_row\[1\].g_col\[0\].pe__1724_ g_row\[1\].g_col\[0\].pe__1718_/B g_row\[1\].g_col\[0\].pe__2250_/A
+ g_row\[1\].g_col\[0\].pe__1724_/S VGND VGND VPWR VPWR g_row\[1\].g_col\[0\].pe__1745_/A
+ sky130_fd_sc_hd__mux2_1
Xg_row\[1\].g_col\[1\].pe__1671_ g_row\[1\].g_col\[1\].pe__1739_/A g_row\[1\].g_col\[1\].pe__1671_/B
+ VGND VGND VPWR VPWR g_row\[1\].g_col\[1\].pe__1690_/A sky130_fd_sc_hd__xor2_2
Xg_row\[1\].g_col\[0\].pe__1655_ g_row\[1\].g_col\[0\].pe__1864_/A g_row\[1\].g_col\[0\].pe__1655_/B
+ VGND VGND VPWR VPWR g_row\[1\].g_col\[0\].pe__1656_/B sky130_fd_sc_hd__xnor2_2
XFILLER_38_201 VGND VGND VPWR VPWR sky130_fd_sc_hd__fill_2
Xg_row\[0\].g_col\[0\].pe__1802_ g_row\[0\].g_col\[0\].pe__2686_/A g_row\[0\].g_col\[0\].pe__1806_/B
+ g_row\[0\].g_col\[0\].pe__1801_/X VGND VGND VPWR VPWR g_row\[0\].g_col\[0\].pe__1807_/B
+ sky130_fd_sc_hd__a21o_2
Xg_row\[1\].g_col\[0\].pe_hold1921 g_row\[1\].g_col\[0\].pe__2775_/A VGND VGND VPWR
+ VPWR g_row\[1\].g_col\[0\].pe__2513_/A1 sky130_fd_sc_hd__clkbuf_2
Xg_row\[1\].g_col\[0\].pe__1586_ g_row\[1\].g_col\[0\].pe__1634_/A g_row\[1\].g_col\[0\].pe__1634_/B
+ VGND VGND VPWR VPWR g_row\[1\].g_col\[0\].pe__1587_/B sky130_fd_sc_hd__xnor2_2
XFILLER_81_502 VGND VGND VPWR VPWR sky130_fd_sc_hd__fill_2
Xg_row\[0\].g_col\[0\].pe__1733_ g_row\[0\].g_col\[0\].pe__1733_/A g_row\[0\].g_col\[0\].pe__1733_/B
+ VGND VGND VPWR VPWR g_row\[0\].g_col\[0\].pe__1758_/B sky130_fd_sc_hd__xor2_2
XFILLER_19_481 VGND VGND VPWR VPWR sky130_fd_sc_hd__fill_2
XFILLER_81_535 VGND VGND VPWR VPWR sky130_fd_sc_hd__decap_3
Xg_row\[0\].g_col\[0\].pe__1664_ g_row\[0\].g_col\[0\].pe__1664_/A g_row\[0\].g_col\[0\].pe__1659_/A
+ VGND VGND VPWR VPWR g_row\[0\].g_col\[0\].pe__1664_/X sky130_fd_sc_hd__or2b_2
Xg_row\[0\].g_col\[1\].pe__1680_ g_row\[0\].g_col\[1\].pe__1728_/A g_row\[0\].g_col\[1\].pe__1680_/B
+ VGND VGND VPWR VPWR g_row\[0\].g_col\[1\].pe__1686_/A sky130_fd_sc_hd__xnor2_2
Xg_row\[1\].g_col\[1\].pe__2223_ g_row\[1\].g_col\[1\].pe__2183_/A g_row\[1\].g_col\[1\].pe__2183_/B
+ g_row\[1\].g_col\[1\].pe__2222_/X VGND VGND VPWR VPWR g_row\[1\].g_col\[1\].pe__2258_/B
+ sky130_fd_sc_hd__o21ai_2
Xg_row\[1\].g_col\[0\].pe__2207_ g_row\[1\].g_col\[0\].pe__2207_/A g_row\[1\].g_col\[0\].pe__2207_/B
+ VGND VGND VPWR VPWR g_row\[1\].g_col\[0\].pe__2210_/A sky130_fd_sc_hd__nand2_2
XFILLER_34_451 VGND VGND VPWR VPWR sky130_fd_sc_hd__fill_1
Xg_row\[1\].g_col\[1\].pe__2154_ g_row\[1\].g_col\[1\].pe__2062_/C g_row\[1\].g_col\[1\].pe__2150_/X
+ g_row\[1\].g_col\[1\].pe__2153_/X g_row\[1\].g_col\[1\].pe__2111_/A VGND VGND VPWR
+ VPWR g_row\[1\].g_col\[1\].pe__2300_/A sky130_fd_sc_hd__a211oi_2
XFILLER_22_635 VGND VGND VPWR VPWR sky130_fd_sc_hd__decap_3
Xg_row\[0\].g_col\[0\].pe__1595_ g_row\[0\].g_col\[0\].pe__1591_/A g_row\[0\].g_col\[0\].pe__1593_/Y
+ g_row\[0\].g_col\[0\].pe__1594_/Y VGND VGND VPWR VPWR g_row\[0\].g_col\[0\].pe__1844_/A
+ sky130_fd_sc_hd__o21ai_2
Xg_row\[1\].g_col\[0\].pe__2138_ g_row\[1\].g_col\[0\].pe__2616_/B g_row\[1\].g_col\[0\].pe__1558_/B
+ g_row\[1\].g_col\[0\].pe__2177_/B1 place1094/X VGND VGND VPWR VPWR g_row\[1\].g_col\[0\].pe__2174_/A
+ sky130_fd_sc_hd__a22o_2
XFILLER_61_281 VGND VGND VPWR VPWR sky130_fd_sc_hd__fill_2
XTAP_TAPCELL_ROW_62_1138 VGND VPWR sky130_fd_sc_hd__tapvpwrvgnd_1
Xg_row\[1\].g_col\[1\].pe__2085_ g_row\[1\].g_col\[1\].pe__2085_/A g_row\[1\].g_col\[1\].pe__2085_/B
+ g_row\[1\].g_col\[1\].pe__2085_/C VGND VGND VPWR VPWR g_row\[1\].g_col\[1\].pe__2087_/C
+ sky130_fd_sc_hd__nand3_2
Xg_row\[1\].g_col\[0\].pe__2069_ g_row\[1\].g_col\[0\].pe__2058_/A g_row\[1\].g_col\[0\].pe__2058_/B
+ g_row\[1\].g_col\[0\].pe__2068_/Y VGND VGND VPWR VPWR g_row\[1\].g_col\[0\].pe__2117_/A
+ sky130_fd_sc_hd__o21ba_2
Xg_row\[0\].g_col\[1\].pe__2301_ g_row\[0\].g_col\[1\].pe__1894_/Y g_row\[0\].g_col\[1\].pe__1895_/X
+ g_row\[0\].g_col\[1\].pe__2151_/X g_row\[0\].g_col\[1\].pe__2300_/B VGND VGND VPWR
+ VPWR g_row\[0\].g_col\[1\].pe__2304_/B sky130_fd_sc_hd__a211o_4
XTAP_TAPCELL_ROW_32_685 VGND VPWR sky130_fd_sc_hd__tapvpwrvgnd_1
XTAP_TAPCELL_ROW_32_696 VGND VPWR sky130_fd_sc_hd__tapvpwrvgnd_1
Xg_row\[0\].g_col\[0\].pe__2216_ g_row\[0\].g_col\[0\].pe__2030_/A g_row\[0\].g_col\[0\].pe__2279_/A2
+ g_row\[0\].g_col\[0\].pe__2279_/B1 g_row\[0\].g_col\[0\].pe__1970_/A VGND VGND VPWR
+ VPWR g_row\[0\].g_col\[0\].pe__2217_/B sky130_fd_sc_hd__a22o_2
Xg_row\[0\].g_col\[1\].pe__2232_ g_row\[0\].g_col\[1\].pe__2161_/Y g_row\[0\].g_col\[1\].pe__2200_/B
+ g_row\[0\].g_col\[1\].pe__2231_/Y VGND VGND VPWR VPWR g_row\[0\].g_col\[1\].pe__2233_/C
+ sky130_fd_sc_hd__o21a_2
Xg_row\[0\].g_col\[0\].pe__2147_ g_row\[0\].g_col\[0\].pe__2147_/A g_row\[0\].g_col\[0\].pe__2147_/B
+ VGND VGND VPWR VPWR g_row\[0\].g_col\[0\].pe__2162_/B sky130_fd_sc_hd__xor2_2
Xg_row\[0\].g_col\[1\].pe__2163_ g_row\[0\].g_col\[1\].pe__2163_/A g_row\[0\].g_col\[1\].pe__2163_/B
+ VGND VGND VPWR VPWR g_row\[0\].g_col\[1\].pe__2165_/B sky130_fd_sc_hd__nand2_2
Xg_row\[1\].g_col\[1\].pe_hold2207 g_row\[1\].g_col\[1\].pe__2655_/X VGND VGND VPWR
+ VPWR g_row\[1\].g_col\[1\].pe__2656_/C1 sky130_fd_sc_hd__clkbuf_2
XTAP_TAPCELL_ROW_77_1370 VGND VPWR sky130_fd_sc_hd__tapvpwrvgnd_1
Xg_row\[0\].g_col\[0\].pe__2078_ g_row\[0\].g_col\[0\].pe__2078_/A g_row\[0\].g_col\[0\].pe__2078_/B
+ VGND VGND VPWR VPWR g_row\[0\].g_col\[0\].pe__2101_/A sky130_fd_sc_hd__xnor2_2
Xg_row\[1\].g_col\[1\].pe__1938_ g_row\[1\].g_col\[1\].pe__1938_/A g_row\[1\].g_col\[1\].pe__1952_/A
+ VGND VGND VPWR VPWR g_row\[1\].g_col\[1\].pe__1939_/B sky130_fd_sc_hd__xnor2_2
Xg_row\[0\].g_col\[1\].pe__2094_ g_row\[0\].g_col\[1\].pe__2094_/A g_row\[0\].g_col\[1\].pe__2094_/B
+ g_row\[0\].g_col\[1\].pe__2094_/C VGND VGND VPWR VPWR g_row\[0\].g_col\[1\].pe__2095_/B
+ sky130_fd_sc_hd__nand3_2
Xg_row\[1\].g_col\[1\].pe__1869_ g_row\[1\].g_col\[1\].pe__2703_/Q g_row\[1\].g_col\[1\].pe__1414_/X
+ g_row\[1\].g_col\[1\].pe__1415_/Y g_row\[1\].g_col\[1\].pe__1920_/A2 g_row\[1\].g_col\[1\].pe__2704_/Q
+ VGND VGND VPWR VPWR g_row\[1\].g_col\[1\].pe__1870_/B sky130_fd_sc_hd__a32o_2
XFILLER_29_223 VGND VGND VPWR VPWR sky130_fd_sc_hd__fill_1
XFILLER_85_841 VGND VGND VPWR VPWR sky130_fd_sc_hd__fill_1
Xhold1520 hold3268/X VGND VGND VPWR VPWR hold3269/A sky130_fd_sc_hd__clkbuf_2
Xhold1531 hold3404/X VGND VGND VPWR VPWR hold3405/A sky130_fd_sc_hd__clkbuf_2
Xhold1542 hold2640/X VGND VGND VPWR VPWR hold2641/A sky130_fd_sc_hd__clkbuf_2
Xhold1553 hold3422/X VGND VGND VPWR VPWR hold3423/A sky130_fd_sc_hd__clkbuf_2
Xhold1564 hold3425/X VGND VGND VPWR VPWR hold3426/A sky130_fd_sc_hd__clkbuf_2
Xhold1575 hold2688/X VGND VGND VPWR VPWR hold2689/A sky130_fd_sc_hd__clkbuf_2
Xhold1586 hold3499/X VGND VGND VPWR VPWR hold3500/A sky130_fd_sc_hd__clkbuf_2
Xg_row\[0\].g_col\[1\].pe__1947_ g_row\[0\].g_col\[1\].pe__1944_/Y g_row\[0\].g_col\[1\].pe__2008_/A
+ g_row\[0\].g_col\[1\].pe__1947_/B1 g_row\[0\].g_col\[1\].pe__2663_/A VGND VGND VPWR
+ VPWR g_row\[0\].g_col\[1\].pe__1948_/B sky130_fd_sc_hd__o2bb2a_2
XFILLER_57_598 VGND VGND VPWR VPWR sky130_fd_sc_hd__decap_3
Xhold1597 hold3523/X VGND VGND VPWR VPWR hold3524/A sky130_fd_sc_hd__clkbuf_2
Xg_row\[1\].g_col\[0\].pe_place914 g_row\[1\].g_col\[0\].pe__2348_/A VGND VGND VPWR
+ VPWR g_row\[1\].g_col\[0\].pe__2209_/A sky130_fd_sc_hd__buf_6
Xg_row\[0\].g_col\[1\].pe__1878_ g_row\[0\].g_col\[1\].pe__1878_/A g_row\[0\].g_col\[1\].pe__1878_/B
+ VGND VGND VPWR VPWR g_row\[0\].g_col\[1\].pe__1936_/A sky130_fd_sc_hd__xnor2_2
XFILLER_72_579 VGND VGND VPWR VPWR sky130_fd_sc_hd__fill_1
Xg_row\[1\].g_col\[0\].pe_place925 g_row\[1\].g_col\[0\].pe__1414_/X VGND VGND VPWR
+ VPWR g_row\[1\].g_col\[0\].pe__1729_/A2 sky130_fd_sc_hd__buf_6
XFILLER_25_462 VGND VGND VPWR VPWR sky130_fd_sc_hd__decap_3
XFILLER_13_646 VGND VGND VPWR VPWR sky130_fd_sc_hd__decap_3
XFILLER_40_421 VGND VGND VPWR VPWR sky130_fd_sc_hd__fill_2
XFILLER_9_617 VGND VGND VPWR VPWR sky130_fd_sc_hd__decap_3
XFILLER_13_679 VGND VGND VPWR VPWR sky130_fd_sc_hd__decap_3
XTAP_TAPCELL_ROW_51_972 VGND VPWR sky130_fd_sc_hd__tapvpwrvgnd_1
Xg_row\[1\].g_col\[0\].pe_place1091 place1092/A VGND VGND VPWR VPWR g_row\[1\].g_col\[0\].pe__2616_/B
+ sky130_fd_sc_hd__buf_6
XFILLER_32_85 VGND VGND VPWR VPWR sky130_fd_sc_hd__fill_1
XTAP_TAPCELL_ROW_10_357 VGND VPWR sky130_fd_sc_hd__tapvpwrvgnd_1
Xg_row\[0\].g_col\[0\].pe_place1178 g_row\[0\].g_col\[0\].pe__2732_/Q VGND VGND VPWR
+ VPWR ANTENNA_182/DIODE sky130_fd_sc_hd__buf_6
Xg_row\[0\].g_col\[0\].pe_place1189 g_row\[0\].g_col\[0\].pe__2726_/Q VGND VGND VPWR
+ VPWR g_row\[0\].g_col\[0\].pe__2045_/A sky130_fd_sc_hd__buf_6
XFILLER_0_561 VGND VGND VPWR VPWR sky130_fd_sc_hd__fill_1
Xg_row\[1\].g_col\[0\].pe__1440_ place1092/X g_row\[1\].g_col\[0\].pe__1732_/A2 g_row\[1\].g_col\[0\].pe__1732_/B1
+ place1093/X VGND VGND VPWR VPWR g_row\[1\].g_col\[0\].pe__1441_/B sky130_fd_sc_hd__a22o_2
XFILLER_48_521 VGND VGND VPWR VPWR sky130_fd_sc_hd__decap_3
XFILLER_88_690 VGND VGND VPWR VPWR sky130_fd_sc_hd__fill_1
Xg_row\[1\].g_col\[0\].pe__1371_ g_row\[1\].g_col\[0\].pe__2424_/A g_row\[1\].g_col\[0\].pe__1371_/B
+ VGND VGND VPWR VPWR output1395/A sky130_fd_sc_hd__xnor2_2
XFILLER_35_204 VGND VGND VPWR VPWR sky130_fd_sc_hd__fill_1
XFILLER_36_705 VGND VGND VPWR VPWR sky130_fd_sc_hd__decap_3
XFILLER_48_587 VGND VGND VPWR VPWR sky130_fd_sc_hd__fill_1
XFILLER_63_502 VGND VGND VPWR VPWR sky130_fd_sc_hd__fill_2
XFILLER_35_259 VGND VGND VPWR VPWR sky130_fd_sc_hd__decap_3
XFILLER_90_365 VGND VGND VPWR VPWR sky130_fd_sc_hd__decap_3
XFILLER_16_473 VGND VGND VPWR VPWR sky130_fd_sc_hd__decap_3
XTAP_TAPCELL_ROW_18_479 VGND VPWR sky130_fd_sc_hd__tapvpwrvgnd_1
XFILLER_71_590 VGND VGND VPWR VPWR sky130_fd_sc_hd__fill_2
Xg_row\[0\].g_col\[0\].pe__1380_ g_row\[0\].g_col\[0\].pe__1380_/A1 g_row\[0\].g_col\[0\].pe__2684_/B
+ g_row\[0\].g_col\[0\].pe__1376_/X g_row\[0\].g_col\[0\].pe__2640_/C1 VGND VGND VPWR
+ VPWR g_row\[0\].g_col\[0\].pe__1380_/X sky130_fd_sc_hd__o211a_2
XPHY_EDGE_ROW_75_Left_169 VGND VGND VPWR VPWR sky130_fd_sc_hd__decap_3
XFILLER_31_498 VGND VGND VPWR VPWR sky130_fd_sc_hd__decap_3
Xg_row\[0\].g_col\[0\].pe__2001_ g_row\[0\].g_col\[0\].pe__2014_/B g_row\[0\].g_col\[0\].pe__2001_/B
+ VGND VGND VPWR VPWR g_row\[0\].g_col\[0\].pe__2002_/B sky130_fd_sc_hd__xnor2_2
Xg_row\[1\].g_col\[1\].pe__1723_ g_row\[1\].g_col\[1\].pe__1723_/A g_row\[1\].g_col\[1\].pe__1723_/B
+ VGND VGND VPWR VPWR g_row\[1\].g_col\[1\].pe__1745_/B sky130_fd_sc_hd__xor2_2
Xg_row\[1\].g_col\[0\].pe__2756_ clkbuf_leaf_59_clk/X g_row\[1\].g_col\[0\].pe__2756_/D
+ VGND VGND VPWR VPWR g_row\[1\].g_col\[0\].pe__2775_/A sky130_fd_sc_hd__dfxtp_2
XFILLER_86_605 VGND VGND VPWR VPWR sky130_fd_sc_hd__fill_2
Xg_row\[1\].g_col\[0\].pe__2687_ hold2043/X g_row\[1\].g_col\[0\].pe__2680_/B g_row\[1\].g_col\[0\].pe__2686_/X
+ g_row\[1\].g_col\[0\].pe__2687_/C1 VGND VGND VPWR VPWR g_row\[1\].g_col\[0\].pe__2687_/X
+ sky130_fd_sc_hd__o211a_2
Xg_row\[1\].g_col\[0\].pe__1707_ g_row\[1\].g_col\[0\].pe__1730_/A g_row\[1\].g_col\[0\].pe__1707_/B
+ VGND VGND VPWR VPWR g_row\[1\].g_col\[0\].pe__1709_/B sky130_fd_sc_hd__xor2_2
XPHY_EDGE_ROW_84_Left_178 VGND VGND VPWR VPWR sky130_fd_sc_hd__decap_3
Xg_row\[1\].g_col\[1\].pe__1654_ g_row\[1\].g_col\[1\].pe__1901_/B2 g_row\[1\].g_col\[1\].pe__1715_/B
+ g_row\[1\].g_col\[1\].pe__1863_/B1 g_row\[1\].g_col\[1\].pe__1853_/B2 VGND VGND
+ VPWR VPWR g_row\[1\].g_col\[1\].pe__1655_/B sky130_fd_sc_hd__a22o_2
Xg_row\[1\].g_col\[0\].pe__1638_ g_row\[1\].g_col\[0\].pe__1844_/A g_row\[1\].g_col\[0\].pe__1844_/B
+ VGND VGND VPWR VPWR g_row\[1\].g_col\[0\].pe__1840_/B sky130_fd_sc_hd__xnor2_2
XFILLER_67_841 VGND VGND VPWR VPWR sky130_fd_sc_hd__fill_1
Xg_row\[1\].g_col\[1\].pe__1585_ g_row\[1\].g_col\[1\].pe__1533_/A g_row\[1\].g_col\[1\].pe__1533_/B
+ g_row\[1\].g_col\[1\].pe__1584_/Y VGND VGND VPWR VPWR g_row\[1\].g_col\[1\].pe__1634_/B
+ sky130_fd_sc_hd__a21oi_2
Xg_row\[1\].g_col\[0\].pe__1569_ g_row\[1\].g_col\[0\].pe__2610_/B g_row\[1\].g_col\[0\].pe__1657_/B
+ g_row\[1\].g_col\[0\].pe__2036_/B1 place1099/X VGND VGND VPWR VPWR g_row\[1\].g_col\[0\].pe__1570_/B
+ sky130_fd_sc_hd__a22o_2
Xg_row\[0\].g_col\[1\].pe__1801_ g_row\[0\].g_col\[1\].pe__1801_/A g_row\[0\].g_col\[1\].pe__1801_/B
+ g_row\[0\].g_col\[1\].pe__1801_/C VGND VGND VPWR VPWR g_row\[0\].g_col\[1\].pe__1801_/X
+ sky130_fd_sc_hd__and3_2
XFILLER_27_727 VGND VGND VPWR VPWR sky130_fd_sc_hd__fill_1
XFILLER_82_811 VGND VGND VPWR VPWR sky130_fd_sc_hd__fill_1
Xg_row\[0\].g_col\[0\].pe__2765_ clkbuf_leaf_52_clk/X g_row\[0\].g_col\[0\].pe__2765_/D
+ VGND VGND VPWR VPWR g_row\[0\].g_col\[0\].pe__2765_/Q sky130_fd_sc_hd__dfxtp_2
Xg_row\[1\].g_col\[0\].pe_hold1762 g_row\[1\].g_col\[0\].pe__2679_/X VGND VGND VPWR
+ VPWR g_row\[1\].g_col\[0\].pe__2722_/D sky130_fd_sc_hd__clkbuf_2
Xg_row\[0\].g_col\[0\].pe__1716_ place1217/X g_row\[0\].g_col\[0\].pe__1748_/B g_row\[0\].g_col\[0\].pe__1738_/B1
+ place1220/X VGND VGND VPWR VPWR g_row\[0\].g_col\[0\].pe__1717_/B sky130_fd_sc_hd__a22o_2
Xg_row\[0\].g_col\[1\].pe__1732_ g_row\[0\].g_col\[1\].pe__1799_/A2 g_row\[0\].g_col\[1\].pe__1732_/A2
+ g_row\[0\].g_col\[1\].pe__1732_/B1 g_row\[0\].g_col\[1\].pe__1805_/A2 VGND VGND
+ VPWR VPWR g_row\[0\].g_col\[1\].pe__1733_/B sky130_fd_sc_hd__a22o_2
Xg_row\[1\].g_col\[0\].pe_hold1784 g_row\[1\].g_col\[0\].pe_hold2946/X VGND VGND VPWR
+ VPWR g_row\[1\].g_col\[0\].pe_hold2947/A sky130_fd_sc_hd__clkbuf_2
Xg_row\[1\].g_col\[0\].pe_hold1773 g_row\[1\].g_col\[0\].pe__2713_/Q VGND VGND VPWR
+ VPWR g_row\[1\].g_col\[0\].pe__2655_/B sky130_fd_sc_hd__clkbuf_2
XTAP_TAPCELL_ROW_37_766 VGND VPWR sky130_fd_sc_hd__tapvpwrvgnd_1
Xg_row\[0\].g_col\[0\].pe__2696_ _287_/CLK g_row\[0\].g_col\[0\].pe__2696_/D VGND
+ VGND VPWR VPWR place1210/A sky130_fd_sc_hd__dfxtp_2
Xg_row\[0\].g_col\[1\].pe__1663_ g_row\[0\].g_col\[1\].pe__1663_/A g_row\[0\].g_col\[1\].pe__1663_/B
+ VGND VGND VPWR VPWR g_row\[0\].g_col\[1\].pe__1697_/B sky130_fd_sc_hd__xnor2_2
Xg_row\[1\].g_col\[1\].pe__2206_ g_row\[1\].g_col\[1\].pe__2125_/A g_row\[1\].g_col\[1\].pe__2204_/Y
+ g_row\[1\].g_col\[1\].pe__2167_/A g_row\[1\].g_col\[1\].pe__1611_/A VGND VGND VPWR
+ VPWR g_row\[1\].g_col\[1\].pe__2207_/B sky130_fd_sc_hd__o211ai_2
Xg_row\[0\].g_col\[0\].pe__1647_ g_row\[0\].g_col\[0\].pe__1733_/A g_row\[0\].g_col\[0\].pe__1647_/B
+ VGND VGND VPWR VPWR g_row\[0\].g_col\[0\].pe__1688_/B sky130_fd_sc_hd__xor2_2
XPHY_EDGE_ROW_93_Left_187 VGND VGND VPWR VPWR sky130_fd_sc_hd__decap_3
Xg_row\[0\].g_col\[0\].pe__1578_ g_row\[0\].g_col\[0\].pe__1768_/A g_row\[0\].g_col\[0\].pe__1578_/B
+ VGND VGND VPWR VPWR g_row\[0\].g_col\[0\].pe__1579_/B sky130_fd_sc_hd__xor2_2
Xg_row\[0\].g_col\[1\].pe__1594_ g_row\[0\].g_col\[1\].pe__1594_/A g_row\[0\].g_col\[1\].pe__1594_/B
+ VGND VGND VPWR VPWR g_row\[0\].g_col\[1\].pe__1594_/Y sky130_fd_sc_hd__nand2_2
Xg_row\[1\].g_col\[1\].pe__2137_ g_row\[1\].g_col\[1\].pe__2091_/B g_row\[1\].g_col\[1\].pe__2091_/C
+ g_row\[1\].g_col\[1\].pe__2091_/A VGND VGND VPWR VPWR g_row\[1\].g_col\[1\].pe__2142_/A
+ sky130_fd_sc_hd__a21boi_2
Xg_row\[1\].g_col\[1\].pe__2068_ g_row\[1\].g_col\[1\].pe__2068_/A g_row\[1\].g_col\[1\].pe__2068_/B
+ VGND VGND VPWR VPWR g_row\[1\].g_col\[1\].pe__2068_/Y sky130_fd_sc_hd__nor2_2
Xg_row\[0\].g_col\[1\].pe__2215_ g_row\[0\].g_col\[1\].pe__2621_/B g_row\[0\].g_col\[1\].pe__1558_/B
+ g_row\[0\].g_col\[1\].pe__2215_/B1 g_row\[0\].g_col\[1\].pe__2698_/Q VGND VGND VPWR
+ VPWR g_row\[0\].g_col\[1\].pe__2239_/A sky130_fd_sc_hd__a22o_2
XTAP_TAPCELL_ROW_75_1329 VGND VPWR sky130_fd_sc_hd__tapvpwrvgnd_1
Xg_row\[0\].g_col\[1\].pe__2146_ g_row\[0\].g_col\[1\].pe__2192_/A g_row\[0\].g_col\[1\].pe__2192_/B
+ VGND VGND VPWR VPWR g_row\[0\].g_col\[1\].pe__2147_/B sky130_fd_sc_hd__xor2_2
Xg_row\[0\].g_col\[1\].pe__2077_ g_row\[0\].g_col\[1\].pe__2077_/A g_row\[0\].g_col\[1\].pe__2119_/B
+ VGND VGND VPWR VPWR g_row\[0\].g_col\[1\].pe__2078_/B sky130_fd_sc_hd__xnor2_2
XFILLER_49_318 VGND VGND VPWR VPWR sky130_fd_sc_hd__fill_1
XFILLER_57_340 VGND VGND VPWR VPWR sky130_fd_sc_hd__fill_2
Xhold2084 hold3115/X VGND VGND VPWR VPWR hold2084/X sky130_fd_sc_hd__clkbuf_2
XFILLER_18_738 VGND VGND VPWR VPWR sky130_fd_sc_hd__decap_3
XFILLER_85_682 VGND VGND VPWR VPWR sky130_fd_sc_hd__fill_1
XFILLER_72_365 VGND VGND VPWR VPWR sky130_fd_sc_hd__fill_1
XFILLER_32_218 VGND VGND VPWR VPWR sky130_fd_sc_hd__decap_3
XFILLER_60_516 VGND VGND VPWR VPWR sky130_fd_sc_hd__fill_1
XFILLER_13_421 VGND VGND VPWR VPWR sky130_fd_sc_hd__fill_1
XFILLER_53_590 VGND VGND VPWR VPWR sky130_fd_sc_hd__decap_3
XTAP_TAPCELL_ROW_15_438 VGND VPWR sky130_fd_sc_hd__tapvpwrvgnd_1
Xg_row\[0\].g_col\[0\].pe_hold1805 g_row\[0\].g_col\[0\].pe__2679_/X VGND VGND VPWR
+ VPWR g_row\[0\].g_col\[0\].pe__2722_/D sky130_fd_sc_hd__clkbuf_2
XFILLER_40_251 VGND VGND VPWR VPWR sky130_fd_sc_hd__fill_1
XFILLER_41_785 VGND VGND VPWR VPWR sky130_fd_sc_hd__decap_3
XFILLER_5_653 VGND VGND VPWR VPWR sky130_fd_sc_hd__fill_2
Xinput1293 hold3427/X VGND VGND VPWR VPWR hold3428/A sky130_fd_sc_hd__buf_2
Xg_row\[1\].g_col\[0\].pe__2610_ place1246/X g_row\[1\].g_col\[0\].pe__2610_/B VGND
+ VGND VPWR VPWR g_row\[1\].g_col\[0\].pe__2610_/X sky130_fd_sc_hd__or2_2
Xg_row\[1\].g_col\[0\].pe__2541_ g_row\[1\].g_col\[0\].pe__2541_/A1 g_row\[1\].g_col\[0\].pe__2560_/A2
+ g_row\[1\].g_col\[0\].pe__2560_/B1 g_row\[1\].g_col\[0\].pe__2540_/X VGND VGND VPWR
+ VPWR g_row\[1\].g_col\[0\].pe__2542_/B sky130_fd_sc_hd__a22o_2
XFILLER_68_627 VGND VGND VPWR VPWR sky130_fd_sc_hd__decap_3
Xg_row\[1\].g_col\[0\].pe__2472_ g_row\[1\].g_col\[0\].pe__2765_/Q g_row\[1\].g_col\[0\].pe__2472_/B
+ VGND VGND VPWR VPWR g_row\[1\].g_col\[0\].pe__2491_/A sky130_fd_sc_hd__xnor2_2
XFILLER_49_841 VGND VGND VPWR VPWR sky130_fd_sc_hd__fill_1
Xg_row\[1\].g_col\[0\].pe__1423_ g_row\[1\].g_col\[0\].pe__2726_/Q g_row\[1\].g_col\[0\].pe__2727_/Q
+ g_row\[1\].g_col\[0\].pe__1789_/A VGND VGND VPWR VPWR g_row\[1\].g_col\[0\].pe__1424_/B
+ sky130_fd_sc_hd__or3b_4
Xg_row\[1\].g_col\[1\].pe__1370_ g_row\[1\].g_col\[1\].pe__2769_/Q g_row\[1\].g_col\[1\].pe__2768_/Q
+ g_row\[1\].g_col\[1\].pe__1366_/B g_row\[1\].g_col\[1\].pe__2776_/A VGND VGND VPWR
+ VPWR g_row\[1\].g_col\[1\].pe__1371_/B sky130_fd_sc_hd__o31a_2
XFILLER_36_513 VGND VGND VPWR VPWR sky130_fd_sc_hd__decap_3
Xg_row\[1\].g_col\[1\].pe_place1238 place1239/X VGND VGND VPWR VPWR g_row\[1\].g_col\[1\].pe__2669_/A
+ sky130_fd_sc_hd__buf_6
Xg_row\[1\].g_col\[0\].pe__1354_ g_row\[1\].g_col\[0\].pe__2771_/Q g_row\[1\].g_col\[0\].pe__2762_/Q
+ g_row\[1\].g_col\[0\].pe__1353_/B VGND VGND VPWR VPWR g_row\[1\].g_col\[0\].pe__1355_/B
+ sky130_fd_sc_hd__a21o_2
XFILLER_36_546 VGND VGND VPWR VPWR sky130_fd_sc_hd__fill_1
XFILLER_51_505 VGND VGND VPWR VPWR sky130_fd_sc_hd__decap_3
XFILLER_75_192 VGND VGND VPWR VPWR sky130_fd_sc_hd__decap_3
Xg_row\[0\].g_col\[0\].pe__1501_ g_row\[0\].g_col\[0\].pe__1501_/A g_row\[0\].g_col\[0\].pe__1510_/B
+ VGND VGND VPWR VPWR g_row\[0\].g_col\[0\].pe__1640_/A sky130_fd_sc_hd__xnor2_2
XFILLER_23_229 VGND VGND VPWR VPWR sky130_fd_sc_hd__fill_1
XFILLER_63_365 VGND VGND VPWR VPWR sky130_fd_sc_hd__fill_1
XFILLER_91_696 VGND VGND VPWR VPWR sky130_fd_sc_hd__decap_3
XTAP_TAPCELL_ROW_34_714 VGND VPWR sky130_fd_sc_hd__tapvpwrvgnd_1
XTAP_TAPCELL_ROW_34_725 VGND VPWR sky130_fd_sc_hd__tapvpwrvgnd_1
Xg_row\[0\].g_col\[0\].pe__2481_ g_row\[0\].g_col\[0\].pe__2494_/B g_row\[0\].g_col\[0\].pe__2585_/A
+ VGND VGND VPWR VPWR g_row\[0\].g_col\[0\].pe__2482_/B sky130_fd_sc_hd__nor2_2
XFILLER_32_741 VGND VGND VPWR VPWR sky130_fd_sc_hd__fill_2
Xg_row\[0\].g_col\[0\].pe__1432_ g_row\[0\].g_col\[0\].pe__1705_/A g_row\[0\].g_col\[0\].pe__1432_/B
+ VGND VGND VPWR VPWR g_row\[0\].g_col\[0\].pe__1481_/A sky130_fd_sc_hd__xnor2_2
Xg_row\[0\].g_col\[0\].pe__1363_ g_row\[0\].g_col\[0\].pe__2767_/Q g_row\[0\].g_col\[0\].pe__1363_/B
+ VGND VGND VPWR VPWR output1357/A sky130_fd_sc_hd__xnor2_2
Xg_row\[0\].g_col\[1\].pe__2000_ g_row\[0\].g_col\[1\].pe__1935_/A g_row\[0\].g_col\[1\].pe__1998_/X
+ g_row\[0\].g_col\[1\].pe__1999_/X VGND VGND VPWR VPWR g_row\[0\].g_col\[1\].pe__2001_/B
+ sky130_fd_sc_hd__o21a_2
XTAP_TAPCELL_ROW_57_1059 VGND VPWR sky130_fd_sc_hd__tapvpwrvgnd_1
Xg_row\[1\].g_col\[1\].pe__2755_ _303_/CLK g_row\[1\].g_col\[1\].pe__2755_/D VGND
+ VGND VPWR VPWR g_row\[1\].g_col\[1\].pe__2755_/Q sky130_fd_sc_hd__dfxtp_2
Xg_row\[1\].g_col\[0\].pe__2739_ clkbuf_leaf_59_clk/X g_row\[1\].g_col\[0\].pe__2739_/D
+ VGND VGND VPWR VPWR g_row\[1\].g_col\[0\].pe__2739_/Q sky130_fd_sc_hd__dfxtp_2
XFILLER_48_29 VGND VGND VPWR VPWR sky130_fd_sc_hd__fill_2
Xg_row\[1\].g_col\[1\].pe__2686_ g_row\[1\].g_col\[1\].pe__2686_/A g_row\[1\].g_col\[1\].pe__2686_/B
+ VGND VGND VPWR VPWR g_row\[1\].g_col\[1\].pe__2686_/X sky130_fd_sc_hd__or2_2
Xg_row\[1\].g_col\[1\].pe__1706_ g_row\[1\].g_col\[1\].pe__1761_/A2 g_row\[1\].g_col\[1\].pe__1729_/A2
+ g_row\[1\].g_col\[1\].pe__1729_/A3 g_row\[1\].g_col\[1\].pe__1729_/B1 g_row\[1\].g_col\[1\].pe__2695_/Q
+ VGND VGND VPWR VPWR g_row\[1\].g_col\[1\].pe__1707_/B sky130_fd_sc_hd__a32o_2
XFILLER_58_137 VGND VGND VPWR VPWR sky130_fd_sc_hd__decap_3
XTAP_TAPCELL_ROW_70_1259 VGND VPWR sky130_fd_sc_hd__tapvpwrvgnd_1
Xg_row\[1\].g_col\[1\].pe__1637_ g_row\[1\].g_col\[1\].pe__1846_/A g_row\[1\].g_col\[1\].pe__1847_/B
+ VGND VGND VPWR VPWR g_row\[1\].g_col\[1\].pe__1844_/B sky130_fd_sc_hd__xnor2_2
XFILLER_67_671 VGND VGND VPWR VPWR sky130_fd_sc_hd__fill_1
XFILLER_74_608 VGND VGND VPWR VPWR sky130_fd_sc_hd__fill_1
Xg_row\[1\].g_col\[1\].pe_place830 g_row\[1\].g_col\[1\].pe__2010_/A VGND VGND VPWR
+ VPWR g_row\[1\].g_col\[1\].pe__2394_/B1 sky130_fd_sc_hd__buf_6
Xg_row\[1\].g_col\[0\].pe_hold2260 g_row\[1\].g_col\[0\].pe__1406_/Y VGND VGND VPWR
+ VPWR g_row\[1\].g_col\[0\].pe__2404_/B1 sky130_fd_sc_hd__clkbuf_2
XFILLER_55_822 VGND VGND VPWR VPWR sky130_fd_sc_hd__fill_1
Xg_row\[1\].g_col\[1\].pe_place874 g_row\[1\].g_col\[1\].pe__1558_/B VGND VGND VPWR
+ VPWR g_row\[1\].g_col\[1\].pe__2363_/A2 sky130_fd_sc_hd__buf_6
Xg_row\[1\].g_col\[1\].pe_place885 g_row\[1\].g_col\[1\].pe__1611_/A VGND VGND VPWR
+ VPWR g_row\[1\].g_col\[1\].pe__1673_/A sky130_fd_sc_hd__buf_6
Xg_row\[1\].g_col\[1\].pe__1568_ g_row\[1\].g_col\[1\].pe__1596_/A g_row\[1\].g_col\[1\].pe__1596_/B
+ VGND VGND VPWR VPWR g_row\[1\].g_col\[1\].pe__1571_/A sky130_fd_sc_hd__xor2_2
Xg_row\[0\].g_col\[1\].pe__2764_ clkbuf_leaf_3_clk/X g_row\[0\].g_col\[1\].pe__2764_/D
+ VGND VGND VPWR VPWR g_row\[0\].g_col\[1\].pe__2764_/Q sky130_fd_sc_hd__dfxtp_2
XFILLER_27_546 VGND VGND VPWR VPWR sky130_fd_sc_hd__fill_1
Xclkbuf_leaf_93_clk clkload1/A VGND VGND VPWR VPWR clkbuf_leaf_93_clk/X sky130_fd_sc_hd__clkbuf_16
Xg_row\[0\].g_col\[0\].pe__2748_ _309_/CLK g_row\[0\].g_col\[0\].pe__2748_/D VGND
+ VGND VPWR VPWR ANTENNA_43/DIODE sky130_fd_sc_hd__dfxtp_2
Xg_row\[0\].g_col\[1\].pe__1715_ g_row\[0\].g_col\[1\].pe__2690_/Q g_row\[0\].g_col\[1\].pe__1715_/B
+ VGND VGND VPWR VPWR g_row\[0\].g_col\[1\].pe__1724_/S sky130_fd_sc_hd__nand2_2
Xg_row\[1\].g_col\[1\].pe_place896 g_row\[1\].g_col\[1\].pe__1950_/A VGND VGND VPWR
+ VPWR g_row\[1\].g_col\[1\].pe__2626_/A1 sky130_fd_sc_hd__buf_6
Xg_row\[1\].g_col\[1\].pe__1499_ g_row\[1\].g_col\[1\].pe__1499_/A g_row\[1\].g_col\[1\].pe__1499_/B
+ VGND VGND VPWR VPWR g_row\[1\].g_col\[1\].pe__1500_/B sky130_fd_sc_hd__xor2_2
XFILLER_54_365 VGND VGND VPWR VPWR sky130_fd_sc_hd__decap_3
XFILLER_54_387 VGND VGND VPWR VPWR sky130_fd_sc_hd__fill_2
Xg_row\[0\].g_col\[0\].pe__2679_ g_row\[0\].g_col\[0\].pe__2679_/A1 g_row\[0\].g_col\[0\].pe__2686_/B
+ g_row\[0\].g_col\[0\].pe__2678_/Y g_row\[0\].g_col\[0\].pe__1377_/Y VGND VGND VPWR
+ VPWR g_row\[0\].g_col\[0\].pe__2679_/X sky130_fd_sc_hd__o211a_2
Xg_row\[0\].g_col\[1\].pe__2695_ _336_/CLK g_row\[0\].g_col\[1\].pe__2695_/D VGND
+ VGND VPWR VPWR g_row\[0\].g_col\[1\].pe__2695_/Q sky130_fd_sc_hd__dfxtp_2
XFILLER_23_741 VGND VGND VPWR VPWR sky130_fd_sc_hd__fill_1
XTAP_TAPCELL_ROW_85_1480 VGND VPWR sky130_fd_sc_hd__tapvpwrvgnd_1
XTAP_TAPCELL_ROW_85_1491 VGND VPWR sky130_fd_sc_hd__tapvpwrvgnd_1
Xg_row\[0\].g_col\[1\].pe__1646_ g_row\[0\].g_col\[1\].pe__1749_/A2 g_row\[0\].g_col\[1\].pe__1732_/A2
+ g_row\[0\].g_col\[1\].pe__1732_/B1 g_row\[0\].g_col\[1\].pe__1761_/A2 VGND VGND
+ VPWR VPWR g_row\[0\].g_col\[1\].pe__1647_/B sky130_fd_sc_hd__a22o_2
Xg_row\[0\].g_col\[1\].pe_hold1979 g_row\[0\].g_col\[1\].pe__2656_/X VGND VGND VPWR
+ VPWR g_row\[0\].g_col\[1\].pe__2713_/D sky130_fd_sc_hd__clkbuf_2
Xg_row\[0\].g_col\[1\].pe__1577_ g_row\[0\].g_col\[1\].pe__1970_/A g_row\[0\].g_col\[1\].pe__1982_/B
+ g_row\[0\].g_col\[1\].pe__1424_/Y g_row\[0\].g_col\[1\].pe__1911_/A1 VGND VGND VPWR
+ VPWR g_row\[0\].g_col\[1\].pe__1578_/B sky130_fd_sc_hd__a22o_2
Xg_row\[0\].g_col\[1\].pe__2129_ g_row\[0\].g_col\[1\].pe__2129_/A g_row\[0\].g_col\[1\].pe__2129_/B
+ VGND VGND VPWR VPWR g_row\[0\].g_col\[1\].pe__2132_/A sky130_fd_sc_hd__nor2_2
XFILLER_2_645 VGND VGND VPWR VPWR sky130_fd_sc_hd__decap_3
XFILLER_8_3 VGND VGND VPWR VPWR sky130_fd_sc_hd__fill_1
XFILLER_2_678 VGND VGND VPWR VPWR sky130_fd_sc_hd__fill_2
XFILLER_2_689 VGND VGND VPWR VPWR sky130_fd_sc_hd__fill_2
XFILLER_38_51 VGND VGND VPWR VPWR sky130_fd_sc_hd__fill_1
XFILLER_58_671 VGND VGND VPWR VPWR sky130_fd_sc_hd__decap_3
XFILLER_18_557 VGND VGND VPWR VPWR sky130_fd_sc_hd__fill_1
XFILLER_45_354 VGND VGND VPWR VPWR sky130_fd_sc_hd__decap_3
Xclkbuf_leaf_84_clk clkbuf_4_8_0_clk/X VGND VGND VPWR VPWR clkbuf_leaf_84_clk/X sky130_fd_sc_hd__clkbuf_16
XFILLER_73_685 VGND VGND VPWR VPWR sky130_fd_sc_hd__decap_3
Xg_row\[0\].g_col\[0\].pe_hold3015 g_row\[0\].g_col\[0\].pe_hold3015/A VGND VGND VPWR
+ VPWR g_row\[0\].g_col\[0\].pe__1403_/A1 sky130_fd_sc_hd__clkbuf_2
XFILLER_14_730 VGND VGND VPWR VPWR sky130_fd_sc_hd__decap_3
Xg_row\[0\].g_col\[0\].pe_hold2303 g_row\[0\].g_col\[0\].pe__2611_/X VGND VGND VPWR
+ VPWR g_row\[0\].g_col\[0\].pe__2694_/D sky130_fd_sc_hd__clkbuf_2
Xg_row\[0\].g_col\[0\].pe_hold2314 g_row\[0\].g_col\[0\].pe__1388_/X VGND VGND VPWR
+ VPWR g_row\[0\].g_col\[0\].pe__2730_/D sky130_fd_sc_hd__clkbuf_2
XFILLER_14_752 VGND VGND VPWR VPWR sky130_fd_sc_hd__decap_3
XFILLER_9_200 VGND VGND VPWR VPWR sky130_fd_sc_hd__fill_1
XFILLER_13_273 VGND VGND VPWR VPWR sky130_fd_sc_hd__fill_2
XFILLER_14_785 VGND VGND VPWR VPWR sky130_fd_sc_hd__fill_1
XFILLER_9_222 VGND VGND VPWR VPWR sky130_fd_sc_hd__fill_2
Xg_row\[0\].g_col\[1\].pe_place939 g_row\[0\].g_col\[1\].pe__1901_/B1 VGND VGND VPWR
+ VPWR g_row\[0\].g_col\[1\].pe__2215_/B1 sky130_fd_sc_hd__buf_6
XFILLER_9_255 VGND VGND VPWR VPWR sky130_fd_sc_hd__decap_3
XFILLER_70_82 VGND VGND VPWR VPWR sky130_fd_sc_hd__fill_2
Xclkload14 clkload14/A VGND VGND VPWR VPWR clkload14/X sky130_fd_sc_hd__clkbuf_8
Xg_row\[1\].g_col\[0\].pe__1972_ g_row\[1\].g_col\[0\].pe__2085_/A g_row\[1\].g_col\[0\].pe__1972_/B
+ g_row\[1\].g_col\[0\].pe__1972_/C VGND VGND VPWR VPWR g_row\[1\].g_col\[0\].pe__1974_/C
+ sky130_fd_sc_hd__nand3_2
XFILLER_5_472 VGND VGND VPWR VPWR sky130_fd_sc_hd__fill_2
Xoutput1405 output1405/A VGND VGND VPWR VPWR results_flat[55] sky130_fd_sc_hd__buf_2
Xoutput1416 output1416/A VGND VGND VPWR VPWR results_flat[7] sky130_fd_sc_hd__buf_2
Xg_row\[1\].g_col\[1\].pe_hold3091 g_row\[1\].g_col\[1\].pe__2734_/Q VGND VGND VPWR
+ VPWR g_row\[1\].g_col\[1\].pe_hold3091/X sky130_fd_sc_hd__clkbuf_2
Xg_row\[0\].g_col\[0\].pe__1981_ g_row\[0\].g_col\[0\].pe__2725_/Q g_row\[0\].g_col\[0\].pe__2045_/B
+ g_row\[0\].g_col\[0\].pe__2632_/B VGND VGND VPWR VPWR g_row\[0\].g_col\[0\].pe__1981_/Y
+ sky130_fd_sc_hd__nand3_2
Xhold2809 hold2809/A VGND VGND VPWR VPWR _306_/D sky130_fd_sc_hd__clkbuf_2
Xg_row\[1\].g_col\[1\].pe__2540_ g_row\[1\].g_col\[1\].pe__2544_/B g_row\[1\].g_col\[1\].pe__2539_/X
+ g_row\[1\].g_col\[1\].pe__2559_/A VGND VGND VPWR VPWR g_row\[1\].g_col\[1\].pe__2540_/X
+ sky130_fd_sc_hd__a21o_2
Xg_row\[1\].g_col\[1\].pe__2471_ g_row\[1\].g_col\[1\].pe__2471_/A g_row\[1\].g_col\[1\].pe__2495_/A
+ g_row\[1\].g_col\[1\].pe__2471_/C VGND VGND VPWR VPWR g_row\[1\].g_col\[1\].pe__2505_/A
+ sky130_fd_sc_hd__and3_2
XFILLER_56_619 VGND VGND VPWR VPWR sky130_fd_sc_hd__decap_3
XFILLER_68_457 VGND VGND VPWR VPWR sky130_fd_sc_hd__decap_3
Xg_row\[1\].g_col\[1\].pe__1422_ g_row\[1\].g_col\[1\].pe__2125_/C g_row\[1\].g_col\[1\].pe__2727_/Q
+ g_row\[1\].g_col\[1\].pe__2726_/Q VGND VGND VPWR VPWR g_row\[1\].g_col\[1\].pe__1424_/A
+ sky130_fd_sc_hd__nand3b_2
Xg_row\[1\].g_col\[0\].pe__2455_ g_row\[1\].g_col\[0\].pe__2455_/A g_row\[1\].g_col\[0\].pe__2455_/B
+ VGND VGND VPWR VPWR g_row\[1\].g_col\[0\].pe__2457_/B sky130_fd_sc_hd__xnor2_2
Xg_row\[1\].g_col\[1\].pe_place1002 g_row\[1\].g_col\[1\].pe__2771_/Q VGND VGND VPWR
+ VPWR g_row\[1\].g_col\[1\].pe__1348_/A sky130_fd_sc_hd__buf_6
Xg_row\[1\].g_col\[1\].pe_place1013 g_row\[1\].g_col\[1\].pe__2686_/A VGND VGND VPWR
+ VPWR g_row\[1\].g_col\[1\].pe__1730_/A sky130_fd_sc_hd__buf_6
Xg_row\[1\].g_col\[0\].pe__2386_ g_row\[1\].g_col\[0\].pe__2386_/A g_row\[1\].g_col\[0\].pe__2372_/A
+ VGND VGND VPWR VPWR g_row\[1\].g_col\[0\].pe__2387_/B sky130_fd_sc_hd__or2b_2
Xg_row\[1\].g_col\[0\].pe__1406_ g_row\[1\].g_col\[0\].pe__1406_/A VGND VGND VPWR
+ VPWR g_row\[1\].g_col\[0\].pe__1406_/Y sky130_fd_sc_hd__inv_2
XFILLER_64_630 VGND VGND VPWR VPWR sky130_fd_sc_hd__decap_3
XFILLER_64_652 VGND VGND VPWR VPWR sky130_fd_sc_hd__decap_3
Xclkbuf_leaf_75_clk clkbuf_4_10_0_clk/X VGND VGND VPWR VPWR clkbuf_leaf_75_clk/X sky130_fd_sc_hd__clkbuf_16
Xg_row\[1\].g_col\[1\].pe_place1024 g_row\[1\].g_col\[1\].pe__2702_/Q VGND VGND VPWR
+ VPWR g_row\[1\].g_col\[1\].pe__2083_/A sky130_fd_sc_hd__buf_6
Xg_row\[1\].g_col\[1\].pe_place1035 g_row\[1\].g_col\[1\].pe_hold1946/X VGND VGND
+ VPWR VPWR g_row\[1\].g_col\[1\].pe__2614_/B sky130_fd_sc_hd__buf_6
Xg_row\[1\].g_col\[1\].pe_place1046 g_row\[1\].g_col\[1\].pe__2691_/Q VGND VGND VPWR
+ VPWR g_row\[1\].g_col\[1\].pe__1805_/A2 sky130_fd_sc_hd__buf_6
Xg_row\[1\].g_col\[1\].pe__1353_ g_row\[1\].g_col\[1\].pe__2762_/Q g_row\[1\].g_col\[1\].pe__1353_/B
+ VGND VGND VPWR VPWR output1404/A sky130_fd_sc_hd__xor2_2
XFILLER_24_505 VGND VGND VPWR VPWR sky130_fd_sc_hd__fill_1
XFILLER_51_313 VGND VGND VPWR VPWR sky130_fd_sc_hd__decap_3
Xg_row\[0\].g_col\[0\].pe__2533_ g_row\[0\].g_col\[0\].pe__2533_/A g_row\[0\].g_col\[0\].pe__2533_/B
+ VGND VGND VPWR VPWR g_row\[0\].g_col\[0\].pe__2534_/C sky130_fd_sc_hd__and2_2
Xg_row\[1\].g_col\[1\].pe_place1057 g_row\[1\].g_col\[1\].pe__2595_/A VGND VGND VPWR
+ VPWR g_row\[1\].g_col\[1\].pe__2592_/A sky130_fd_sc_hd__buf_6
Xg_row\[0\].g_col\[1\].pe__1500_ g_row\[0\].g_col\[1\].pe__1500_/A g_row\[0\].g_col\[1\].pe__1500_/B
+ VGND VGND VPWR VPWR g_row\[0\].g_col\[1\].pe__1510_/B sky130_fd_sc_hd__xor2_2
Xg_row\[0\].g_col\[1\].pe__2480_ g_row\[0\].g_col\[1\].pe__2478_/A g_row\[0\].g_col\[1\].pe__2478_/B
+ g_row\[0\].g_col\[1\].pe__2479_/X VGND VGND VPWR VPWR g_row\[0\].g_col\[1\].pe__2585_/A
+ sky130_fd_sc_hd__o21ai_2
Xg_row\[0\].g_col\[0\].pe__2464_ g_row\[0\].g_col\[0\].pe__2759_/Q g_row\[0\].g_col\[0\].pe__2464_/B
+ VGND VGND VPWR VPWR g_row\[0\].g_col\[0\].pe__2464_/X sky130_fd_sc_hd__and2_2
Xg_row\[0\].g_col\[1\].pe__1431_ g_row\[0\].g_col\[1\].pe__1704_/A1 g_row\[0\].g_col\[1\].pe__2030_/A
+ g_row\[0\].g_col\[1\].pe__1970_/A g_row\[0\].g_col\[1\].pe__1704_/B2 VGND VGND VPWR
+ VPWR g_row\[0\].g_col\[1\].pe__1432_/B sky130_fd_sc_hd__a22o_2
Xg_row\[0\].g_col\[0\].pe__1415_ g_row\[0\].g_col\[0\].pe__2725_/Q g_row\[0\].g_col\[0\].pe__2045_/B
+ g_row\[0\].g_col\[0\].pe__2726_/Q VGND VGND VPWR VPWR g_row\[0\].g_col\[0\].pe__1415_/Y
+ sky130_fd_sc_hd__o21ai_2
Xg_row\[0\].g_col\[0\].pe__2395_ g_row\[0\].g_col\[0\].pe__2395_/A1 g_row\[0\].g_col\[0\].pe__2422_/A
+ g_row\[0\].g_col\[0\].pe__2393_/Y g_row\[0\].g_col\[0\].pe__2394_/X VGND VGND VPWR
+ VPWR g_row\[0\].g_col\[0\].pe__2396_/B sky130_fd_sc_hd__o22a_4
Xclkload8 clkload8/A VGND VGND VPWR VPWR clkload8/X sky130_fd_sc_hd__clkbuf_16
Xg_row\[0\].g_col\[0\].pe__1346_ g_row\[0\].g_col\[0\].pe__2759_/Q g_row\[0\].g_col\[0\].pe__1346_/B
+ VGND VGND VPWR VPWR output1388/A sky130_fd_sc_hd__xor2_2
Xg_row\[0\].g_col\[1\].pe__1362_ g_row\[0\].g_col\[1\].pe__2766_/Q g_row\[0\].g_col\[1\].pe__1361_/B
+ ANTENNA_146/DIODE VGND VGND VPWR VPWR g_row\[0\].g_col\[1\].pe__1363_/B sky130_fd_sc_hd__o21ai_2
Xg_row\[1\].g_col\[1\].pe__2738_ clkload17/A g_row\[1\].g_col\[1\].pe__2738_/D VGND
+ VGND VPWR VPWR g_row\[1\].g_col\[1\].pe__2738_/Q sky130_fd_sc_hd__dfxtp_2
XFILLER_87_766 VGND VGND VPWR VPWR sky130_fd_sc_hd__decap_3
Xg_row\[1\].g_col\[1\].pe__2669_ g_row\[1\].g_col\[1\].pe__2669_/A g_row\[1\].g_col\[1\].pe__2669_/B
+ VGND VGND VPWR VPWR g_row\[1\].g_col\[1\].pe__2669_/X sky130_fd_sc_hd__or2_2
XFILLER_27_310 VGND VGND VPWR VPWR sky130_fd_sc_hd__fill_2
XTAP_TAPCELL_ROW_87_1520 VGND VPWR sky130_fd_sc_hd__tapvpwrvgnd_1
Xg_row\[0\].g_col\[1\].pe_hold3123 g_row\[0\].g_col\[1\].pe__2734_/Q VGND VGND VPWR
+ VPWR g_row\[0\].g_col\[1\].pe_hold3123/X sky130_fd_sc_hd__clkbuf_2
Xg_row\[0\].g_col\[1\].pe_hold2400 g_row\[0\].g_col\[1\].pe__2741_/Q VGND VGND VPWR
+ VPWR g_row\[0\].g_col\[1\].pe__1946_/A sky130_fd_sc_hd__clkbuf_2
XFILLER_27_321 VGND VGND VPWR VPWR sky130_fd_sc_hd__fill_2
Xclkbuf_leaf_66_clk clkbuf_4_10_0_clk/X VGND VGND VPWR VPWR _304_/CLK sky130_fd_sc_hd__clkbuf_16
Xg_row\[0\].g_col\[1\].pe__2747_ clkload9/A g_row\[0\].g_col\[1\].pe__2747_/D VGND
+ VGND VPWR VPWR g_row\[0\].g_col\[1\].pe__2747_/Q sky130_fd_sc_hd__dfxtp_2
X_300_ _300_/CLK _300_/D VGND VGND VPWR VPWR _300_/Q sky130_fd_sc_hd__dfxtp_2
Xg_row\[0\].g_col\[1\].pe__2678_ g_row\[0\].g_col\[1\].pe__2678_/A g_row\[0\].g_col\[1\].pe__2678_/B
+ VGND VGND VPWR VPWR g_row\[0\].g_col\[1\].pe__2678_/Y sky130_fd_sc_hd__nand2_2
XFILLER_11_700 VGND VGND VPWR VPWR sky130_fd_sc_hd__decap_3
XFILLER_70_677 VGND VGND VPWR VPWR sky130_fd_sc_hd__decap_3
Xg_row\[0\].g_col\[1\].pe__1629_ g_row\[0\].g_col\[1\].pe__1629_/A g_row\[0\].g_col\[1\].pe__1629_/B
+ VGND VGND VPWR VPWR g_row\[0\].g_col\[1\].pe__1883_/A sky130_fd_sc_hd__xnor2_2
XTAP_TAPCELL_ROW_25_588 VGND VPWR sky130_fd_sc_hd__tapvpwrvgnd_1
X_231_ _237_/A _231_/B_N VGND VGND VPWR VPWR _231_/Y sky130_fd_sc_hd__nor2b_4
XFILLER_11_799 VGND VGND VPWR VPWR sky130_fd_sc_hd__decap_3
XFILLER_6_247 VGND VGND VPWR VPWR sky130_fd_sc_hd__fill_1
XFILLER_2_442 VGND VGND VPWR VPWR sky130_fd_sc_hd__decap_3
XFILLER_78_766 VGND VGND VPWR VPWR sky130_fd_sc_hd__fill_2
XTAP_TAPCELL_ROW_5_280 VGND VPWR sky130_fd_sc_hd__tapvpwrvgnd_1
XTAP_TAPCELL_ROW_5_291 VGND VPWR sky130_fd_sc_hd__tapvpwrvgnd_1
Xg_row\[1\].g_col\[0\].pe__2240_ g_row\[1\].g_col\[0\].pe__2207_/B g_row\[1\].g_col\[0\].pe__2210_/B
+ g_row\[1\].g_col\[0\].pe__2207_/A VGND VGND VPWR VPWR g_row\[1\].g_col\[0\].pe__2288_/A
+ sky130_fd_sc_hd__a21bo_2
XFILLER_46_652 VGND VGND VPWR VPWR sky130_fd_sc_hd__decap_3
XFILLER_58_490 VGND VGND VPWR VPWR sky130_fd_sc_hd__decap_3
Xclkbuf_leaf_57_clk clkload7/A VGND VGND VPWR VPWR clkbuf_leaf_57_clk/X sky130_fd_sc_hd__clkbuf_16
Xg_row\[1\].g_col\[0\].pe__2171_ g_row\[1\].g_col\[0\].pe__2209_/A g_row\[1\].g_col\[0\].pe__2171_/B
+ VGND VGND VPWR VPWR g_row\[1\].g_col\[0\].pe__2172_/B sky130_fd_sc_hd__xnor2_2
XFILLER_80_419 VGND VGND VPWR VPWR sky130_fd_sc_hd__fill_1
XANTENNA_150 hold3258/A VGND VGND VPWR VPWR sky130_fd_sc_hd__diode_2
XANTENNA_161 _326_/D VGND VGND VPWR VPWR sky130_fd_sc_hd__diode_2
XFILLER_61_655 VGND VGND VPWR VPWR sky130_fd_sc_hd__decap_3
XANTENNA_172 hold3256/X VGND VGND VPWR VPWR sky130_fd_sc_hd__diode_2
XTAP_TAPCELL_ROW_44_864 VGND VPWR sky130_fd_sc_hd__tapvpwrvgnd_1
XTAP_TAPCELL_ROW_44_875 VGND VPWR sky130_fd_sc_hd__tapvpwrvgnd_1
Xg_row\[0\].g_col\[0\].pe_hold2122 g_row\[0\].g_col\[0\].pe__2548_/X VGND VGND VPWR
+ VPWR g_row\[0\].g_col\[0\].pe__2549_/B sky130_fd_sc_hd__clkbuf_2
XFILLER_14_571 VGND VGND VPWR VPWR sky130_fd_sc_hd__decap_3
Xg_row\[0\].g_col\[0\].pe_hold2166 g_row\[0\].g_col\[0\].pe_hold2983/X VGND VGND VPWR
+ VPWR g_row\[0\].g_col\[0\].pe__2717_/D sky130_fd_sc_hd__clkbuf_2
Xg_row\[0\].g_col\[0\].pe__2180_ g_row\[0\].g_col\[0\].pe__2213_/A g_row\[0\].g_col\[0\].pe__2213_/B
+ VGND VGND VPWR VPWR g_row\[0\].g_col\[0\].pe__2181_/B sky130_fd_sc_hd__xor2_2
Xg_row\[1\].g_col\[1\].pe__1971_ g_row\[1\].g_col\[1\].pe__1461_/A g_row\[1\].g_col\[1\].pe__1461_/B
+ g_row\[1\].g_col\[1\].pe__1608_/A1 VGND VGND VPWR VPWR g_row\[1\].g_col\[1\].pe__1972_/C
+ sky130_fd_sc_hd__a21bo_2
Xg_row\[1\].g_col\[0\].pe__1955_ g_row\[1\].g_col\[0\].pe__1955_/A g_row\[1\].g_col\[0\].pe__1955_/B
+ VGND VGND VPWR VPWR g_row\[1\].g_col\[0\].pe__1955_/X sky130_fd_sc_hd__and2_2
XTAP_TAPCELL_ROW_54_1018 VGND VPWR sky130_fd_sc_hd__tapvpwrvgnd_1
Xg_row\[1\].g_col\[0\].pe__1886_ g_row\[1\].g_col\[0\].pe__1886_/A g_row\[1\].g_col\[0\].pe__1897_/B
+ VGND VGND VPWR VPWR g_row\[1\].g_col\[0\].pe__1888_/C sky130_fd_sc_hd__xnor2_2
Xhold3307 hold3307/A VGND VGND VPWR VPWR hold3307/X sky130_fd_sc_hd__clkbuf_2
Xhold3318 hold3318/A VGND VGND VPWR VPWR hold3318/X sky130_fd_sc_hd__clkbuf_2
Xhold3329 hold3329/A VGND VGND VPWR VPWR hold3329/X sky130_fd_sc_hd__clkbuf_2
Xhold2606 hold3361/X VGND VGND VPWR VPWR hold3362/A sky130_fd_sc_hd__clkbuf_2
Xhold2617 hold2617/A VGND VGND VPWR VPWR _289_/D sky130_fd_sc_hd__clkbuf_2
Xhold2628 _227_/Y VGND VGND VPWR VPWR hold2628/X sky130_fd_sc_hd__clkbuf_2
Xg_row\[0\].g_col\[1\].pe__1980_ g_row\[0\].g_col\[1\].pe__1980_/A g_row\[0\].g_col\[1\].pe__1980_/B
+ g_row\[0\].g_col\[1\].pe__1980_/C VGND VGND VPWR VPWR g_row\[0\].g_col\[1\].pe__1980_/X
+ sky130_fd_sc_hd__or3_4
XFILLER_69_777 VGND VGND VPWR VPWR sky130_fd_sc_hd__fill_2
Xg_row\[0\].g_col\[0\].pe__1964_ g_row\[0\].g_col\[0\].pe__1964_/A g_row\[0\].g_col\[0\].pe__1964_/B
+ VGND VGND VPWR VPWR g_row\[0\].g_col\[0\].pe__1997_/A sky130_fd_sc_hd__xnor2_2
Xhold1905 hold3085/X VGND VGND VPWR VPWR hold1905/X sky130_fd_sc_hd__clkbuf_2
Xhold2639 hold3458/X VGND VGND VPWR VPWR _187_/B_N sky130_fd_sc_hd__clkbuf_2
Xg_row\[1\].g_col\[0\].pe__2507_ g_row\[1\].g_col\[0\].pe__2575_/A g_row\[1\].g_col\[0\].pe__2507_/B
+ VGND VGND VPWR VPWR g_row\[1\].g_col\[0\].pe__2507_/Y sky130_fd_sc_hd__nor2_2
XFILLER_84_747 VGND VGND VPWR VPWR sky130_fd_sc_hd__decap_3
Xg_row\[0\].g_col\[0\].pe__1895_ g_row\[0\].g_col\[0\].pe__1843_/A g_row\[0\].g_col\[0\].pe__1843_/B
+ g_row\[0\].g_col\[0\].pe__1891_/B VGND VGND VPWR VPWR g_row\[0\].g_col\[0\].pe__1895_/X
+ sky130_fd_sc_hd__a21bo_2
Xhold1938 hold1938/A VGND VGND VPWR VPWR hold1938/X sky130_fd_sc_hd__clkbuf_2
Xg_row\[1\].g_col\[1\].pe__2454_ g_row\[1\].g_col\[1\].pe__2759_/Q g_row\[1\].g_col\[1\].pe__2464_/B
+ VGND VGND VPWR VPWR g_row\[1\].g_col\[1\].pe__2538_/B sky130_fd_sc_hd__or2_2
Xg_row\[1\].g_col\[0\].pe__2438_ g_row\[1\].g_col\[0\].pe__2764_/Q g_row\[1\].g_col\[0\].pe__2438_/B
+ VGND VGND VPWR VPWR g_row\[1\].g_col\[0\].pe__2471_/A sky130_fd_sc_hd__xnor2_2
Xclkbuf_leaf_48_clk clkbuf_4_12_0_clk/X VGND VGND VPWR VPWR clkbuf_leaf_48_clk/X sky130_fd_sc_hd__clkbuf_16
Xg_row\[1\].g_col\[1\].pe__2385_ g_row\[1\].g_col\[1\].pe__2385_/A g_row\[1\].g_col\[1\].pe__2385_/B
+ VGND VGND VPWR VPWR g_row\[1\].g_col\[1\].pe__2392_/A sky130_fd_sc_hd__nand2_2
Xg_row\[1\].g_col\[1\].pe__1405_ g_row\[1\].g_col\[1\].pe__1838_/A place1233/X VGND
+ VGND VPWR VPWR g_row\[1\].g_col\[1\].pe__2157_/A sky130_fd_sc_hd__nor2_2
XTAP_TAPCELL_ROW_69_1250 VGND VPWR sky130_fd_sc_hd__tapvpwrvgnd_1
Xg_row\[1\].g_col\[0\].pe__2369_ g_row\[1\].g_col\[0\].pe__2368_/A g_row\[1\].g_col\[0\].pe__2368_/B
+ g_row\[1\].g_col\[0\].pe__2367_/X VGND VGND VPWR VPWR g_row\[1\].g_col\[0\].pe__2370_/B
+ sky130_fd_sc_hd__o21bai_2
Xg_row\[0\].g_col\[1\].pe__2532_ g_row\[0\].g_col\[1\].pe__2533_/A g_row\[0\].g_col\[1\].pe__2533_/B
+ VGND VGND VPWR VPWR g_row\[0\].g_col\[1\].pe__2534_/B sky130_fd_sc_hd__nor2_2
XFILLER_52_655 VGND VGND VPWR VPWR sky130_fd_sc_hd__decap_3
Xg_row\[0\].g_col\[0\].pe__2516_ g_row\[0\].g_col\[0\].pe__2503_/B g_row\[0\].g_col\[0\].pe__2516_/B
+ VGND VGND VPWR VPWR g_row\[0\].g_col\[0\].pe__2516_/X sky130_fd_sc_hd__and2b_2
Xg_row\[0\].g_col\[0\].pe__2447_ g_row\[0\].g_col\[0\].pe__2497_/B VGND VGND VPWR
+ VPWR g_row\[0\].g_col\[0\].pe__2551_/B sky130_fd_sc_hd__inv_2
Xg_row\[0\].g_col\[1\].pe__2463_ g_row\[0\].g_col\[1\].pe__2519_/A g_row\[0\].g_col\[1\].pe__2519_/B
+ g_row\[0\].g_col\[1\].pe__2462_/Y VGND VGND VPWR VPWR g_row\[0\].g_col\[1\].pe__2526_/B
+ sky130_fd_sc_hd__o21ai_2
XTAP_TAPCELL_ROW_22_536 VGND VPWR sky130_fd_sc_hd__tapvpwrvgnd_1
XTAP_TAPCELL_ROW_22_547 VGND VPWR sky130_fd_sc_hd__tapvpwrvgnd_1
Xg_row\[0\].g_col\[1\].pe__1414_ g_row\[0\].g_col\[1\].pe__2725_/Q g_row\[0\].g_col\[1\].pe__2724_/Q
+ g_row\[0\].g_col\[1\].pe__2686_/A VGND VGND VPWR VPWR g_row\[0\].g_col\[1\].pe__1414_/X
+ sky130_fd_sc_hd__a21o_2
Xg_row\[0\].g_col\[1\].pe__2394_ g_row\[0\].g_col\[1\].pe__2378_/X g_row\[0\].g_col\[1\].pe__2384_/Y
+ g_row\[0\].g_col\[1\].pe__2392_/Y g_row\[0\].g_col\[1\].pe__2010_/A VGND VGND VPWR
+ VPWR g_row\[0\].g_col\[1\].pe__2394_/X sky130_fd_sc_hd__a31o_2
Xg_row\[0\].g_col\[0\].pe__2378_ g_row\[0\].g_col\[0\].pe__2358_/A g_row\[0\].g_col\[0\].pe__2358_/B
+ g_row\[0\].g_col\[0\].pe__2377_/Y VGND VGND VPWR VPWR g_row\[0\].g_col\[0\].pe__2378_/X
+ sky130_fd_sc_hd__a21o_2
Xg_row\[0\].g_col\[1\].pe__1345_ g_row\[0\].g_col\[1\].pe__2758_/Q g_row\[0\].g_col\[1\].pe__2757_/Q
+ g_row\[0\].g_col\[1\].pe__2775_/A g_row\[0\].g_col\[1\].pe__1348_/A VGND VGND VPWR
+ VPWR g_row\[0\].g_col\[1\].pe__1346_/B sky130_fd_sc_hd__o31a_2
XFILLER_4_707 VGND VGND VPWR VPWR sky130_fd_sc_hd__fill_1
XFILLER_75_714 VGND VGND VPWR VPWR sky130_fd_sc_hd__fill_2
XFILLER_28_630 VGND VGND VPWR VPWR sky130_fd_sc_hd__fill_1
XFILLER_28_641 VGND VGND VPWR VPWR sky130_fd_sc_hd__decap_3
XFILLER_47_449 VGND VGND VPWR VPWR sky130_fd_sc_hd__decap_3
Xclkbuf_leaf_39_clk clkload2/A VGND VGND VPWR VPWR clkbuf_leaf_39_clk/X sky130_fd_sc_hd__clkbuf_16
Xg_row\[0\].g_col\[1\].pe_hold2230 g_row\[0\].g_col\[1\].pe__2626_/X VGND VGND VPWR
+ VPWR g_row\[0\].g_col\[1\].pe__2701_/D sky130_fd_sc_hd__clkbuf_2
XFILLER_35_74 VGND VGND VPWR VPWR sky130_fd_sc_hd__fill_1
XFILLER_31_839 VGND VGND VPWR VPWR sky130_fd_sc_hd__fill_1
XFILLER_42_176 VGND VGND VPWR VPWR sky130_fd_sc_hd__decap_3
XFILLER_70_474 VGND VGND VPWR VPWR sky130_fd_sc_hd__fill_2
XTAP_TAPCELL_ROW_41_823 VGND VPWR sky130_fd_sc_hd__tapvpwrvgnd_1
XFILLER_7_523 VGND VGND VPWR VPWR sky130_fd_sc_hd__fill_2
X_145_ _173_/A _145_/B_N VGND VGND VPWR VPWR _145_/Y sky130_fd_sc_hd__nor2b_4
Xg_row\[1\].g_col\[0\].pe__1740_ g_row\[1\].g_col\[0\].pe__1740_/A g_row\[1\].g_col\[0\].pe__1740_/B
+ VGND VGND VPWR VPWR g_row\[1\].g_col\[0\].pe__1740_/Y sky130_fd_sc_hd__nor2_2
Xg_row\[0\].g_col\[0\].pe_place970 g_row\[0\].g_col\[0\].pe__2363_/A2 VGND VGND VPWR
+ VPWR g_row\[0\].g_col\[0\].pe__2278_/A2 sky130_fd_sc_hd__buf_6
Xg_row\[0\].g_col\[0\].pe_place981 g_row\[0\].g_col\[0\].pe__1912_/A VGND VGND VPWR
+ VPWR g_row\[0\].g_col\[0\].pe__1864_/A sky130_fd_sc_hd__buf_6
Xg_row\[0\].g_col\[0\].pe_place992 g_row\[0\].g_col\[0\].pe__1950_/A VGND VGND VPWR
+ VPWR g_row\[0\].g_col\[0\].pe__2640_/A1 sky130_fd_sc_hd__buf_6
Xg_row\[1\].g_col\[0\].pe__1671_ g_row\[1\].g_col\[0\].pe__1816_/A g_row\[1\].g_col\[0\].pe__1671_/B
+ VGND VGND VPWR VPWR g_row\[1\].g_col\[0\].pe__1690_/A sky130_fd_sc_hd__xor2_2
Xg_row\[1\].g_col\[0\].pe_hold2848 g_row\[1\].g_col\[0\].pe__2652_/X VGND VGND VPWR
+ VPWR g_row\[1\].g_col\[0\].pe_hold2848/X sky130_fd_sc_hd__clkbuf_2
Xg_row\[1\].g_col\[0\].pe_hold2837 g_row\[1\].g_col\[0\].pe_hold2837/A VGND VGND VPWR
+ VPWR g_row\[1\].g_col\[0\].pe__2712_/D sky130_fd_sc_hd__clkbuf_2
XFILLER_38_427 VGND VGND VPWR VPWR sky130_fd_sc_hd__decap_3
XFILLER_78_574 VGND VGND VPWR VPWR sky130_fd_sc_hd__fill_1
Xg_row\[1\].g_col\[0\].pe_hold2859 g_row\[1\].g_col\[0\].pe__2669_/X VGND VGND VPWR
+ VPWR g_row\[1\].g_col\[0\].pe__2670_/C1 sky130_fd_sc_hd__clkbuf_2
XFILLER_76_81 VGND VGND VPWR VPWR sky130_fd_sc_hd__decap_3
XTAP_TAPCELL_ROW_0_209 VGND VPWR sky130_fd_sc_hd__tapvpwrvgnd_1
XTAP_TAPCELL_ROW_49_945 VGND VPWR sky130_fd_sc_hd__tapvpwrvgnd_1
XFILLER_46_460 VGND VGND VPWR VPWR sky130_fd_sc_hd__decap_3
Xg_row\[0\].g_col\[0\].pe__1680_ g_row\[0\].g_col\[0\].pe__1705_/A g_row\[0\].g_col\[0\].pe__1680_/B
+ VGND VGND VPWR VPWR g_row\[0\].g_col\[0\].pe__1686_/A sky130_fd_sc_hd__xnor2_2
Xg_row\[1\].g_col\[0\].pe__2223_ g_row\[1\].g_col\[0\].pe__2183_/A g_row\[1\].g_col\[0\].pe__2183_/B
+ g_row\[1\].g_col\[0\].pe__2222_/X VGND VGND VPWR VPWR g_row\[1\].g_col\[0\].pe__2258_/B
+ sky130_fd_sc_hd__o21ai_2
XFILLER_18_184 VGND VGND VPWR VPWR sky130_fd_sc_hd__fill_1
Xg_row\[1\].g_col\[1\].pe__2170_ g_row\[1\].g_col\[1\].pe__2340_/B2 g_row\[1\].g_col\[1\].pe__1471_/X
+ g_row\[1\].g_col\[1\].pe__2247_/B1 g_row\[1\].g_col\[1\].pe__2030_/A VGND VGND VPWR
+ VPWR g_row\[1\].g_col\[1\].pe__2171_/B sky130_fd_sc_hd__a22o_2
Xg_row\[1\].g_col\[0\].pe__2154_ g_row\[1\].g_col\[0\].pe__2062_/C g_row\[1\].g_col\[0\].pe__2150_/X
+ g_row\[1\].g_col\[0\].pe__2153_/X g_row\[1\].g_col\[0\].pe__2111_/A VGND VGND VPWR
+ VPWR g_row\[1\].g_col\[0\].pe__2300_/A sky130_fd_sc_hd__a211oi_2
Xg_row\[1\].g_col\[0\].pe__2085_ g_row\[1\].g_col\[0\].pe__2085_/A g_row\[1\].g_col\[0\].pe__2085_/B
+ g_row\[1\].g_col\[0\].pe__2085_/C VGND VGND VPWR VPWR g_row\[1\].g_col\[0\].pe__2087_/C
+ sky130_fd_sc_hd__nand3_2
XFILLER_34_699 VGND VGND VPWR VPWR sky130_fd_sc_hd__fill_1
Xg_row\[0\].g_col\[0\].pe__2301_ g_row\[0\].g_col\[0\].pe__1894_/Y g_row\[0\].g_col\[0\].pe__1895_/X
+ g_row\[0\].g_col\[0\].pe__2151_/X g_row\[0\].g_col\[0\].pe__2300_/B VGND VGND VPWR
+ VPWR g_row\[0\].g_col\[0\].pe__2304_/B sky130_fd_sc_hd__a211o_4
XFILLER_33_198 VGND VGND VPWR VPWR sky130_fd_sc_hd__fill_2
Xg_row\[0\].g_col\[0\].pe__2232_ g_row\[0\].g_col\[0\].pe__2161_/Y g_row\[0\].g_col\[0\].pe__2200_/B
+ g_row\[0\].g_col\[0\].pe__2231_/Y VGND VGND VPWR VPWR g_row\[0\].g_col\[0\].pe__2233_/C
+ sky130_fd_sc_hd__o21a_2
Xg_row\[0\].g_col\[0\].pe__2163_ g_row\[0\].g_col\[0\].pe__2632_/B g_row\[0\].g_col\[0\].pe__2163_/B
+ VGND VGND VPWR VPWR g_row\[0\].g_col\[0\].pe__2165_/B sky130_fd_sc_hd__nand2_2
Xg_row\[0\].g_col\[0\].pe__2094_ g_row\[0\].g_col\[0\].pe__2094_/A g_row\[0\].g_col\[0\].pe__2094_/B
+ g_row\[0\].g_col\[0\].pe__2094_/C VGND VGND VPWR VPWR g_row\[0\].g_col\[0\].pe__2095_/B
+ sky130_fd_sc_hd__nand3_2
Xg_row\[1\].g_col\[1\].pe__1954_ g_row\[1\].g_col\[1\].pe__1857_/A g_row\[1\].g_col\[1\].pe__1857_/B
+ g_row\[1\].g_col\[1\].pe__1908_/B g_row\[1\].g_col\[1\].pe__1907_/B g_row\[1\].g_col\[1\].pe__1907_/A
+ VGND VGND VPWR VPWR g_row\[1\].g_col\[1\].pe__2002_/A sky130_fd_sc_hd__a32o_2
Xg_row\[1\].g_col\[0\].pe__1938_ g_row\[1\].g_col\[0\].pe__1938_/A g_row\[1\].g_col\[0\].pe__1952_/A
+ VGND VGND VPWR VPWR g_row\[1\].g_col\[0\].pe__1939_/B sky130_fd_sc_hd__xnor2_2
Xhold3115 hold3115/A VGND VGND VPWR VPWR hold3115/X sky130_fd_sc_hd__clkbuf_2
Xg_row\[1\].g_col\[1\].pe__1885_ g_row\[1\].g_col\[1\].pe__1885_/A g_row\[1\].g_col\[1\].pe__1896_/A
+ VGND VGND VPWR VPWR g_row\[1\].g_col\[1\].pe__1897_/B sky130_fd_sc_hd__xnor2_2
Xg_row\[1\].g_col\[0\].pe__1869_ place1080/X g_row\[1\].g_col\[0\].pe__1414_/X g_row\[1\].g_col\[0\].pe__1415_/Y
+ g_row\[1\].g_col\[0\].pe__1416_/X hold1989/A VGND VGND VPWR VPWR g_row\[1\].g_col\[0\].pe__1870_/B
+ sky130_fd_sc_hd__a32o_2
Xhold3137 compute_enable VGND VGND VPWR VPWR hold3137/X sky130_fd_sc_hd__clkbuf_2
Xhold3148 hold3148/A VGND VGND VPWR VPWR hold3148/X sky130_fd_sc_hd__clkbuf_2
XFILLER_69_552 VGND VGND VPWR VPWR sky130_fd_sc_hd__fill_1
Xhold2414 hold3137/X VGND VGND VPWR VPWR hold3138/A sky130_fd_sc_hd__clkbuf_2
Xhold2425 hold2425/A VGND VGND VPWR VPWR _291_/D sky130_fd_sc_hd__clkbuf_2
Xhold2436 _249_/Y VGND VGND VPWR VPWR hold2436/X sky130_fd_sc_hd__clkbuf_2
Xhold3159 hold3159/A VGND VGND VPWR VPWR hold3159/X sky130_fd_sc_hd__clkbuf_2
Xg_row\[0\].g_col\[0\].pe__1947_ g_row\[0\].g_col\[0\].pe__1944_/Y g_row\[0\].g_col\[0\].pe__2008_/A
+ g_row\[0\].g_col\[0\].pe__1947_/B1 g_row\[0\].g_col\[0\].pe__2599_/A VGND VGND VPWR
+ VPWR g_row\[0\].g_col\[0\].pe__1948_/B sky130_fd_sc_hd__o2bb2a_2
Xhold2447 hold3157/X VGND VGND VPWR VPWR _161_/B_N sky130_fd_sc_hd__clkbuf_2
Xhold2458 hold3190/X VGND VGND VPWR VPWR hold3191/A sky130_fd_sc_hd__clkbuf_2
Xhold2469 hold3202/X VGND VGND VPWR VPWR hold3203/A sky130_fd_sc_hd__clkbuf_2
Xg_row\[1\].g_col\[1\].pe__2506_ g_row\[1\].g_col\[1\].pe__2571_/A g_row\[1\].g_col\[1\].pe__2567_/A
+ g_row\[1\].g_col\[1\].pe__2506_/C g_row\[1\].g_col\[1\].pe__2505_/X VGND VGND VPWR
+ VPWR g_row\[1\].g_col\[1\].pe__2507_/B sky130_fd_sc_hd__or4b_4
Xg_row\[0\].g_col\[1\].pe__1963_ g_row\[0\].g_col\[1\].pe__1963_/A g_row\[0\].g_col\[1\].pe__1963_/B
+ VGND VGND VPWR VPWR g_row\[0\].g_col\[1\].pe__1964_/B sky130_fd_sc_hd__xor2_2
XFILLER_29_449 VGND VGND VPWR VPWR sky130_fd_sc_hd__decap_3
XFILLER_84_533 VGND VGND VPWR VPWR sky130_fd_sc_hd__fill_1
Xg_row\[1\].g_col\[1\].pe__2437_ g_row\[1\].g_col\[1\].pe__2438_/B g_row\[1\].g_col\[1\].pe__2764_/Q
+ VGND VGND VPWR VPWR g_row\[1\].g_col\[1\].pe__2491_/B sky130_fd_sc_hd__and2b_2
Xg_row\[0\].g_col\[1\].pe__1894_ g_row\[0\].g_col\[1\].pe__1894_/A g_row\[0\].g_col\[1\].pe__1894_/B
+ VGND VGND VPWR VPWR g_row\[0\].g_col\[1\].pe__1894_/Y sky130_fd_sc_hd__nand2_2
XFILLER_44_408 VGND VGND VPWR VPWR sky130_fd_sc_hd__decap_3
XTAP_TAPCELL_ROW_27_617 VGND VPWR sky130_fd_sc_hd__tapvpwrvgnd_1
XTAP_TAPCELL_ROW_67_1209 VGND VPWR sky130_fd_sc_hd__tapvpwrvgnd_1
Xg_row\[0\].g_col\[0\].pe__1878_ g_row\[0\].g_col\[0\].pe__1878_/A g_row\[0\].g_col\[0\].pe__1878_/B
+ VGND VGND VPWR VPWR g_row\[0\].g_col\[0\].pe__1936_/A sky130_fd_sc_hd__xnor2_2
Xg_row\[1\].g_col\[1\].pe__2368_ g_row\[1\].g_col\[1\].pe__2368_/A g_row\[1\].g_col\[1\].pe__2368_/B
+ g_row\[1\].g_col\[1\].pe__2367_/X VGND VGND VPWR VPWR g_row\[1\].g_col\[1\].pe__2387_/A
+ sky130_fd_sc_hd__or3b_2
XFILLER_52_441 VGND VGND VPWR VPWR sky130_fd_sc_hd__decap_3
XTAP_TAPCELL_ROW_80_1409 VGND VPWR sky130_fd_sc_hd__tapvpwrvgnd_1
Xg_row\[1\].g_col\[1\].pe__2299_ g_row\[1\].g_col\[1\].pe__2299_/A g_row\[1\].g_col\[1\].pe__2299_/B
+ VGND VGND VPWR VPWR g_row\[1\].g_col\[1\].pe__2300_/B sky130_fd_sc_hd__or2_4
XFILLER_40_614 VGND VGND VPWR VPWR sky130_fd_sc_hd__fill_1
XFILLER_8_309 VGND VGND VPWR VPWR sky130_fd_sc_hd__fill_1
Xg_row\[0\].g_col\[1\].pe__2446_ g_row\[0\].g_col\[1\].pe__2761_/Q g_row\[0\].g_col\[1\].pe__2446_/B
+ VGND VGND VPWR VPWR g_row\[0\].g_col\[1\].pe__2497_/B sky130_fd_sc_hd__and2b_2
XANTENNA_50 hold3286/A VGND VGND VPWR VPWR sky130_fd_sc_hd__diode_2
XANTENNA_61 _333_/D VGND VGND VPWR VPWR sky130_fd_sc_hd__diode_2
XANTENNA_72 hold3175/X VGND VGND VPWR VPWR sky130_fd_sc_hd__diode_2
XANTENNA_83 hold3243/X VGND VGND VPWR VPWR sky130_fd_sc_hd__diode_2
Xg_row\[0\].g_col\[1\].pe__2377_ g_row\[0\].g_col\[1\].pe__2377_/A g_row\[0\].g_col\[1\].pe__2377_/B
+ VGND VGND VPWR VPWR g_row\[0\].g_col\[1\].pe__2377_/Y sky130_fd_sc_hd__nand2_2
XANTENNA_94 hold3352/X VGND VGND VPWR VPWR sky130_fd_sc_hd__diode_2
XFILLER_0_732 VGND VGND VPWR VPWR sky130_fd_sc_hd__fill_2
XTAP_TAPCELL_ROW_7_320 VGND VPWR sky130_fd_sc_hd__tapvpwrvgnd_1
XFILLER_75_544 VGND VGND VPWR VPWR sky130_fd_sc_hd__fill_1
XFILLER_47_279 VGND VGND VPWR VPWR sky130_fd_sc_hd__fill_1
XTAP_TAPCELL_ROW_46_904 VGND VPWR sky130_fd_sc_hd__tapvpwrvgnd_1
XFILLER_16_633 VGND VGND VPWR VPWR sky130_fd_sc_hd__decap_3
XFILLER_28_493 VGND VGND VPWR VPWR sky130_fd_sc_hd__decap_3
XFILLER_16_666 VGND VGND VPWR VPWR sky130_fd_sc_hd__decap_3
XFILLER_16_677 VGND VGND VPWR VPWR sky130_fd_sc_hd__fill_2
XFILLER_16_699 VGND VGND VPWR VPWR sky130_fd_sc_hd__fill_1
XFILLER_31_603 VGND VGND VPWR VPWR sky130_fd_sc_hd__decap_3
XFILLER_31_636 VGND VGND VPWR VPWR sky130_fd_sc_hd__decap_3
XFILLER_8_810 VGND VGND VPWR VPWR sky130_fd_sc_hd__fill_2
XFILLER_7_45 VGND VGND VPWR VPWR sky130_fd_sc_hd__fill_1
XTAP_TAPCELL_ROW_13_399 VGND VPWR sky130_fd_sc_hd__tapvpwrvgnd_1
Xg_row\[1\].g_col\[0\].pe__1723_ g_row\[1\].g_col\[0\].pe__1723_/A g_row\[1\].g_col\[0\].pe__1723_/B
+ VGND VGND VPWR VPWR g_row\[1\].g_col\[0\].pe__1745_/B sky130_fd_sc_hd__xor2_2
Xg_row\[1\].g_col\[1\].pe__1670_ g_row\[1\].g_col\[1\].pe__1782_/A2 g_row\[1\].g_col\[1\].pe__1748_/B
+ g_row\[1\].g_col\[1\].pe__1738_/B1 g_row\[1\].g_col\[1\].pe__2605_/B VGND VGND VPWR
+ VPWR g_row\[1\].g_col\[1\].pe__1671_/B sky130_fd_sc_hd__a22o_2
Xg_row\[1\].g_col\[0\].pe__1654_ g_row\[1\].g_col\[0\].pe__2605_/B g_row\[1\].g_col\[0\].pe__1715_/B
+ g_row\[1\].g_col\[0\].pe__1863_/B1 g_row\[1\].g_col\[0\].pe__2603_/B VGND VGND VPWR
+ VPWR g_row\[1\].g_col\[0\].pe__1655_/B sky130_fd_sc_hd__a22o_2
XFILLER_85_319 VGND VGND VPWR VPWR sky130_fd_sc_hd__fill_1
Xg_row\[0\].g_col\[0\].pe__1801_ place1222/X g_row\[0\].g_col\[0\].pe__1801_/B g_row\[0\].g_col\[0\].pe__1801_/C
+ VGND VGND VPWR VPWR g_row\[0\].g_col\[0\].pe__1801_/X sky130_fd_sc_hd__and3_2
Xg_row\[1\].g_col\[0\].pe_hold1900 g_row\[1\].g_col\[0\].pe__1393_/X VGND VGND VPWR
+ VPWR g_row\[1\].g_col\[0\].pe__2732_/D sky130_fd_sc_hd__clkbuf_2
Xg_row\[1\].g_col\[0\].pe__1585_ g_row\[1\].g_col\[0\].pe__1533_/A g_row\[1\].g_col\[0\].pe__1533_/B
+ g_row\[1\].g_col\[0\].pe__1584_/Y VGND VGND VPWR VPWR g_row\[1\].g_col\[0\].pe__1634_/B
+ sky130_fd_sc_hd__a21oi_2
XFILLER_66_533 VGND VGND VPWR VPWR sky130_fd_sc_hd__decap_3
XFILLER_93_330 VGND VGND VPWR VPWR sky130_fd_sc_hd__fill_2
Xg_row\[1\].g_col\[0\].pe_hold1922 g_row\[1\].g_col\[0\].pe__2513_/Y VGND VGND VPWR
+ VPWR g_row\[1\].g_col\[0\].pe__2514_/B sky130_fd_sc_hd__clkbuf_2
XFILLER_66_566 VGND VGND VPWR VPWR sky130_fd_sc_hd__decap_3
XFILLER_93_363 VGND VGND VPWR VPWR sky130_fd_sc_hd__fill_1
Xg_row\[0\].g_col\[0\].pe__1732_ place1217/X g_row\[0\].g_col\[0\].pe__1732_/A2 g_row\[0\].g_col\[0\].pe__1732_/B1
+ place1220/X VGND VGND VPWR VPWR g_row\[0\].g_col\[0\].pe__1733_/B sky130_fd_sc_hd__a22o_2
Xg_row\[0\].g_col\[0\].pe__1663_ g_row\[0\].g_col\[0\].pe__1663_/A g_row\[0\].g_col\[0\].pe__1663_/B
+ VGND VGND VPWR VPWR g_row\[0\].g_col\[0\].pe__1697_/B sky130_fd_sc_hd__xnor2_2
Xg_row\[1\].g_col\[1\].pe__2222_ g_row\[1\].g_col\[1\].pe__2222_/A g_row\[1\].g_col\[1\].pe__2253_/A
+ VGND VGND VPWR VPWR g_row\[1\].g_col\[1\].pe__2222_/X sky130_fd_sc_hd__or2_2
Xg_row\[1\].g_col\[0\].pe__2206_ g_row\[1\].g_col\[0\].pe__2125_/A g_row\[1\].g_col\[0\].pe__2204_/Y
+ g_row\[1\].g_col\[0\].pe__2167_/A g_row\[1\].g_col\[0\].pe__2165_/A VGND VGND VPWR
+ VPWR g_row\[1\].g_col\[0\].pe__2207_/B sky130_fd_sc_hd__o211ai_2
XFILLER_81_558 VGND VGND VPWR VPWR sky130_fd_sc_hd__fill_2
Xg_row\[1\].g_col\[1\].pe__2153_ g_row\[1\].g_col\[1\].pe__2153_/A g_row\[1\].g_col\[1\].pe__2153_/B
+ g_row\[1\].g_col\[1\].pe__2153_/C VGND VGND VPWR VPWR g_row\[1\].g_col\[1\].pe__2153_/X
+ sky130_fd_sc_hd__and3_2
XFILLER_22_603 VGND VGND VPWR VPWR sky130_fd_sc_hd__decap_3
Xg_row\[0\].g_col\[0\].pe__1594_ g_row\[0\].g_col\[0\].pe__1594_/A g_row\[0\].g_col\[0\].pe__1594_/B
+ VGND VGND VPWR VPWR g_row\[0\].g_col\[0\].pe__1594_/Y sky130_fd_sc_hd__nand2_2
Xg_row\[1\].g_col\[0\].pe__2137_ g_row\[1\].g_col\[0\].pe__2091_/B g_row\[1\].g_col\[0\].pe__2091_/C
+ g_row\[1\].g_col\[0\].pe__2091_/A VGND VGND VPWR VPWR g_row\[1\].g_col\[0\].pe__2142_/A
+ sky130_fd_sc_hd__a21boi_2
XFILLER_22_669 VGND VGND VPWR VPWR sky130_fd_sc_hd__decap_3
XTAP_TAPCELL_ROW_62_1139 VGND VPWR sky130_fd_sc_hd__tapvpwrvgnd_1
Xg_row\[1\].g_col\[1\].pe__2084_ g_row\[1\].g_col\[1\].pe__1461_/A g_row\[1\].g_col\[1\].pe__1461_/B
+ g_row\[1\].g_col\[1\].pe__1966_/Y VGND VGND VPWR VPWR g_row\[1\].g_col\[1\].pe__2085_/C
+ sky130_fd_sc_hd__a21o_2
Xg_row\[1\].g_col\[0\].pe__2068_ g_row\[1\].g_col\[0\].pe__2068_/A g_row\[1\].g_col\[0\].pe__2068_/B
+ VGND VGND VPWR VPWR g_row\[1\].g_col\[0\].pe__2068_/Y sky130_fd_sc_hd__nor2_2
Xg_row\[0\].g_col\[1\].pe__2300_ g_row\[0\].g_col\[1\].pe__2300_/A g_row\[0\].g_col\[1\].pe__2300_/B
+ VGND VGND VPWR VPWR g_row\[0\].g_col\[1\].pe__2304_/A sky130_fd_sc_hd__or2_2
XFILLER_21_146 VGND VGND VPWR VPWR sky130_fd_sc_hd__decap_3
Xg_row\[0\].g_col\[1\].pe__2231_ g_row\[0\].g_col\[1\].pe__2231_/A g_row\[0\].g_col\[1\].pe__2231_/B
+ VGND VGND VPWR VPWR g_row\[0\].g_col\[1\].pe__2231_/Y sky130_fd_sc_hd__nand2_2
XFILLER_30_691 VGND VGND VPWR VPWR sky130_fd_sc_hd__decap_3
XTAP_TAPCELL_ROW_32_686 VGND VPWR sky130_fd_sc_hd__tapvpwrvgnd_1
XTAP_TAPCELL_ROW_32_697 VGND VPWR sky130_fd_sc_hd__tapvpwrvgnd_1
Xg_row\[0\].g_col\[0\].pe__2215_ g_row\[0\].g_col\[0\].pe__2241_/B2 g_row\[0\].g_col\[0\].pe__2278_/A2
+ g_row\[0\].g_col\[0\].pe__2278_/B1 g_row\[0\].g_col\[0\].pe__2215_/B2 VGND VGND
+ VPWR VPWR g_row\[0\].g_col\[0\].pe__2239_/A sky130_fd_sc_hd__a22o_2
Xg_row\[0\].g_col\[0\].pe__2146_ g_row\[0\].g_col\[0\].pe__2192_/A g_row\[0\].g_col\[0\].pe__2192_/B
+ VGND VGND VPWR VPWR g_row\[0\].g_col\[0\].pe__2147_/B sky130_fd_sc_hd__xor2_2
Xg_row\[0\].g_col\[1\].pe__2162_ g_row\[0\].g_col\[1\].pe__2148_/A g_row\[0\].g_col\[1\].pe__2162_/B
+ VGND VGND VPWR VPWR g_row\[0\].g_col\[1\].pe__2231_/A sky130_fd_sc_hd__and2b_2
Xg_row\[1\].g_col\[1\].pe_hold2208 g_row\[1\].g_col\[1\].pe_hold2980/X VGND VGND VPWR
+ VPWR g_row\[1\].g_col\[1\].pe__2713_/D sky130_fd_sc_hd__clkbuf_2
Xg_row\[0\].g_col\[1\].pe__2093_ g_row\[0\].g_col\[1\].pe__2094_/B g_row\[0\].g_col\[1\].pe__2094_/C
+ g_row\[0\].g_col\[1\].pe__2094_/A VGND VGND VPWR VPWR g_row\[0\].g_col\[1\].pe__2184_/C
+ sky130_fd_sc_hd__a21o_2
XTAP_TAPCELL_ROW_77_1360 VGND VPWR sky130_fd_sc_hd__tapvpwrvgnd_1
XTAP_TAPCELL_ROW_77_1371 VGND VPWR sky130_fd_sc_hd__tapvpwrvgnd_1
Xg_row\[0\].g_col\[0\].pe__2077_ g_row\[0\].g_col\[0\].pe__2077_/A g_row\[0\].g_col\[0\].pe__2119_/B
+ VGND VGND VPWR VPWR g_row\[0\].g_col\[0\].pe__2078_/B sky130_fd_sc_hd__xnor2_2
Xg_row\[1\].g_col\[1\].pe__1937_ g_row\[1\].g_col\[1\].pe__1882_/A g_row\[1\].g_col\[1\].pe__1882_/B
+ g_row\[1\].g_col\[1\].pe__1936_/X VGND VGND VPWR VPWR g_row\[1\].g_col\[1\].pe__1952_/A
+ sky130_fd_sc_hd__o21a_2
XFILLER_89_625 VGND VGND VPWR VPWR sky130_fd_sc_hd__fill_1
Xg_row\[1\].g_col\[1\].pe__1868_ g_row\[1\].g_col\[1\].pe__1868_/A g_row\[1\].g_col\[1\].pe__1868_/B
+ VGND VGND VPWR VPWR g_row\[1\].g_col\[1\].pe__1878_/A sky130_fd_sc_hd__xor2_2
XFILLER_77_809 VGND VGND VPWR VPWR sky130_fd_sc_hd__decap_3
XTAP_TAPCELL_ROW_90_1560 VGND VPWR sky130_fd_sc_hd__tapvpwrvgnd_1
Xhold2200 hold2200/A VGND VGND VPWR VPWR hold2200/X sky130_fd_sc_hd__clkbuf_2
XFILLER_57_500 VGND VGND VPWR VPWR sky130_fd_sc_hd__decap_3
Xhold1510 hold3390/X VGND VGND VPWR VPWR hold3391/A sky130_fd_sc_hd__clkbuf_2
Xg_row\[1\].g_col\[1\].pe__1799_ g_row\[1\].g_col\[1\].pe__1804_/A g_row\[1\].g_col\[1\].pe__2692_/Q
+ g_row\[1\].g_col\[1\].pe__1805_/A2 g_row\[1\].g_col\[1\].pe__1804_/B VGND VGND VPWR
+ VPWR g_row\[1\].g_col\[1\].pe__1800_/B sky130_fd_sc_hd__a22o_2
XFILLER_57_522 VGND VGND VPWR VPWR sky130_fd_sc_hd__decap_3
XFILLER_57_544 VGND VGND VPWR VPWR sky130_fd_sc_hd__decap_3
XFILLER_69_393 VGND VGND VPWR VPWR sky130_fd_sc_hd__fill_2
Xhold1521 hold2574/X VGND VGND VPWR VPWR hold2575/A sky130_fd_sc_hd__clkbuf_2
Xhold1532 hold3408/X VGND VGND VPWR VPWR hold3409/A sky130_fd_sc_hd__clkbuf_2
Xhold1543 hold3348/X VGND VGND VPWR VPWR hold3349/A sky130_fd_sc_hd__clkbuf_2
XFILLER_29_246 VGND VGND VPWR VPWR sky130_fd_sc_hd__decap_3
XFILLER_84_363 VGND VGND VPWR VPWR sky130_fd_sc_hd__fill_1
Xhold1554 hold2664/X VGND VGND VPWR VPWR hold2665/A sky130_fd_sc_hd__clkbuf_2
Xhold1565 hold3429/X VGND VGND VPWR VPWR hold3430/A sky130_fd_sc_hd__clkbuf_2
Xhold1576 hold3432/X VGND VGND VPWR VPWR hold3433/A sky130_fd_sc_hd__clkbuf_2
Xg_row\[0\].g_col\[1\].pe__1946_ g_row\[0\].g_col\[1\].pe__1946_/A VGND VGND VPWR
+ VPWR g_row\[0\].g_col\[1\].pe__2455_/A sky130_fd_sc_hd__inv_2
XFILLER_72_547 VGND VGND VPWR VPWR sky130_fd_sc_hd__fill_1
Xhold1587 hold2736/X VGND VGND VPWR VPWR hold2737/A sky130_fd_sc_hd__clkbuf_2
Xhold1598 hold3527/X VGND VGND VPWR VPWR hold3528/A sky130_fd_sc_hd__clkbuf_2
Xg_row\[1\].g_col\[0\].pe_place915 g_row\[1\].g_col\[0\].pe__2163_/B VGND VGND VPWR
+ VPWR g_row\[1\].g_col\[0\].pe__1715_/B sky130_fd_sc_hd__buf_6
Xg_row\[0\].g_col\[1\].pe__1877_ g_row\[0\].g_col\[1\].pe__1932_/B g_row\[0\].g_col\[1\].pe__1877_/B
+ VGND VGND VPWR VPWR g_row\[0\].g_col\[1\].pe__1878_/B sky130_fd_sc_hd__xnor2_2
Xg_row\[1\].g_col\[0\].pe_place926 g_row\[1\].g_col\[0\].pe__1642_/A VGND VGND VPWR
+ VPWR g_row\[1\].g_col\[0\].pe__1808_/A sky130_fd_sc_hd__buf_6
XFILLER_25_474 VGND VGND VPWR VPWR sky130_fd_sc_hd__fill_2
Xg_row\[1\].g_col\[0\].pe_place1081 place1082/X VGND VGND VPWR VPWR g_row\[1\].g_col\[0\].pe__1965_/A
+ sky130_fd_sc_hd__buf_6
Xg_row\[1\].g_col\[0\].pe_place1070 g_row\[1\].g_col\[0\].pe__2728_/Q VGND VGND VPWR
+ VPWR g_row\[1\].g_col\[0\].pe__2125_/C sky130_fd_sc_hd__buf_6
XFILLER_40_466 VGND VGND VPWR VPWR sky130_fd_sc_hd__fill_2
XTAP_TAPCELL_ROW_51_973 VGND VPWR sky130_fd_sc_hd__tapvpwrvgnd_1
Xg_row\[0\].g_col\[1\].pe__2429_ g_row\[0\].g_col\[1\].pe__2751_/Q g_row\[0\].g_col\[1\].pe__2429_/B
+ VGND VGND VPWR VPWR g_row\[0\].g_col\[1\].pe__2478_/B sky130_fd_sc_hd__xnor2_2
XTAP_TAPCELL_ROW_10_358 VGND VPWR sky130_fd_sc_hd__tapvpwrvgnd_1
Xg_row\[0\].g_col\[0\].pe_place1179 g_row\[0\].g_col\[0\].pe__1910_/A VGND VGND VPWR
+ VPWR g_row\[0\].g_col\[0\].pe__1816_/A sky130_fd_sc_hd__buf_6
XFILLER_0_551 VGND VGND VPWR VPWR sky130_fd_sc_hd__fill_2
XFILLER_88_680 VGND VGND VPWR VPWR sky130_fd_sc_hd__fill_2
XFILLER_48_533 VGND VGND VPWR VPWR sky130_fd_sc_hd__decap_3
Xhold3490 hold3490/A VGND VGND VPWR VPWR hold3490/X sky130_fd_sc_hd__clkbuf_2
Xg_row\[1\].g_col\[0\].pe__1370_ g_row\[1\].g_col\[0\].pe__2769_/Q g_row\[1\].g_col\[0\].pe__2768_/Q
+ g_row\[1\].g_col\[0\].pe__1366_/B g_row\[1\].g_col\[0\].pe__2594_/B2 VGND VGND VPWR
+ VPWR g_row\[1\].g_col\[0\].pe__1371_/B sky130_fd_sc_hd__o31a_2
XFILLER_48_555 VGND VGND VPWR VPWR sky130_fd_sc_hd__fill_1
XFILLER_57_72 VGND VGND VPWR VPWR sky130_fd_sc_hd__decap_3
XFILLER_63_525 VGND VGND VPWR VPWR sky130_fd_sc_hd__decap_3
XFILLER_31_444 VGND VGND VPWR VPWR sky130_fd_sc_hd__decap_3
XFILLER_12_680 VGND VGND VPWR VPWR sky130_fd_sc_hd__decap_3
Xg_row\[0\].g_col\[0\].pe__2000_ g_row\[0\].g_col\[0\].pe__1935_/A g_row\[0\].g_col\[0\].pe__1998_/X
+ g_row\[0\].g_col\[0\].pe__1999_/X VGND VGND VPWR VPWR g_row\[0\].g_col\[0\].pe__2001_/B
+ sky130_fd_sc_hd__o21a_2
XFILLER_8_695 VGND VGND VPWR VPWR sky130_fd_sc_hd__decap_3
XPHY_EDGE_ROW_9_Right_9 VGND VGND VPWR VPWR sky130_fd_sc_hd__decap_3
Xg_row\[1\].g_col\[1\].pe__2771_ _303_/CLK g_row\[1\].g_col\[1\].pe__2771_/D VGND
+ VGND VPWR VPWR g_row\[1\].g_col\[1\].pe__2771_/Q sky130_fd_sc_hd__dfxtp_2
Xg_row\[1\].g_col\[0\].pe__2755_ clkbuf_leaf_55_clk/X g_row\[1\].g_col\[0\].pe__2755_/D
+ VGND VGND VPWR VPWR g_row\[1\].g_col\[0\].pe__2755_/Q sky130_fd_sc_hd__dfxtp_2
XTAP_TAPCELL_ROW_59_1090 VGND VPWR sky130_fd_sc_hd__tapvpwrvgnd_1
Xg_row\[1\].g_col\[1\].pe__1722_ g_row\[1\].g_col\[1\].pe__1722_/A g_row\[1\].g_col\[1\].pe__1722_/B
+ VGND VGND VPWR VPWR g_row\[1\].g_col\[1\].pe__1723_/B sky130_fd_sc_hd__xnor2_2
Xg_row\[1\].g_col\[0\].pe__1706_ place1098/X g_row\[1\].g_col\[0\].pe__1729_/A2 g_row\[1\].g_col\[0\].pe__1729_/A3
+ g_row\[1\].g_col\[0\].pe__1729_/B1 place1096/X VGND VGND VPWR VPWR g_row\[1\].g_col\[0\].pe__1707_/B
+ sky130_fd_sc_hd__a32o_2
Xg_row\[1\].g_col\[1\].pe__1653_ g_row\[1\].g_col\[1\].pe__1739_/A g_row\[1\].g_col\[1\].pe__1653_/B
+ VGND VGND VPWR VPWR g_row\[1\].g_col\[1\].pe__1656_/A sky130_fd_sc_hd__xor2_2
Xg_row\[1\].g_col\[0\].pe__2686_ g_row\[1\].g_col\[0\].pe__2686_/A g_row\[1\].g_col\[0\].pe__2686_/B
+ VGND VGND VPWR VPWR g_row\[1\].g_col\[0\].pe__2686_/X sky130_fd_sc_hd__or2_2
Xg_row\[1\].g_col\[0\].pe__1637_ g_row\[1\].g_col\[0\].pe__1846_/A g_row\[1\].g_col\[0\].pe__1847_/B
+ VGND VGND VPWR VPWR g_row\[1\].g_col\[0\].pe__1844_/B sky130_fd_sc_hd__xnor2_2
XTAP_TAPCELL_ROW_72_1290 VGND VPWR sky130_fd_sc_hd__tapvpwrvgnd_1
Xg_row\[1\].g_col\[1\].pe__1584_ g_row\[1\].g_col\[1\].pe__1584_/A g_row\[1\].g_col\[1\].pe__1584_/B
+ VGND VGND VPWR VPWR g_row\[1\].g_col\[1\].pe__1584_/Y sky130_fd_sc_hd__nor2_2
Xg_row\[1\].g_col\[0\].pe__1568_ g_row\[1\].g_col\[0\].pe__1596_/A g_row\[1\].g_col\[0\].pe__1596_/B
+ VGND VGND VPWR VPWR g_row\[1\].g_col\[0\].pe__1571_/A sky130_fd_sc_hd__xor2_2
Xg_row\[0\].g_col\[1\].pe__1800_ g_row\[0\].g_col\[1\].pe__1808_/A g_row\[0\].g_col\[1\].pe__1800_/B
+ VGND VGND VPWR VPWR g_row\[0\].g_col\[1\].pe__1801_/C sky130_fd_sc_hd__xnor2_2
Xg_row\[0\].g_col\[0\].pe__2764_ clkbuf_leaf_50_clk/X g_row\[0\].g_col\[0\].pe__2764_/D
+ VGND VGND VPWR VPWR g_row\[0\].g_col\[0\].pe__2764_/Q sky130_fd_sc_hd__dfxtp_2
XFILLER_26_227 VGND VGND VPWR VPWR sky130_fd_sc_hd__decap_3
XFILLER_54_514 VGND VGND VPWR VPWR sky130_fd_sc_hd__decap_3
Xg_row\[0\].g_col\[0\].pe__1715_ place1222/X g_row\[0\].g_col\[0\].pe__1715_/B VGND
+ VGND VPWR VPWR g_row\[0\].g_col\[0\].pe__1724_/S sky130_fd_sc_hd__nand2_2
Xg_row\[0\].g_col\[1\].pe__1731_ g_row\[0\].g_col\[1\].pe__1734_/A g_row\[0\].g_col\[1\].pe__1734_/B
+ VGND VGND VPWR VPWR g_row\[0\].g_col\[1\].pe__1758_/A sky130_fd_sc_hd__xor2_2
Xg_row\[1\].g_col\[0\].pe_hold1785 g_row\[1\].g_col\[0\].pe_hold2948/X VGND VGND VPWR
+ VPWR g_row\[1\].g_col\[0\].pe__2698_/D sky130_fd_sc_hd__clkbuf_2
Xg_row\[1\].g_col\[0\].pe_hold1774 g_row\[1\].g_col\[0\].pe__2655_/X VGND VGND VPWR
+ VPWR g_row\[1\].g_col\[0\].pe__2656_/C1 sky130_fd_sc_hd__clkbuf_2
Xg_row\[1\].g_col\[0\].pe__1499_ g_row\[1\].g_col\[0\].pe__1499_/A g_row\[1\].g_col\[0\].pe__1499_/B
+ VGND VGND VPWR VPWR g_row\[1\].g_col\[0\].pe__1500_/B sky130_fd_sc_hd__xor2_2
XTAP_TAPCELL_ROW_37_767 VGND VPWR sky130_fd_sc_hd__tapvpwrvgnd_1
Xg_row\[0\].g_col\[0\].pe__2695_ _289_/CLK g_row\[0\].g_col\[0\].pe__2695_/D VGND
+ VGND VPWR VPWR place1212/A sky130_fd_sc_hd__dfxtp_2
Xg_row\[0\].g_col\[1\].pe__1662_ g_row\[0\].g_col\[1\].pe__1662_/A g_row\[0\].g_col\[1\].pe__1662_/B
+ VGND VGND VPWR VPWR g_row\[0\].g_col\[1\].pe__1663_/B sky130_fd_sc_hd__xor2_2
Xg_row\[1\].g_col\[1\].pe__2205_ g_row\[1\].g_col\[1\].pe__2388_/A g_row\[1\].g_col\[1\].pe__2204_/Y
+ g_row\[1\].g_col\[1\].pe__2167_/A g_row\[1\].g_col\[1\].pe__2165_/A VGND VGND VPWR
+ VPWR g_row\[1\].g_col\[1\].pe__2207_/A sky130_fd_sc_hd__a211o_2
XFILLER_35_783 VGND VGND VPWR VPWR sky130_fd_sc_hd__fill_1
Xg_row\[0\].g_col\[0\].pe__1646_ place1212/X g_row\[0\].g_col\[0\].pe__1732_/A2 g_row\[0\].g_col\[0\].pe__1732_/B1
+ place1213/X VGND VGND VPWR VPWR g_row\[0\].g_col\[0\].pe__1647_/B sky130_fd_sc_hd__a22o_2
Xg_row\[0\].g_col\[0\].pe__1577_ place1201/X g_row\[0\].g_col\[0\].pe__1982_/B g_row\[0\].g_col\[0\].pe__1424_/Y
+ place1204/X VGND VGND VPWR VPWR g_row\[0\].g_col\[0\].pe__1578_/B sky130_fd_sc_hd__a22o_2
Xg_row\[0\].g_col\[1\].pe__1593_ g_row\[0\].g_col\[1\].pe__1594_/A g_row\[0\].g_col\[1\].pe__1594_/B
+ VGND VGND VPWR VPWR g_row\[0\].g_col\[1\].pe__1593_/Y sky130_fd_sc_hd__nor2_2
Xg_row\[1\].g_col\[1\].pe__2136_ g_row\[1\].g_col\[1\].pe__2136_/A g_row\[1\].g_col\[1\].pe__2136_/B
+ VGND VGND VPWR VPWR g_row\[1\].g_col\[1\].pe__2143_/A sky130_fd_sc_hd__and2_2
Xg_row\[1\].g_col\[1\].pe__2067_ g_row\[1\].g_col\[1\].pe__2067_/A g_row\[1\].g_col\[1\].pe__2059_/A
+ VGND VGND VPWR VPWR g_row\[1\].g_col\[1\].pe__2110_/A sky130_fd_sc_hd__nor2b_2
XTAP_TAPCELL_ROW_79_1400 VGND VPWR sky130_fd_sc_hd__tapvpwrvgnd_1
Xg_row\[0\].g_col\[1\].pe__2214_ g_row\[0\].g_col\[1\].pe__2169_/B g_row\[0\].g_col\[1\].pe__2172_/B
+ g_row\[0\].g_col\[1\].pe__2167_/X VGND VGND VPWR VPWR g_row\[0\].g_col\[1\].pe__2219_/A
+ sky130_fd_sc_hd__a21o_2
Xg_row\[0\].g_col\[1\].pe__2145_ g_row\[0\].g_col\[1\].pe__2145_/A g_row\[0\].g_col\[1\].pe__2104_/A
+ VGND VGND VPWR VPWR g_row\[0\].g_col\[1\].pe__2192_/B sky130_fd_sc_hd__nor2b_4
Xg_row\[0\].g_col\[0\].pe__2129_ g_row\[0\].g_col\[0\].pe__2129_/A g_row\[0\].g_col\[0\].pe__2129_/B
+ VGND VGND VPWR VPWR g_row\[0\].g_col\[0\].pe__2132_/A sky130_fd_sc_hd__nor2_2
Xg_row\[0\].g_col\[1\].pe__2076_ g_row\[0\].g_col\[1\].pe__2136_/A g_row\[0\].g_col\[1\].pe__2136_/B
+ VGND VGND VPWR VPWR g_row\[0\].g_col\[1\].pe__2119_/B sky130_fd_sc_hd__xor2_2
XFILLER_49_308 VGND VGND VPWR VPWR sky130_fd_sc_hd__fill_1
XFILLER_85_661 VGND VGND VPWR VPWR sky130_fd_sc_hd__decap_3
XFILLER_72_322 VGND VGND VPWR VPWR sky130_fd_sc_hd__fill_1
XFILLER_73_834 VGND VGND VPWR VPWR sky130_fd_sc_hd__fill_2
Xg_row\[0\].g_col\[1\].pe__1929_ g_row\[0\].g_col\[1\].pe__1874_/A g_row\[0\].g_col\[1\].pe__1874_/B
+ g_row\[0\].g_col\[1\].pe__1928_/X VGND VGND VPWR VPWR g_row\[0\].g_col\[1\].pe__1994_/B
+ sky130_fd_sc_hd__a21oi_2
XFILLER_17_249 VGND VGND VPWR VPWR sky130_fd_sc_hd__fill_1
XFILLER_60_528 VGND VGND VPWR VPWR sky130_fd_sc_hd__decap_3
XTAP_TAPCELL_ROW_15_428 VGND VPWR sky130_fd_sc_hd__tapvpwrvgnd_1
XTAP_TAPCELL_ROW_15_439 VGND VPWR sky130_fd_sc_hd__tapvpwrvgnd_1
Xinput1294 hold3476/X VGND VGND VPWR VPWR hold3477/A sky130_fd_sc_hd__buf_2
Xg_row\[1\].g_col\[0\].pe__2540_ g_row\[1\].g_col\[0\].pe__2544_/B g_row\[1\].g_col\[0\].pe__2539_/X
+ g_row\[1\].g_col\[0\].pe__2559_/A VGND VGND VPWR VPWR g_row\[1\].g_col\[0\].pe__2540_/X
+ sky130_fd_sc_hd__a21o_2
XFILLER_68_639 VGND VGND VPWR VPWR sky130_fd_sc_hd__decap_3
Xg_row\[1\].g_col\[0\].pe__2471_ g_row\[1\].g_col\[0\].pe__2471_/A g_row\[1\].g_col\[0\].pe__2495_/A
+ g_row\[1\].g_col\[0\].pe__2471_/C VGND VGND VPWR VPWR g_row\[1\].g_col\[0\].pe__2505_/A
+ sky130_fd_sc_hd__and3_2
XFILLER_67_127 VGND VGND VPWR VPWR sky130_fd_sc_hd__fill_1
Xg_row\[1\].g_col\[0\].pe__1422_ g_row\[1\].g_col\[0\].pe__1789_/A g_row\[1\].g_col\[0\].pe__2727_/Q
+ g_row\[1\].g_col\[0\].pe__2726_/Q VGND VGND VPWR VPWR g_row\[1\].g_col\[0\].pe__1424_/A
+ sky130_fd_sc_hd__nand3b_2
XFILLER_83_609 VGND VGND VPWR VPWR sky130_fd_sc_hd__fill_2
Xg_row\[1\].g_col\[0\].pe__1353_ g_row\[1\].g_col\[0\].pe__2762_/Q g_row\[1\].g_col\[0\].pe__1353_/B
+ VGND VGND VPWR VPWR output1386/A sky130_fd_sc_hd__xor2_2
XFILLER_90_141 VGND VGND VPWR VPWR sky130_fd_sc_hd__fill_1
Xg_row\[0\].g_col\[0\].pe__1500_ g_row\[0\].g_col\[0\].pe__1500_/A g_row\[0\].g_col\[0\].pe__1500_/B
+ VGND VGND VPWR VPWR g_row\[0\].g_col\[0\].pe__1510_/B sky130_fd_sc_hd__xor2_2
XTAP_TAPCELL_ROW_34_715 VGND VPWR sky130_fd_sc_hd__tapvpwrvgnd_1
Xg_row\[0\].g_col\[0\].pe__2480_ g_row\[0\].g_col\[0\].pe__2478_/A g_row\[0\].g_col\[0\].pe__2478_/B
+ g_row\[0\].g_col\[0\].pe__2479_/X VGND VGND VPWR VPWR g_row\[0\].g_col\[0\].pe__2585_/A
+ sky130_fd_sc_hd__o21ai_2
XFILLER_32_720 VGND VGND VPWR VPWR sky130_fd_sc_hd__fill_1
XTAP_TAPCELL_ROW_34_726 VGND VPWR sky130_fd_sc_hd__tapvpwrvgnd_1
Xg_row\[0\].g_col\[0\].pe__1431_ g_row\[0\].g_col\[0\].pe__1804_/A place1199/X place1201/X
+ g_row\[0\].g_col\[0\].pe__1804_/B VGND VGND VPWR VPWR g_row\[0\].g_col\[0\].pe__1432_/B
+ sky130_fd_sc_hd__a22o_2
XFILLER_31_252 VGND VGND VPWR VPWR sky130_fd_sc_hd__fill_2
XFILLER_90_3 VGND VGND VPWR VPWR sky130_fd_sc_hd__fill_2
Xg_row\[0\].g_col\[0\].pe__1362_ g_row\[0\].g_col\[0\].pe__2766_/Q g_row\[0\].g_col\[0\].pe__1361_/B
+ g_row\[0\].g_col\[0\].pe__2776_/A VGND VGND VPWR VPWR g_row\[0\].g_col\[0\].pe__1363_/B
+ sky130_fd_sc_hd__o21ai_2
Xg_row\[1\].g_col\[1\].pe__2754_ clkbuf_leaf_72_clk/X g_row\[1\].g_col\[1\].pe__2754_/D
+ VGND VGND VPWR VPWR g_row\[1\].g_col\[1\].pe__2754_/Q sky130_fd_sc_hd__dfxtp_2
Xg_row\[1\].g_col\[0\].pe__2738_ clkbuf_leaf_55_clk/X g_row\[1\].g_col\[0\].pe__2738_/D
+ VGND VGND VPWR VPWR g_row\[1\].g_col\[0\].pe__2738_/Q sky130_fd_sc_hd__dfxtp_2
XFILLER_59_617 VGND VGND VPWR VPWR sky130_fd_sc_hd__decap_3
Xg_row\[1\].g_col\[1\].pe__2685_ g_row\[1\].g_col\[1\].pe__2685_/A1 g_row\[1\].g_col\[1\].pe__2680_/B
+ g_row\[1\].g_col\[1\].pe__2684_/X g_row\[1\].g_col\[1\].pe__2687_/C1 VGND VGND VPWR
+ VPWR g_row\[1\].g_col\[1\].pe__2685_/X sky130_fd_sc_hd__o211a_2
Xg_row\[1\].g_col\[1\].pe__1705_ g_row\[1\].g_col\[1\].pe__1728_/A g_row\[1\].g_col\[1\].pe__1705_/B
+ VGND VGND VPWR VPWR g_row\[1\].g_col\[1\].pe__1709_/A sky130_fd_sc_hd__xnor2_2
Xg_row\[1\].g_col\[0\].pe__2669_ g_row\[1\].g_col\[0\].pe__2669_/A g_row\[1\].g_col\[0\].pe__2669_/B
+ VGND VGND VPWR VPWR g_row\[1\].g_col\[0\].pe__2669_/X sky130_fd_sc_hd__or2_2
XFILLER_86_425 VGND VGND VPWR VPWR sky130_fd_sc_hd__fill_2
Xg_row\[1\].g_col\[1\].pe__1636_ g_row\[1\].g_col\[1\].pe__1845_/B g_row\[1\].g_col\[1\].pe__1636_/B
+ VGND VGND VPWR VPWR g_row\[1\].g_col\[1\].pe__1847_/B sky130_fd_sc_hd__xor2_2
Xg_row\[1\].g_col\[1\].pe_place820 g_row\[1\].g_col\[1\].pe__2590_/A VGND VGND VPWR
+ VPWR g_row\[1\].g_col\[1\].pe__2559_/A sky130_fd_sc_hd__buf_6
Xg_row\[1\].g_col\[1\].pe_place831 g_row\[1\].g_col\[1\].pe__1541_/X VGND VGND VPWR
+ VPWR g_row\[1\].g_col\[1\].pe__2313_/B1 sky130_fd_sc_hd__buf_6
Xg_row\[1\].g_col\[1\].pe__1567_ g_row\[1\].g_col\[1\].pe__1673_/A g_row\[1\].g_col\[1\].pe__1567_/B
+ VGND VGND VPWR VPWR g_row\[1\].g_col\[1\].pe__1596_/B sky130_fd_sc_hd__xnor2_2
Xg_row\[1\].g_col\[0\].pe_hold2261 g_row\[1\].g_col\[0\].pe__2404_/X VGND VGND VPWR
+ VPWR g_row\[1\].g_col\[0\].pe__2405_/B sky130_fd_sc_hd__clkbuf_2
Xg_row\[1\].g_col\[1\].pe_place875 g_row\[1\].g_col\[1\].pe__1558_/B VGND VGND VPWR
+ VPWR g_row\[1\].g_col\[1\].pe__2177_/A2 sky130_fd_sc_hd__buf_6
Xg_row\[0\].g_col\[1\].pe__2763_ clkbuf_leaf_4_clk/X g_row\[0\].g_col\[1\].pe__2763_/D
+ VGND VGND VPWR VPWR g_row\[0\].g_col\[1\].pe__2763_/Q sky130_fd_sc_hd__dfxtp_2
XFILLER_15_709 VGND VGND VPWR VPWR sky130_fd_sc_hd__decap_3
XFILLER_39_396 VGND VGND VPWR VPWR sky130_fd_sc_hd__fill_2
XFILLER_54_322 VGND VGND VPWR VPWR sky130_fd_sc_hd__fill_1
Xg_row\[0\].g_col\[0\].pe__2747_ _309_/CLK g_row\[0\].g_col\[0\].pe__2747_/D VGND
+ VGND VPWR VPWR g_row\[0\].g_col\[0\].pe__2747_/Q sky130_fd_sc_hd__dfxtp_2
Xg_row\[0\].g_col\[1\].pe__1714_ g_row\[0\].g_col\[1\].pe__1714_/A g_row\[0\].g_col\[1\].pe__1714_/B
+ g_row\[0\].g_col\[1\].pe__1714_/C VGND VGND VPWR VPWR g_row\[0\].g_col\[1\].pe__1742_/B
+ sky130_fd_sc_hd__nand3_2
Xg_row\[1\].g_col\[1\].pe_place886 g_row\[1\].g_col\[1\].pe__2085_/A VGND VGND VPWR
+ VPWR g_row\[1\].g_col\[1\].pe__2165_/A sky130_fd_sc_hd__buf_6
Xg_row\[1\].g_col\[1\].pe_place897 g_row\[1\].g_col\[1\].pe__2656_/A1 VGND VGND VPWR
+ VPWR g_row\[1\].g_col\[1\].pe__2670_/A1 sky130_fd_sc_hd__buf_6
Xg_row\[1\].g_col\[1\].pe__1498_ g_row\[1\].g_col\[1\].pe__1676_/A g_row\[1\].g_col\[1\].pe__1498_/B
+ VGND VGND VPWR VPWR g_row\[1\].g_col\[1\].pe__1499_/B sky130_fd_sc_hd__xnor2_2
Xg_row\[0\].g_col\[0\].pe__2678_ g_row\[0\].g_col\[0\].pe__2686_/B g_row\[0\].g_col\[0\].pe__2678_/B
+ VGND VGND VPWR VPWR g_row\[0\].g_col\[0\].pe__2678_/Y sky130_fd_sc_hd__nand2_2
Xg_row\[0\].g_col\[1\].pe__2694_ _276_/CLK g_row\[0\].g_col\[1\].pe__2694_/D VGND
+ VGND VPWR VPWR g_row\[0\].g_col\[1\].pe__2694_/Q sky130_fd_sc_hd__dfxtp_2
XFILLER_35_580 VGND VGND VPWR VPWR sky130_fd_sc_hd__decap_3
XTAP_TAPCELL_ROW_85_1481 VGND VPWR sky130_fd_sc_hd__tapvpwrvgnd_1
XTAP_TAPCELL_ROW_85_1492 VGND VPWR sky130_fd_sc_hd__tapvpwrvgnd_1
Xg_row\[0\].g_col\[0\].pe__1629_ g_row\[0\].g_col\[0\].pe__1629_/A g_row\[0\].g_col\[0\].pe__1629_/B
+ VGND VGND VPWR VPWR g_row\[0\].g_col\[0\].pe__1883_/A sky130_fd_sc_hd__xnor2_2
Xg_row\[0\].g_col\[1\].pe__1645_ g_row\[0\].g_col\[1\].pe__1648_/A g_row\[0\].g_col\[1\].pe__1648_/B
+ VGND VGND VPWR VPWR g_row\[0\].g_col\[1\].pe__1688_/A sky130_fd_sc_hd__xor2_2
XFILLER_80_39 VGND VGND VPWR VPWR sky130_fd_sc_hd__fill_1
Xg_row\[0\].g_col\[1\].pe__1576_ g_row\[0\].g_col\[1\].pe__1626_/A g_row\[0\].g_col\[1\].pe__1626_/B
+ VGND VGND VPWR VPWR g_row\[0\].g_col\[1\].pe__1579_/A sky130_fd_sc_hd__xor2_2
Xg_row\[1\].g_col\[1\].pe__2119_ g_row\[1\].g_col\[1\].pe__2077_/A g_row\[1\].g_col\[1\].pe__2119_/B
+ VGND VGND VPWR VPWR g_row\[1\].g_col\[1\].pe__2119_/X sky130_fd_sc_hd__and2b_2
XFILLER_2_602 VGND VGND VPWR VPWR sky130_fd_sc_hd__decap_3
Xg_row\[0\].g_col\[1\].pe__2128_ g_row\[0\].g_col\[1\].pe__2128_/A g_row\[0\].g_col\[1\].pe__2128_/B
+ g_row\[0\].g_col\[1\].pe__2128_/C VGND VGND VPWR VPWR g_row\[0\].g_col\[1\].pe__2129_/B
+ sky130_fd_sc_hd__and3_2
Xg_row\[0\].g_col\[1\].pe__2059_ g_row\[0\].g_col\[1\].pe__2059_/A g_row\[0\].g_col\[1\].pe__2067_/A
+ VGND VGND VPWR VPWR g_row\[0\].g_col\[1\].pe__2153_/B sky130_fd_sc_hd__xnor2_2
XFILLER_77_403 VGND VGND VPWR VPWR sky130_fd_sc_hd__decap_3
XFILLER_77_447 VGND VGND VPWR VPWR sky130_fd_sc_hd__fill_1
XFILLER_18_525 VGND VGND VPWR VPWR sky130_fd_sc_hd__decap_3
XFILLER_73_620 VGND VGND VPWR VPWR sky130_fd_sc_hd__fill_1
XFILLER_45_333 VGND VGND VPWR VPWR sky130_fd_sc_hd__decap_3
XFILLER_61_837 VGND VGND VPWR VPWR sky130_fd_sc_hd__decap_3
XFILLER_72_141 VGND VGND VPWR VPWR sky130_fd_sc_hd__fill_1
Xg_row\[0\].g_col\[0\].pe_hold2304 g_row\[0\].g_col\[0\].pe_hold3068/X VGND VGND VPWR
+ VPWR g_row\[0\].g_col\[0\].pe__2626_/A2 sky130_fd_sc_hd__clkbuf_2
Xg_row\[0\].g_col\[0\].pe_hold2315 g_row\[0\].g_col\[0\].pe_hold2936/X VGND VGND VPWR
+ VPWR g_row\[0\].g_col\[0\].pe_hold2937/A sky130_fd_sc_hd__clkbuf_2
Xg_row\[0\].g_col\[0\].pe_hold3038 _321_/Q VGND VGND VPWR VPWR g_row\[0\].g_col\[0\].pe_hold3038/X
+ sky130_fd_sc_hd__clkbuf_2
XFILLER_60_369 VGND VGND VPWR VPWR sky130_fd_sc_hd__decap_3
Xg_row\[0\].g_col\[0\].pe_hold1636 g_row\[0\].g_col\[0\].pe__2396_/Y VGND VGND VPWR
+ VPWR g_row\[0\].g_col\[0\].pe__2753_/D sky130_fd_sc_hd__clkbuf_2
Xg_row\[1\].g_col\[0\].pe__1971_ g_row\[1\].g_col\[0\].pe__1461_/A g_row\[1\].g_col\[0\].pe__1461_/B
+ hold3129/A VGND VGND VPWR VPWR g_row\[1\].g_col\[0\].pe__1972_/C sky130_fd_sc_hd__a21bo_2
XFILLER_9_278 VGND VGND VPWR VPWR sky130_fd_sc_hd__fill_2
Xclkload15 clkload15/A VGND VGND VPWR VPWR clkload15/X sky130_fd_sc_hd__buf_2
Xoutput1406 output1406/A VGND VGND VPWR VPWR results_flat[56] sky130_fd_sc_hd__buf_2
Xoutput1417 output1417/A VGND VGND VPWR VPWR results_flat[8] sky130_fd_sc_hd__buf_2
Xg_row\[1\].g_col\[1\].pe_hold3092 g_row\[1\].g_col\[1\].pe__1397_/X VGND VGND VPWR
+ VPWR g_row\[1\].g_col\[1\].pe_hold3092/X sky130_fd_sc_hd__clkbuf_2
Xg_row\[0\].g_col\[0\].pe__1980_ g_row\[0\].g_col\[0\].pe__1980_/A g_row\[0\].g_col\[0\].pe__1980_/B
+ g_row\[0\].g_col\[0\].pe__1980_/C VGND VGND VPWR VPWR g_row\[0\].g_col\[0\].pe__1980_/X
+ sky130_fd_sc_hd__or3_4
Xg_row\[1\].g_col\[1\].pe__2470_ g_row\[1\].g_col\[1\].pe__2551_/A g_row\[1\].g_col\[1\].pe__2551_/B
+ g_row\[1\].g_col\[1\].pe__2551_/C g_row\[1\].g_col\[1\].pe__2444_/A g_row\[1\].g_col\[1\].pe__2496_/B
+ VGND VGND VPWR VPWR g_row\[1\].g_col\[1\].pe__2471_/C sky130_fd_sc_hd__a311o_2
Xg_row\[1\].g_col\[1\].pe__1421_ g_row\[1\].g_col\[1\].pe__2726_/Q g_row\[1\].g_col\[1\].pe__2727_/Q
+ VGND VGND VPWR VPWR g_row\[1\].g_col\[1\].pe__1982_/B sky130_fd_sc_hd__xor2_2
Xg_row\[1\].g_col\[0\].pe__2454_ g_row\[1\].g_col\[0\].pe__2759_/Q g_row\[1\].g_col\[0\].pe__2464_/B
+ VGND VGND VPWR VPWR g_row\[1\].g_col\[0\].pe__2538_/B sky130_fd_sc_hd__or2_2
Xg_row\[1\].g_col\[1\].pe_place1003 g_row\[1\].g_col\[1\].pe__1540_/C VGND VGND VPWR
+ VPWR g_row\[1\].g_col\[1\].pe__2368_/A sky130_fd_sc_hd__buf_6
Xg_row\[1\].g_col\[0\].pe__2385_ g_row\[1\].g_col\[0\].pe__2385_/A g_row\[1\].g_col\[0\].pe__2385_/B
+ VGND VGND VPWR VPWR g_row\[1\].g_col\[0\].pe__2392_/A sky130_fd_sc_hd__nand2_2
Xg_row\[1\].g_col\[0\].pe__1405_ g_row\[1\].g_col\[0\].pe__1838_/A place1233/X VGND
+ VGND VPWR VPWR g_row\[1\].g_col\[0\].pe__2157_/A sky130_fd_sc_hd__nor2_2
XFILLER_48_193 VGND VGND VPWR VPWR sky130_fd_sc_hd__decap_3
XFILLER_64_642 VGND VGND VPWR VPWR sky130_fd_sc_hd__fill_2
Xg_row\[1\].g_col\[1\].pe_place1014 g_row\[1\].g_col\[1\].pe__2686_/A VGND VGND VPWR
+ VPWR g_row\[1\].g_col\[1\].pe__1785_/A sky130_fd_sc_hd__buf_6
Xg_row\[1\].g_col\[1\].pe_place1025 g_row\[1\].g_col\[1\].pe__2625_/B VGND VGND VPWR
+ VPWR g_row\[1\].g_col\[1\].pe__2030_/A sky130_fd_sc_hd__buf_6
Xg_row\[1\].g_col\[1\].pe_place1036 g_row\[1\].g_col\[1\].pe__2696_/Q VGND VGND VPWR
+ VPWR g_row\[1\].g_col\[1\].pe__2138_/B2 sky130_fd_sc_hd__buf_6
Xg_row\[1\].g_col\[1\].pe__1352_ g_row\[1\].g_col\[1\].pe__2761_/Q g_row\[1\].g_col\[1\].pe__2760_/Q
+ g_row\[1\].g_col\[1\].pe__1348_/B g_row\[1\].g_col\[1\].pe__2771_/Q VGND VGND VPWR
+ VPWR g_row\[1\].g_col\[1\].pe__1353_/B sky130_fd_sc_hd__o31a_2
XFILLER_64_686 VGND VGND VPWR VPWR sky130_fd_sc_hd__decap_3
Xg_row\[0\].g_col\[0\].pe__2532_ g_row\[0\].g_col\[0\].pe__2533_/A g_row\[0\].g_col\[0\].pe__2533_/B
+ VGND VGND VPWR VPWR g_row\[0\].g_col\[0\].pe__2534_/B sky130_fd_sc_hd__nor2_2
Xg_row\[1\].g_col\[1\].pe_place1047 g_row\[1\].g_col\[1\].pe__2599_/B VGND VGND VPWR
+ VPWR g_row\[1\].g_col\[1\].pe__1657_/A sky130_fd_sc_hd__buf_6
XFILLER_36_399 VGND VGND VPWR VPWR sky130_fd_sc_hd__decap_3
Xg_row\[0\].g_col\[0\].pe__2463_ g_row\[0\].g_col\[0\].pe__2519_/A g_row\[0\].g_col\[0\].pe__2519_/B
+ g_row\[0\].g_col\[0\].pe__2462_/Y VGND VGND VPWR VPWR g_row\[0\].g_col\[0\].pe__2526_/B
+ sky130_fd_sc_hd__o21ai_2
Xg_row\[0\].g_col\[0\].pe__1414_ g_row\[0\].g_col\[0\].pe__2725_/Q g_row\[0\].g_col\[0\].pe__2724_/Q
+ g_row\[0\].g_col\[0\].pe__2726_/Q VGND VGND VPWR VPWR g_row\[0\].g_col\[0\].pe__1414_/X
+ sky130_fd_sc_hd__a21o_2
XFILLER_32_561 VGND VGND VPWR VPWR sky130_fd_sc_hd__decap_3
Xg_row\[0\].g_col\[0\].pe__2394_ g_row\[0\].g_col\[0\].pe__2378_/X g_row\[0\].g_col\[0\].pe__2384_/Y
+ g_row\[0\].g_col\[0\].pe__2392_/Y g_row\[0\].g_col\[0\].pe__2394_/B1 VGND VGND VPWR
+ VPWR g_row\[0\].g_col\[0\].pe__2394_/X sky130_fd_sc_hd__a31o_2
Xg_row\[0\].g_col\[1\].pe__1361_ g_row\[0\].g_col\[1\].pe__2766_/Q g_row\[0\].g_col\[1\].pe__1361_/B
+ VGND VGND VPWR VPWR output1373/A sky130_fd_sc_hd__xor2_2
Xclkload9 clkload9/A VGND VGND VPWR VPWR clkload9/X sky130_fd_sc_hd__buf_2
Xg_row\[0\].g_col\[0\].pe__1345_ g_row\[0\].g_col\[0\].pe__2758_/Q g_row\[0\].g_col\[0\].pe__2757_/Q
+ g_row\[0\].g_col\[0\].pe__2775_/A g_row\[0\].g_col\[0\].pe__1348_/A VGND VGND VPWR
+ VPWR g_row\[0\].g_col\[0\].pe__1346_/B sky130_fd_sc_hd__o31a_2
XFILLER_87_701 VGND VGND VPWR VPWR sky130_fd_sc_hd__decap_3
Xg_row\[1\].g_col\[1\].pe__2737_ clkbuf_leaf_83_clk/X g_row\[1\].g_col\[1\].pe__2737_/D
+ VGND VGND VPWR VPWR g_row\[1\].g_col\[1\].pe__2737_/Q sky130_fd_sc_hd__dfxtp_2
XFILLER_87_723 VGND VGND VPWR VPWR sky130_fd_sc_hd__decap_3
XFILLER_87_745 VGND VGND VPWR VPWR sky130_fd_sc_hd__decap_3
XFILLER_87_756 VGND VGND VPWR VPWR sky130_fd_sc_hd__fill_1
Xg_row\[1\].g_col\[1\].pe__2668_ g_row\[1\].g_col\[1\].pe__2670_/A1 g_row\[1\].g_col\[1\].pe__2668_/A2
+ g_row\[1\].g_col\[1\].pe__2670_/B1 g_row\[1\].g_col\[1\].pe__2668_/C1 VGND VGND
+ VPWR VPWR g_row\[1\].g_col\[1\].pe__2668_/X sky130_fd_sc_hd__o211a_2
XFILLER_55_620 VGND VGND VPWR VPWR sky130_fd_sc_hd__decap_3
XTAP_TAPCELL_ROW_87_1510 VGND VPWR sky130_fd_sc_hd__tapvpwrvgnd_1
Xg_row\[1\].g_col\[1\].pe__2599_ place1247/X g_row\[1\].g_col\[1\].pe__2599_/B VGND
+ VGND VPWR VPWR g_row\[1\].g_col\[1\].pe__2599_/X sky130_fd_sc_hd__or2_2
Xg_row\[1\].g_col\[1\].pe__1619_ g_row\[1\].g_col\[1\].pe__1875_/A g_row\[1\].g_col\[1\].pe__1875_/B
+ VGND VGND VPWR VPWR g_row\[1\].g_col\[1\].pe__1622_/A sky130_fd_sc_hd__nand2_2
Xg_row\[1\].g_col\[0\].pe_hold2080 g_row\[1\].g_col\[0\].pe__2643_/X VGND VGND VPWR
+ VPWR g_row\[1\].g_col\[0\].pe__2644_/C1 sky130_fd_sc_hd__clkbuf_2
Xg_row\[0\].g_col\[1\].pe_hold2401 g_row\[0\].g_col\[1\].pe__2455_/A VGND VGND VPWR
+ VPWR g_row\[0\].g_col\[1\].pe__1947_/B1 sky130_fd_sc_hd__clkbuf_2
XFILLER_67_491 VGND VGND VPWR VPWR sky130_fd_sc_hd__fill_2
XTAP_TAPCELL_ROW_87_1521 VGND VPWR sky130_fd_sc_hd__tapvpwrvgnd_1
XFILLER_55_664 VGND VGND VPWR VPWR sky130_fd_sc_hd__decap_3
Xg_row\[0\].g_col\[1\].pe__2746_ clkbuf_leaf_3_clk/X g_row\[0\].g_col\[1\].pe__2746_/D
+ VGND VGND VPWR VPWR g_row\[0\].g_col\[1\].pe__2746_/Q sky130_fd_sc_hd__dfxtp_2
Xg_row\[0\].g_col\[1\].pe__2677_ hold2149/X place1239/X g_row\[0\].g_col\[1\].pe__2677_/B1
+ g_row\[0\].g_col\[1\].pe__2676_/Y VGND VGND VPWR VPWR g_row\[0\].g_col\[1\].pe__2677_/X
+ sky130_fd_sc_hd__o211a_2
Xg_row\[0\].g_col\[1\].pe__1628_ g_row\[0\].g_col\[1\].pe__1879_/A g_row\[0\].g_col\[1\].pe__1879_/B
+ VGND VGND VPWR VPWR g_row\[0\].g_col\[1\].pe__1629_/B sky130_fd_sc_hd__xor2_2
XFILLER_11_712 VGND VGND VPWR VPWR sky130_fd_sc_hd__fill_2
XFILLER_11_723 VGND VGND VPWR VPWR sky130_fd_sc_hd__decap_3
XFILLER_23_583 VGND VGND VPWR VPWR sky130_fd_sc_hd__fill_1
XTAP_TAPCELL_ROW_25_578 VGND VPWR sky130_fd_sc_hd__tapvpwrvgnd_1
XTAP_TAPCELL_ROW_25_589 VGND VPWR sky130_fd_sc_hd__tapvpwrvgnd_1
XFILLER_50_391 VGND VGND VPWR VPWR sky130_fd_sc_hd__fill_2
X_161_ _171_/A _161_/B_N VGND VGND VPWR VPWR _161_/Y sky130_fd_sc_hd__nor2b_4
Xg_row\[0\].g_col\[1\].pe__1559_ g_row\[0\].g_col\[1\].pe__2599_/B g_row\[0\].g_col\[1\].pe__1558_/B
+ g_row\[0\].g_col\[1\].pe__1558_/C VGND VGND VPWR VPWR g_row\[0\].g_col\[1\].pe__1560_/B
+ sky130_fd_sc_hd__a21o_2
XFILLER_10_277 VGND VGND VPWR VPWR sky130_fd_sc_hd__fill_2
XFILLER_78_701 VGND VGND VPWR VPWR sky130_fd_sc_hd__fill_2
XFILLER_49_95 VGND VGND VPWR VPWR sky130_fd_sc_hd__decap_3
XFILLER_93_726 VGND VGND VPWR VPWR sky130_fd_sc_hd__fill_2
XTAP_TAPCELL_ROW_5_281 VGND VPWR sky130_fd_sc_hd__tapvpwrvgnd_1
XFILLER_92_247 VGND VGND VPWR VPWR sky130_fd_sc_hd__fill_1
XTAP_TAPCELL_ROW_5_292 VGND VPWR sky130_fd_sc_hd__tapvpwrvgnd_1
Xg_row\[1\].g_col\[0\].pe__2170_ g_row\[1\].g_col\[0\].pe__1965_/A g_row\[1\].g_col\[0\].pe__1471_/X
+ g_row\[1\].g_col\[0\].pe__1474_/Y g_row\[1\].g_col\[0\].pe__2030_/A VGND VGND VPWR
+ VPWR g_row\[1\].g_col\[0\].pe__2171_/B sky130_fd_sc_hd__a22o_2
XANTENNA_140 _338_/Q VGND VGND VPWR VPWR sky130_fd_sc_hd__diode_2
XANTENNA_151 hold3314/A VGND VGND VPWR VPWR sky130_fd_sc_hd__diode_2
XFILLER_61_623 VGND VGND VPWR VPWR sky130_fd_sc_hd__decap_3
Xg_row\[0\].g_col\[0\].pe_hold2101 g_row\[0\].g_col\[0\].pe__2770_/Q VGND VGND VPWR
+ VPWR g_row\[0\].g_col\[0\].pe__2591_/A1 sky130_fd_sc_hd__clkbuf_2
XANTENNA_162 _309_/D VGND VGND VPWR VPWR sky130_fd_sc_hd__diode_2
XANTENNA_173 hold3282/X VGND VGND VPWR VPWR sky130_fd_sc_hd__diode_2
XFILLER_14_550 VGND VGND VPWR VPWR sky130_fd_sc_hd__decap_3
XTAP_TAPCELL_ROW_44_865 VGND VPWR sky130_fd_sc_hd__tapvpwrvgnd_1
XTAP_TAPCELL_ROW_44_876 VGND VPWR sky130_fd_sc_hd__tapvpwrvgnd_1
Xg_row\[0\].g_col\[0\].pe_hold2178 g_row\[0\].g_col\[0\].pe_hold3038/X VGND VGND VPWR
+ VPWR g_row\[0\].g_col\[0\].pe__1398_/A sky130_fd_sc_hd__clkbuf_2
Xg_row\[1\].g_col\[1\].pe__1970_ g_row\[1\].g_col\[1\].pe__1970_/A g_row\[1\].g_col\[1\].pe__2163_/B
+ VGND VGND VPWR VPWR g_row\[1\].g_col\[1\].pe__1972_/B sky130_fd_sc_hd__nand2_2
Xg_row\[1\].g_col\[0\].pe__1954_ g_row\[1\].g_col\[0\].pe__1857_/A g_row\[1\].g_col\[0\].pe__1857_/B
+ g_row\[1\].g_col\[0\].pe__1908_/B g_row\[1\].g_col\[0\].pe__1907_/B g_row\[1\].g_col\[0\].pe__1907_/A
+ VGND VGND VPWR VPWR g_row\[1\].g_col\[0\].pe__2002_/A sky130_fd_sc_hd__a32o_2
XFILLER_53_3 VGND VGND VPWR VPWR sky130_fd_sc_hd__decap_3
XFILLER_6_760 VGND VGND VPWR VPWR sky130_fd_sc_hd__decap_3
XFILLER_6_782 VGND VGND VPWR VPWR sky130_fd_sc_hd__decap_3
Xg_row\[1\].g_col\[0\].pe__1885_ g_row\[1\].g_col\[0\].pe__1885_/A g_row\[1\].g_col\[0\].pe__1896_/A
+ VGND VGND VPWR VPWR g_row\[1\].g_col\[0\].pe__1897_/B sky130_fd_sc_hd__xnor2_2
XTAP_TAPCELL_ROW_54_1019 VGND VPWR sky130_fd_sc_hd__tapvpwrvgnd_1
Xhold3308 hold3308/A VGND VGND VPWR VPWR hold3308/X sky130_fd_sc_hd__clkbuf_2
Xhold3319 b_inputs_flat[28] VGND VGND VPWR VPWR hold3319/X sky130_fd_sc_hd__clkbuf_2
Xhold2607 hold3363/X VGND VGND VPWR VPWR hold3364/A sky130_fd_sc_hd__clkbuf_2
Xhold2618 hold3396/X VGND VGND VPWR VPWR hold3397/A sky130_fd_sc_hd__clkbuf_2
Xhold2629 hold2629/A VGND VGND VPWR VPWR _319_/D sky130_fd_sc_hd__clkbuf_2
Xg_row\[1\].g_col\[1\].pe__2522_ g_row\[1\].g_col\[1\].pe__2595_/A g_row\[1\].g_col\[1\].pe__2522_/B
+ VGND VGND VPWR VPWR g_row\[1\].g_col\[1\].pe__2757_/D sky130_fd_sc_hd__and2_2
XFILLER_84_704 VGND VGND VPWR VPWR sky130_fd_sc_hd__decap_3
Xg_row\[0\].g_col\[0\].pe__1963_ g_row\[0\].g_col\[0\].pe__1963_/A g_row\[0\].g_col\[0\].pe__1963_/B
+ VGND VGND VPWR VPWR g_row\[0\].g_col\[0\].pe__1964_/B sky130_fd_sc_hd__xor2_2
Xg_row\[1\].g_col\[0\].pe__2506_ g_row\[1\].g_col\[0\].pe__2571_/A g_row\[1\].g_col\[0\].pe__2567_/A
+ g_row\[1\].g_col\[0\].pe__2506_/C g_row\[1\].g_col\[0\].pe__2505_/X VGND VGND VPWR
+ VPWR g_row\[1\].g_col\[0\].pe__2507_/B sky130_fd_sc_hd__or4b_4
XFILLER_28_119 VGND VGND VPWR VPWR sky130_fd_sc_hd__fill_2
Xg_row\[0\].g_col\[0\].pe__1894_ g_row\[0\].g_col\[0\].pe__1894_/A g_row\[0\].g_col\[0\].pe__1894_/B
+ VGND VGND VPWR VPWR g_row\[0\].g_col\[0\].pe__1894_/Y sky130_fd_sc_hd__nand2_2
Xg_row\[1\].g_col\[1\].pe__2453_ g_row\[1\].g_col\[1\].pe__2742_/Q g_row\[1\].g_col\[1\].pe__2453_/B
+ VGND VGND VPWR VPWR g_row\[1\].g_col\[1\].pe__2464_/B sky130_fd_sc_hd__xnor2_2
Xg_row\[1\].g_col\[0\].pe__2437_ g_row\[1\].g_col\[0\].pe__2438_/B g_row\[1\].g_col\[0\].pe__2764_/Q
+ VGND VGND VPWR VPWR g_row\[1\].g_col\[0\].pe__2491_/B sky130_fd_sc_hd__and2b_2
XFILLER_37_620 VGND VGND VPWR VPWR sky130_fd_sc_hd__decap_3
XFILLER_83_225 VGND VGND VPWR VPWR sky130_fd_sc_hd__fill_2
Xg_row\[1\].g_col\[1\].pe__2384_ g_row\[1\].g_col\[1\].pe__2375_/A g_row\[1\].g_col\[1\].pe__2356_/A
+ g_row\[1\].g_col\[1\].pe__2375_/B VGND VGND VPWR VPWR g_row\[1\].g_col\[1\].pe__2384_/Y
+ sky130_fd_sc_hd__o21ai_2
Xg_row\[1\].g_col\[1\].pe__1404_ place1249/X VGND VGND VPWR VPWR g_row\[1\].g_col\[1\].pe__1838_/A
+ sky130_fd_sc_hd__inv_2
XTAP_TAPCELL_ROW_69_1240 VGND VPWR sky130_fd_sc_hd__tapvpwrvgnd_1
XTAP_TAPCELL_ROW_69_1251 VGND VPWR sky130_fd_sc_hd__tapvpwrvgnd_1
Xg_row\[1\].g_col\[0\].pe__2368_ g_row\[1\].g_col\[0\].pe__2368_/A g_row\[1\].g_col\[0\].pe__2368_/B
+ g_row\[1\].g_col\[0\].pe__2367_/X VGND VGND VPWR VPWR g_row\[1\].g_col\[0\].pe__2387_/A
+ sky130_fd_sc_hd__or3b_2
Xg_row\[0\].g_col\[1\].pe__2600_ g_row\[0\].g_col\[1\].pe__2670_/A1 place1221/X g_row\[0\].g_col\[1\].pe__2679_/C1
+ g_row\[0\].g_col\[1\].pe__2599_/X VGND VGND VPWR VPWR g_row\[0\].g_col\[1\].pe__2690_/D
+ sky130_fd_sc_hd__o211a_2
XFILLER_52_623 VGND VGND VPWR VPWR sky130_fd_sc_hd__decap_3
XFILLER_52_645 VGND VGND VPWR VPWR sky130_fd_sc_hd__fill_1
Xg_row\[1\].g_col\[0\].pe__2299_ g_row\[1\].g_col\[0\].pe__2299_/A g_row\[1\].g_col\[0\].pe__2299_/B
+ VGND VGND VPWR VPWR g_row\[1\].g_col\[0\].pe__2300_/B sky130_fd_sc_hd__or2_4
Xg_row\[0\].g_col\[1\].pe__2531_ g_row\[0\].g_col\[1\].pe__2526_/A g_row\[0\].g_col\[1\].pe__2526_/B
+ g_row\[0\].g_col\[1\].pe__2458_/A VGND VGND VPWR VPWR g_row\[0\].g_col\[1\].pe__2533_/A
+ sky130_fd_sc_hd__a21oi_2
XTAP_TAPCELL_ROW_82_1440 VGND VPWR sky130_fd_sc_hd__tapvpwrvgnd_1
Xg_row\[0\].g_col\[0\].pe__2446_ g_row\[0\].g_col\[0\].pe__2761_/Q g_row\[0\].g_col\[0\].pe__2446_/B
+ VGND VGND VPWR VPWR g_row\[0\].g_col\[0\].pe__2497_/B sky130_fd_sc_hd__and2b_2
Xg_row\[0\].g_col\[1\].pe__2462_ g_row\[0\].g_col\[1\].pe__2757_/Q g_row\[0\].g_col\[1\].pe__2462_/B
+ VGND VGND VPWR VPWR g_row\[0\].g_col\[1\].pe__2462_/Y sky130_fd_sc_hd__nand2_2
XTAP_TAPCELL_ROW_22_537 VGND VPWR sky130_fd_sc_hd__tapvpwrvgnd_1
Xg_row\[0\].g_col\[0\].pe__2377_ g_row\[0\].g_col\[0\].pe__2377_/A g_row\[0\].g_col\[0\].pe__2377_/B
+ VGND VGND VPWR VPWR g_row\[0\].g_col\[0\].pe__2377_/Y sky130_fd_sc_hd__nand2_2
Xg_row\[0\].g_col\[1\].pe__1413_ g_row\[0\].g_col\[1\].pe__1728_/A g_row\[0\].g_col\[1\].pe__1413_/B
+ VGND VGND VPWR VPWR g_row\[0\].g_col\[1\].pe__1428_/A sky130_fd_sc_hd__xnor2_2
Xg_row\[0\].g_col\[1\].pe__2393_ g_row\[0\].g_col\[1\].pe__2378_/X g_row\[0\].g_col\[1\].pe__2384_/Y
+ g_row\[0\].g_col\[1\].pe__2392_/Y VGND VGND VPWR VPWR g_row\[0\].g_col\[1\].pe__2393_/Y
+ sky130_fd_sc_hd__a21oi_2
Xg_row\[0\].g_col\[1\].pe__1344_ g_row\[0\].g_col\[1\].pe__2758_/Q g_row\[0\].g_col\[1\].pe__1344_/B
+ VGND VGND VPWR VPWR output1364/A sky130_fd_sc_hd__xnor2_2
XFILLER_47_406 VGND VGND VPWR VPWR sky130_fd_sc_hd__fill_2
XFILLER_75_737 VGND VGND VPWR VPWR sky130_fd_sc_hd__fill_2
XTAP_TAPCELL_ROW_2_240 VGND VPWR sky130_fd_sc_hd__tapvpwrvgnd_1
Xg_row\[0\].g_col\[1\].pe_hold2220 g_row\[0\].g_col\[1\].pe__2673_/D VGND VGND VPWR
+ VPWR g_row\[0\].g_col\[1\].pe__2685_/A1 sky130_fd_sc_hd__clkbuf_2
XFILLER_55_461 VGND VGND VPWR VPWR sky130_fd_sc_hd__decap_3
XFILLER_15_314 VGND VGND VPWR VPWR sky130_fd_sc_hd__fill_1
XFILLER_28_697 VGND VGND VPWR VPWR sky130_fd_sc_hd__decap_3
Xg_row\[0\].g_col\[1\].pe__2729_ clkbuf_leaf_92_clk/X g_row\[0\].g_col\[1\].pe__2729_/D
+ VGND VGND VPWR VPWR g_row\[0\].g_col\[1\].pe__2729_/Q sky130_fd_sc_hd__dfxtp_2
XTAP_TAPCELL_ROW_41_824 VGND VPWR sky130_fd_sc_hd__tapvpwrvgnd_1
XFILLER_23_391 VGND VGND VPWR VPWR sky130_fd_sc_hd__fill_1
X_213_ _235_/A _213_/B_N VGND VGND VPWR VPWR _213_/Y sky130_fd_sc_hd__nor2b_4
XPHY_EDGE_ROW_2_Left_96 VGND VGND VPWR VPWR sky130_fd_sc_hd__decap_3
Xg_row\[0\].g_col\[0\].pe_place971 g_row\[0\].g_col\[0\].pe__1558_/B VGND VGND VPWR
+ VPWR g_row\[0\].g_col\[0\].pe__2363_/A2 sky130_fd_sc_hd__buf_6
Xg_row\[0\].g_col\[0\].pe_place982 g_row\[0\].g_col\[0\].pe__2123_/A VGND VGND VPWR
+ VPWR g_row\[0\].g_col\[0\].pe__1912_/A sky130_fd_sc_hd__buf_6
Xg_row\[0\].g_col\[0\].pe_place993 g_row\[0\].g_col\[0\].pe__1950_/A VGND VGND VPWR
+ VPWR g_row\[0\].g_col\[0\].pe__2628_/A1 sky130_fd_sc_hd__buf_6
Xg_row\[1\].g_col\[0\].pe__1670_ place1099/X g_row\[1\].g_col\[0\].pe__1748_/B g_row\[1\].g_col\[0\].pe__1738_/B1
+ hold2198/A VGND VGND VPWR VPWR g_row\[1\].g_col\[0\].pe__1671_/B sky130_fd_sc_hd__a22o_2
XFILLER_3_785 VGND VGND VPWR VPWR sky130_fd_sc_hd__decap_3
XFILLER_66_704 VGND VGND VPWR VPWR sky130_fd_sc_hd__decap_3
XFILLER_78_531 VGND VGND VPWR VPWR sky130_fd_sc_hd__fill_1
XFILLER_78_564 VGND VGND VPWR VPWR sky130_fd_sc_hd__decap_3
Xg_row\[1\].g_col\[0\].pe_hold2816 g_row\[1\].g_col\[0\].pe__2708_/Q VGND VGND VPWR
+ VPWR g_row\[1\].g_col\[0\].pe__2645_/B sky130_fd_sc_hd__clkbuf_2
XFILLER_38_406 VGND VGND VPWR VPWR sky130_fd_sc_hd__fill_1
Xg_row\[1\].g_col\[0\].pe_hold2849 g_row\[1\].g_col\[0\].pe_hold2849/A VGND VGND VPWR
+ VPWR g_row\[1\].g_col\[0\].pe__2711_/D sky130_fd_sc_hd__clkbuf_2
XFILLER_19_631 VGND VGND VPWR VPWR sky130_fd_sc_hd__decap_3
XFILLER_93_545 VGND VGND VPWR VPWR sky130_fd_sc_hd__fill_2
XTAP_TAPCELL_ROW_49_946 VGND VPWR sky130_fd_sc_hd__tapvpwrvgnd_1
Xg_row\[1\].g_col\[0\].pe__2222_ g_row\[1\].g_col\[0\].pe__2222_/A g_row\[1\].g_col\[0\].pe__2253_/A
+ VGND VGND VPWR VPWR g_row\[1\].g_col\[0\].pe__2222_/X sky130_fd_sc_hd__or2_2
XFILLER_18_141 VGND VGND VPWR VPWR sky130_fd_sc_hd__decap_3
XFILLER_34_601 VGND VGND VPWR VPWR sky130_fd_sc_hd__decap_3
XFILLER_65_258 VGND VGND VPWR VPWR sky130_fd_sc_hd__decap_3
XFILLER_81_718 VGND VGND VPWR VPWR sky130_fd_sc_hd__fill_1
XFILLER_81_729 VGND VGND VPWR VPWR sky130_fd_sc_hd__decap_3
XFILLER_93_589 VGND VGND VPWR VPWR sky130_fd_sc_hd__fill_2
XFILLER_18_163 VGND VGND VPWR VPWR sky130_fd_sc_hd__decap_3
XFILLER_46_483 VGND VGND VPWR VPWR sky130_fd_sc_hd__decap_3
XFILLER_74_781 VGND VGND VPWR VPWR sky130_fd_sc_hd__decap_3
Xg_row\[1\].g_col\[0\].pe__2153_ g_row\[1\].g_col\[0\].pe__2153_/A g_row\[1\].g_col\[0\].pe__2153_/B
+ g_row\[1\].g_col\[0\].pe__2153_/C VGND VGND VPWR VPWR g_row\[1\].g_col\[0\].pe__2153_/X
+ sky130_fd_sc_hd__and3_2
Xg_row\[1\].g_col\[0\].pe__2084_ g_row\[1\].g_col\[0\].pe__1461_/A g_row\[1\].g_col\[0\].pe__1461_/B
+ g_row\[1\].g_col\[0\].pe__1966_/Y VGND VGND VPWR VPWR g_row\[1\].g_col\[0\].pe__2085_/C
+ sky130_fd_sc_hd__a21o_2
XFILLER_21_317 VGND VGND VPWR VPWR sky130_fd_sc_hd__fill_2
Xg_row\[0\].g_col\[0\].pe__2300_ g_row\[0\].g_col\[0\].pe__2300_/A g_row\[0\].g_col\[0\].pe__2300_/B
+ VGND VGND VPWR VPWR g_row\[0\].g_col\[0\].pe__2304_/A sky130_fd_sc_hd__or2_2
XTAP_TAPCELL_ROW_64_1170 VGND VPWR sky130_fd_sc_hd__tapvpwrvgnd_1
Xg_row\[0\].g_col\[0\].pe__2231_ g_row\[0\].g_col\[0\].pe__2231_/A g_row\[0\].g_col\[0\].pe__2231_/B
+ VGND VGND VPWR VPWR g_row\[0\].g_col\[0\].pe__2231_/Y sky130_fd_sc_hd__nand2_2
Xg_row\[0\].g_col\[0\].pe__2162_ g_row\[0\].g_col\[0\].pe__2148_/A g_row\[0\].g_col\[0\].pe__2162_/B
+ VGND VGND VPWR VPWR g_row\[0\].g_col\[0\].pe__2231_/A sky130_fd_sc_hd__and2b_2
Xg_row\[0\].g_col\[0\].pe__2093_ g_row\[0\].g_col\[0\].pe__2094_/B g_row\[0\].g_col\[0\].pe__2094_/C
+ g_row\[0\].g_col\[0\].pe__2094_/A VGND VGND VPWR VPWR g_row\[0\].g_col\[0\].pe__2184_/C
+ sky130_fd_sc_hd__a21o_2
Xg_row\[1\].g_col\[1\].pe__1953_ g_row\[1\].g_col\[1\].pe__1939_/A g_row\[1\].g_col\[1\].pe__1939_/B
+ g_row\[1\].g_col\[1\].pe__1952_/X VGND VGND VPWR VPWR g_row\[1\].g_col\[1\].pe__2013_/A
+ sky130_fd_sc_hd__a21boi_2
Xg_row\[1\].g_col\[0\].pe__1937_ g_row\[1\].g_col\[0\].pe__1882_/A g_row\[1\].g_col\[0\].pe__1882_/B
+ g_row\[1\].g_col\[0\].pe__1936_/X VGND VGND VPWR VPWR g_row\[1\].g_col\[0\].pe__1952_/A
+ sky130_fd_sc_hd__o21a_2
Xg_row\[1\].g_col\[1\].pe__1884_ g_row\[1\].g_col\[1\].pe__1633_/A g_row\[1\].g_col\[1\].pe__1633_/B
+ g_row\[1\].g_col\[1\].pe__1883_/X VGND VGND VPWR VPWR g_row\[1\].g_col\[1\].pe__1896_/A
+ sky130_fd_sc_hd__o21a_2
Xg_row\[1\].g_col\[0\].pe__1868_ g_row\[1\].g_col\[0\].pe__1868_/A g_row\[1\].g_col\[0\].pe__1868_/B
+ VGND VGND VPWR VPWR g_row\[1\].g_col\[0\].pe__1878_/A sky130_fd_sc_hd__xor2_2
Xhold3138 hold3138/A VGND VGND VPWR VPWR hold3138/X sky130_fd_sc_hd__clkbuf_2
Xg_row\[1\].g_col\[0\].pe__1799_ g_row\[1\].g_col\[0\].pe__1804_/A place1102/X place1104/X
+ g_row\[1\].g_col\[0\].pe__1804_/B VGND VGND VPWR VPWR g_row\[1\].g_col\[0\].pe__1800_/B
+ sky130_fd_sc_hd__a22o_2
Xhold2415 hold3139/X VGND VGND VPWR VPWR hold3140/A sky130_fd_sc_hd__clkbuf_2
Xhold2426 hold3172/X VGND VGND VPWR VPWR hold3173/A sky130_fd_sc_hd__clkbuf_2
Xhold2437 hold2437/A VGND VGND VPWR VPWR _330_/D sky130_fd_sc_hd__clkbuf_2
Xhold3149 hold3149/A VGND VGND VPWR VPWR hold3149/X sky130_fd_sc_hd__clkbuf_2
XFILLER_56_203 VGND VGND VPWR VPWR sky130_fd_sc_hd__fill_1
XFILLER_69_575 VGND VGND VPWR VPWR sky130_fd_sc_hd__decap_3
XPHY_EDGE_ROW_16_Left_110 VGND VGND VPWR VPWR sky130_fd_sc_hd__decap_3
Xg_row\[0\].g_col\[0\].pe__1946_ g_row\[0\].g_col\[0\].pe__1946_/A VGND VGND VPWR
+ VPWR g_row\[0\].g_col\[0\].pe__2455_/A sky130_fd_sc_hd__inv_2
Xhold2448 _161_/Y VGND VGND VPWR VPWR hold2448/X sky130_fd_sc_hd__clkbuf_2
Xhold2459 hold3192/X VGND VGND VPWR VPWR _243_/B_N sky130_fd_sc_hd__clkbuf_2
Xg_row\[1\].g_col\[1\].pe__2505_ g_row\[1\].g_col\[1\].pe__2505_/A g_row\[1\].g_col\[1\].pe__2504_/X
+ VGND VGND VPWR VPWR g_row\[1\].g_col\[1\].pe__2505_/X sky130_fd_sc_hd__or2b_2
Xg_row\[0\].g_col\[1\].pe__1962_ g_row\[0\].g_col\[1\].pe__2024_/A g_row\[0\].g_col\[1\].pe__1962_/B
+ VGND VGND VPWR VPWR g_row\[0\].g_col\[1\].pe__1963_/B sky130_fd_sc_hd__and2_2
Xg_row\[1\].g_col\[1\].pe__2436_ g_row\[1\].g_col\[1\].pe__2436_/A g_row\[1\].g_col\[1\].pe__2436_/B
+ VGND VGND VPWR VPWR g_row\[1\].g_col\[1\].pe__2438_/B sky130_fd_sc_hd__xnor2_2
Xg_row\[0\].g_col\[1\].pe__1893_ _203_/A g_row\[0\].g_col\[1\].pe__1893_/B VGND VGND
+ VPWR VPWR g_row\[0\].g_col\[1\].pe__1893_/Y sky130_fd_sc_hd__nor2_2
XFILLER_25_601 VGND VGND VPWR VPWR sky130_fd_sc_hd__decap_3
XFILLER_72_707 VGND VGND VPWR VPWR sky130_fd_sc_hd__decap_3
Xg_row\[0\].g_col\[0\].pe__1877_ g_row\[0\].g_col\[0\].pe__1932_/B g_row\[0\].g_col\[0\].pe__1877_/B
+ VGND VGND VPWR VPWR g_row\[0\].g_col\[0\].pe__1878_/B sky130_fd_sc_hd__xnor2_2
XFILLER_25_612 VGND VGND VPWR VPWR sky130_fd_sc_hd__decap_3
XFILLER_65_781 VGND VGND VPWR VPWR sky130_fd_sc_hd__decap_3
XTAP_TAPCELL_ROW_27_618 VGND VPWR sky130_fd_sc_hd__tapvpwrvgnd_1
Xg_row\[1\].g_col\[1\].pe__2367_ g_row\[1\].g_col\[1\].pe__2343_/A g_row\[1\].g_col\[1\].pe__2365_/X
+ g_row\[1\].g_col\[1\].pe__2366_/X VGND VGND VPWR VPWR g_row\[1\].g_col\[1\].pe__2367_/X
+ sky130_fd_sc_hd__a21bo_2
Xg_row\[1\].g_col\[1\].pe__2298_ g_row\[1\].g_col\[1\].pe__2298_/A g_row\[1\].g_col\[1\].pe__2263_/X
+ VGND VGND VPWR VPWR g_row\[1\].g_col\[1\].pe__2299_/B sky130_fd_sc_hd__or2b_2
Xg_row\[0\].g_col\[1\].pe__2514_ _199_/A g_row\[0\].g_col\[1\].pe__2514_/B VGND VGND
+ VPWR VPWR g_row\[0\].g_col\[1\].pe__2514_/Y sky130_fd_sc_hd__nor2_2
XFILLER_12_328 VGND VGND VPWR VPWR sky130_fd_sc_hd__decap_3
XFILLER_40_637 VGND VGND VPWR VPWR sky130_fd_sc_hd__fill_2
Xg_row\[0\].g_col\[0\].pe__2429_ g_row\[0\].g_col\[0\].pe__2751_/Q g_row\[0\].g_col\[0\].pe__2429_/B
+ VGND VGND VPWR VPWR g_row\[0\].g_col\[0\].pe__2478_/B sky130_fd_sc_hd__xnor2_2
Xg_row\[0\].g_col\[1\].pe__2445_ g_row\[0\].g_col\[1\].pe__2445_/A g_row\[0\].g_col\[1\].pe__2445_/B
+ VGND VGND VPWR VPWR g_row\[0\].g_col\[1\].pe__2446_/B sky130_fd_sc_hd__xnor2_2
XANTENNA_40 reset VGND VGND VPWR VPWR sky130_fd_sc_hd__diode_2
XANTENNA_51 hold2587/A VGND VGND VPWR VPWR sky130_fd_sc_hd__diode_2
XANTENNA_62 _285_/D VGND VGND VPWR VPWR sky130_fd_sc_hd__diode_2
XANTENNA_73 hold3189/X VGND VGND VPWR VPWR sky130_fd_sc_hd__diode_2
XANTENNA_84 hold3248/X VGND VGND VPWR VPWR sky130_fd_sc_hd__diode_2
Xg_row\[0\].g_col\[1\].pe__2376_ g_row\[0\].g_col\[1\].pe__2377_/A g_row\[0\].g_col\[1\].pe__2359_/B
+ g_row\[0\].g_col\[1\].pe__2377_/B g_row\[0\].g_col\[1\].pe__2356_/A VGND VGND VPWR
+ VPWR g_row\[0\].g_col\[1\].pe__2376_/X sky130_fd_sc_hd__a211o_2
XANTENNA_95 hold3384/X VGND VGND VPWR VPWR sky130_fd_sc_hd__diode_2
XFILLER_21_77 VGND VGND VPWR VPWR sky130_fd_sc_hd__fill_2
XFILLER_21_99 VGND VGND VPWR VPWR sky130_fd_sc_hd__fill_2
XTAP_TAPCELL_ROW_7_310 VGND VPWR sky130_fd_sc_hd__tapvpwrvgnd_1
XTAP_TAPCELL_ROW_7_321 VGND VPWR sky130_fd_sc_hd__tapvpwrvgnd_1
Xg_row\[1\].g_col\[1\].pe_hold2979 hold1778/X VGND VGND VPWR VPWR g_row\[1\].g_col\[1\].pe__2656_/A2
+ sky130_fd_sc_hd__clkbuf_2
XTAP_TAPCELL_ROW_46_905 VGND VPWR sky130_fd_sc_hd__tapvpwrvgnd_1
XFILLER_28_483 VGND VGND VPWR VPWR sky130_fd_sc_hd__fill_1
XFILLER_15_111 VGND VGND VPWR VPWR sky130_fd_sc_hd__fill_1
XFILLER_15_144 VGND VGND VPWR VPWR sky130_fd_sc_hd__decap_3
XFILLER_55_291 VGND VGND VPWR VPWR sky130_fd_sc_hd__fill_2
XFILLER_71_740 VGND VGND VPWR VPWR sky130_fd_sc_hd__decap_3
XFILLER_15_166 VGND VGND VPWR VPWR sky130_fd_sc_hd__fill_2
XFILLER_31_615 VGND VGND VPWR VPWR sky130_fd_sc_hd__fill_1
XFILLER_7_57 VGND VGND VPWR VPWR sky130_fd_sc_hd__decap_3
Xg_row\[1\].g_col\[0\].pe__2771_ clkbuf_leaf_56_clk/X g_row\[1\].g_col\[0\].pe__2771_/D
+ VGND VGND VPWR VPWR g_row\[1\].g_col\[0\].pe__2771_/Q sky130_fd_sc_hd__dfxtp_2
Xg_row\[1\].g_col\[0\].pe__1722_ g_row\[1\].g_col\[0\].pe__1722_/A g_row\[1\].g_col\[0\].pe__1722_/B
+ VGND VGND VPWR VPWR g_row\[1\].g_col\[0\].pe__1723_/B sky130_fd_sc_hd__xnor2_2
Xg_row\[1\].g_col\[0\].pe__1653_ g_row\[1\].g_col\[0\].pe__1816_/A g_row\[1\].g_col\[0\].pe__1653_/B
+ VGND VGND VPWR VPWR g_row\[1\].g_col\[0\].pe__1656_/A sky130_fd_sc_hd__xor2_2
Xg_row\[0\].g_col\[0\].pe__1800_ g_row\[0\].g_col\[0\].pe__1808_/A g_row\[0\].g_col\[0\].pe__1800_/B
+ VGND VGND VPWR VPWR g_row\[0\].g_col\[0\].pe__1801_/C sky130_fd_sc_hd__xnor2_2
Xg_row\[1\].g_col\[0\].pe_hold1912 g_row\[1\].g_col\[0\].pe__2746_/Q VGND VGND VPWR
+ VPWR g_row\[1\].g_col\[0\].pe__2160_/A sky130_fd_sc_hd__clkbuf_2
Xg_row\[1\].g_col\[0\].pe__1584_ g_row\[1\].g_col\[0\].pe__1584_/A g_row\[1\].g_col\[0\].pe__1584_/B
+ VGND VGND VPWR VPWR g_row\[1\].g_col\[0\].pe__1584_/Y sky130_fd_sc_hd__nor2_2
XFILLER_16_3 VGND VGND VPWR VPWR sky130_fd_sc_hd__decap_3
XFILLER_66_523 VGND VGND VPWR VPWR sky130_fd_sc_hd__decap_3
Xg_row\[0\].g_col\[0\].pe__1731_ g_row\[0\].g_col\[0\].pe__1734_/A g_row\[0\].g_col\[0\].pe__1734_/B
+ VGND VGND VPWR VPWR g_row\[0\].g_col\[0\].pe__1758_/A sky130_fd_sc_hd__xor2_2
Xg_row\[1\].g_col\[0\].pe_hold1923 g_row\[1\].g_col\[0\].pe__2514_/Y VGND VGND VPWR
+ VPWR g_row\[1\].g_col\[0\].pe__2756_/D sky130_fd_sc_hd__clkbuf_2
XFILLER_53_239 VGND VGND VPWR VPWR sky130_fd_sc_hd__decap_3
Xg_row\[0\].g_col\[0\].pe__1662_ g_row\[0\].g_col\[0\].pe__1662_/A g_row\[0\].g_col\[0\].pe__1662_/B
+ VGND VGND VPWR VPWR g_row\[0\].g_col\[0\].pe__1663_/B sky130_fd_sc_hd__xor2_2
Xg_row\[1\].g_col\[1\].pe__2221_ g_row\[1\].g_col\[1\].pe__2221_/A g_row\[1\].g_col\[1\].pe__2221_/B
+ VGND VGND VPWR VPWR g_row\[1\].g_col\[1\].pe__2258_/A sky130_fd_sc_hd__xor2_2
Xg_row\[1\].g_col\[0\].pe__2205_ g_row\[1\].g_col\[0\].pe__2388_/A g_row\[1\].g_col\[0\].pe__2204_/Y
+ g_row\[1\].g_col\[0\].pe__2167_/A g_row\[1\].g_col\[0\].pe__2165_/A VGND VGND VPWR
+ VPWR g_row\[1\].g_col\[0\].pe__2207_/A sky130_fd_sc_hd__a211o_2
XFILLER_46_280 VGND VGND VPWR VPWR sky130_fd_sc_hd__decap_3
Xg_row\[0\].g_col\[0\].pe__1593_ g_row\[0\].g_col\[0\].pe__1594_/A g_row\[0\].g_col\[0\].pe__1594_/B
+ VGND VGND VPWR VPWR g_row\[0\].g_col\[0\].pe__1593_/Y sky130_fd_sc_hd__nor2_2
Xg_row\[1\].g_col\[1\].pe__2152_ g_row\[1\].g_col\[1\].pe__1894_/Y g_row\[1\].g_col\[1\].pe__1895_/X
+ g_row\[1\].g_col\[1\].pe__2151_/X VGND VGND VPWR VPWR g_row\[1\].g_col\[1\].pe__2155_/B
+ sky130_fd_sc_hd__a21o_2
Xg_row\[1\].g_col\[0\].pe__2136_ g_row\[1\].g_col\[0\].pe__2136_/A g_row\[1\].g_col\[0\].pe__2136_/B
+ VGND VGND VPWR VPWR g_row\[1\].g_col\[0\].pe__2143_/A sky130_fd_sc_hd__and2_2
XFILLER_34_475 VGND VGND VPWR VPWR sky130_fd_sc_hd__fill_1
XFILLER_61_261 VGND VGND VPWR VPWR sky130_fd_sc_hd__fill_1
Xg_row\[1\].g_col\[1\].pe__2083_ g_row\[1\].g_col\[1\].pe__2083_/A g_row\[1\].g_col\[1\].pe__2163_/B
+ VGND VGND VPWR VPWR g_row\[1\].g_col\[1\].pe__2085_/B sky130_fd_sc_hd__nand2_2
XFILLER_22_648 VGND VGND VPWR VPWR sky130_fd_sc_hd__decap_3
XFILLER_34_497 VGND VGND VPWR VPWR sky130_fd_sc_hd__decap_3
Xg_row\[1\].g_col\[0\].pe__2067_ g_row\[1\].g_col\[0\].pe__2067_/A g_row\[1\].g_col\[0\].pe__2059_/A
+ VGND VGND VPWR VPWR g_row\[1\].g_col\[0\].pe__2110_/A sky130_fd_sc_hd__nor2b_2
XFILLER_21_169 VGND VGND VPWR VPWR sky130_fd_sc_hd__decap_3
Xg_row\[0\].g_col\[1\].pe__2230_ g_row\[0\].g_col\[1\].pe__2238_/A g_row\[0\].g_col\[1\].pe__2238_/B
+ VGND VGND VPWR VPWR g_row\[0\].g_col\[1\].pe__2298_/A sky130_fd_sc_hd__xnor2_2
XTAP_TAPCELL_ROW_32_687 VGND VPWR sky130_fd_sc_hd__tapvpwrvgnd_1
Xg_row\[0\].g_col\[0\].pe__2214_ g_row\[0\].g_col\[0\].pe__2169_/B g_row\[0\].g_col\[0\].pe__2172_/B
+ g_row\[0\].g_col\[0\].pe__2167_/X VGND VGND VPWR VPWR g_row\[0\].g_col\[0\].pe__2219_/A
+ sky130_fd_sc_hd__a21o_2
Xg_row\[0\].g_col\[0\].pe__2145_ g_row\[0\].g_col\[0\].pe__2145_/A g_row\[0\].g_col\[0\].pe__2104_/A
+ VGND VGND VPWR VPWR g_row\[0\].g_col\[0\].pe__2192_/B sky130_fd_sc_hd__nor2b_4
Xg_row\[0\].g_col\[1\].pe__2161_ g_row\[0\].g_col\[1\].pe__2161_/A g_row\[0\].g_col\[1\].pe__2161_/B
+ VGND VGND VPWR VPWR g_row\[0\].g_col\[1\].pe__2161_/Y sky130_fd_sc_hd__nand2_2
Xg_row\[0\].g_col\[1\].pe__2092_ g_row\[0\].g_col\[1\].pe__2091_/A g_row\[0\].g_col\[1\].pe__2091_/B
+ g_row\[0\].g_col\[1\].pe__2091_/C VGND VGND VPWR VPWR g_row\[0\].g_col\[1\].pe__2097_/C
+ sky130_fd_sc_hd__a21oi_2
XTAP_TAPCELL_ROW_77_1361 VGND VPWR sky130_fd_sc_hd__tapvpwrvgnd_1
XTAP_TAPCELL_ROW_77_1372 VGND VPWR sky130_fd_sc_hd__tapvpwrvgnd_1
Xg_row\[0\].g_col\[0\].pe__2076_ g_row\[0\].g_col\[0\].pe__2136_/A g_row\[0\].g_col\[0\].pe__2136_/B
+ VGND VGND VPWR VPWR g_row\[0\].g_col\[0\].pe__2119_/B sky130_fd_sc_hd__xor2_2
Xg_row\[1\].g_col\[1\].pe__1936_ g_row\[1\].g_col\[1\].pe__1936_/A g_row\[1\].g_col\[1\].pe__1936_/B
+ VGND VGND VPWR VPWR g_row\[1\].g_col\[1\].pe__1936_/X sky130_fd_sc_hd__or2_4
Xg_row\[1\].g_col\[1\].pe__1867_ g_row\[1\].g_col\[1\].pe__2348_/A g_row\[1\].g_col\[1\].pe__1867_/B
+ VGND VGND VPWR VPWR g_row\[1\].g_col\[1\].pe__1868_/B sky130_fd_sc_hd__xnor2_2
XTAP_TAPCELL_ROW_90_1561 VGND VPWR sky130_fd_sc_hd__tapvpwrvgnd_1
Xhold1500 hold2550/X VGND VGND VPWR VPWR hold2551/A sky130_fd_sc_hd__clkbuf_2
Xg_row\[1\].g_col\[1\].pe__1798_ g_row\[1\].g_col\[1\].pe__2690_/Q g_row\[1\].g_col\[1\].pe__1801_/B
+ VGND VGND VPWR VPWR g_row\[1\].g_col\[1\].pe__1806_/B sky130_fd_sc_hd__nand2_2
XFILLER_29_214 VGND VGND VPWR VPWR sky130_fd_sc_hd__decap_3
XFILLER_29_225 VGND VGND VPWR VPWR sky130_fd_sc_hd__fill_2
Xhold1511 hold3394/X VGND VGND VPWR VPWR hold3395/A sky130_fd_sc_hd__clkbuf_2
Xhold1522 hold3334/X VGND VGND VPWR VPWR hold3335/A sky130_fd_sc_hd__clkbuf_2
Xhold1533 hold2628/X VGND VGND VPWR VPWR hold2629/A sky130_fd_sc_hd__clkbuf_2
Xhold1544 hold3352/X VGND VGND VPWR VPWR hold3353/A sky130_fd_sc_hd__clkbuf_2
Xg_row\[0\].g_col\[1\].pe__1945_ g_row\[0\].g_col\[1\].pe__1894_/Y g_row\[0\].g_col\[1\].pe__1895_/X
+ g_row\[0\].g_col\[1\].pe__2151_/A VGND VGND VPWR VPWR g_row\[0\].g_col\[1\].pe__2008_/A
+ sky130_fd_sc_hd__a21o_2
XFILLER_45_718 VGND VGND VPWR VPWR sky130_fd_sc_hd__fill_2
Xg_row\[0\].g_col\[0\].pe__1929_ g_row\[0\].g_col\[0\].pe__1874_/A g_row\[0\].g_col\[0\].pe__1874_/B
+ g_row\[0\].g_col\[0\].pe__1928_/X VGND VGND VPWR VPWR g_row\[0\].g_col\[0\].pe__1994_/B
+ sky130_fd_sc_hd__a21oi_2
Xhold1555 hold3369/X VGND VGND VPWR VPWR hold3370/A sky130_fd_sc_hd__clkbuf_2
Xhold1566 hold2670/X VGND VGND VPWR VPWR hold2671/A sky130_fd_sc_hd__clkbuf_2
Xhold1577 hold3436/X VGND VGND VPWR VPWR hold3437/A sky130_fd_sc_hd__clkbuf_2
XFILLER_44_217 VGND VGND VPWR VPWR sky130_fd_sc_hd__decap_3
XFILLER_84_386 VGND VGND VPWR VPWR sky130_fd_sc_hd__fill_2
Xhold1588 hold3467/X VGND VGND VPWR VPWR hold3468/A sky130_fd_sc_hd__clkbuf_2
Xhold1599 hold2748/X VGND VGND VPWR VPWR hold2749/A sky130_fd_sc_hd__clkbuf_2
Xg_row\[1\].g_col\[1\].pe__2419_ g_row\[1\].g_col\[1\].pe__2450_/A1 g_row\[1\].g_col\[1\].pe__2750_/Q
+ g_row\[1\].g_col\[1\].pe__2430_/B VGND VGND VPWR VPWR g_row\[1\].g_col\[1\].pe__2429_/B
+ sky130_fd_sc_hd__a21oi_2
Xg_row\[1\].g_col\[0\].pe_place905 g_row\[1\].g_col\[0\].pe__2363_/A2 VGND VGND VPWR
+ VPWR g_row\[1\].g_col\[0\].pe__1558_/B sky130_fd_sc_hd__buf_6
Xg_row\[0\].g_col\[1\].pe__1876_ g_row\[0\].g_col\[1\].pe__1625_/A g_row\[0\].g_col\[1\].pe__1625_/B
+ g_row\[0\].g_col\[1\].pe__1875_/X VGND VGND VPWR VPWR g_row\[0\].g_col\[1\].pe__1877_/B
+ sky130_fd_sc_hd__a21oi_2
Xg_row\[1\].g_col\[0\].pe_place927 g_row\[1\].g_col\[0\].pe__1838_/A VGND VGND VPWR
+ VPWR g_row\[1\].g_col\[0\].pe__2670_/A1 sky130_fd_sc_hd__buf_6
Xg_row\[1\].g_col\[0\].pe_place916 g_row\[1\].g_col\[0\].pe__2085_/A VGND VGND VPWR
+ VPWR g_row\[1\].g_col\[0\].pe__1864_/A sky130_fd_sc_hd__buf_6
XFILLER_13_615 VGND VGND VPWR VPWR sky130_fd_sc_hd__fill_1
XFILLER_25_453 VGND VGND VPWR VPWR sky130_fd_sc_hd__decap_3
XFILLER_53_762 VGND VGND VPWR VPWR sky130_fd_sc_hd__decap_3
XFILLER_52_283 VGND VGND VPWR VPWR sky130_fd_sc_hd__fill_2
Xg_row\[1\].g_col\[0\].pe_place1071 g_row\[1\].g_col\[0\].pe__1870_/A VGND VGND VPWR
+ VPWR g_row\[1\].g_col\[0\].pe__1730_/A sky130_fd_sc_hd__buf_6
Xg_row\[1\].g_col\[0\].pe_place1060 g_row\[1\].g_col\[0\].pe__2368_/A VGND VGND VPWR
+ VPWR g_row\[1\].g_col\[0\].pe__2321_/A sky130_fd_sc_hd__buf_6
XTAP_TAPCELL_ROW_51_974 VGND VPWR sky130_fd_sc_hd__tapvpwrvgnd_1
XFILLER_21_692 VGND VGND VPWR VPWR sky130_fd_sc_hd__fill_1
Xg_row\[0\].g_col\[1\].pe__2428_ g_row\[0\].g_col\[1\].pe__2427_/B g_row\[0\].g_col\[1\].pe__2769_/Q
+ VGND VGND VPWR VPWR g_row\[0\].g_col\[1\].pe__2494_/B sky130_fd_sc_hd__and2b_2
XFILLER_20_191 VGND VGND VPWR VPWR sky130_fd_sc_hd__decap_3
XFILLER_5_803 VGND VGND VPWR VPWR sky130_fd_sc_hd__decap_3
XTAP_TAPCELL_ROW_10_359 VGND VPWR sky130_fd_sc_hd__tapvpwrvgnd_1
Xg_row\[0\].g_col\[1\].pe__2359_ g_row\[0\].g_col\[1\].pe__2377_/A g_row\[0\].g_col\[1\].pe__2359_/B
+ VGND VGND VPWR VPWR g_row\[0\].g_col\[1\].pe__2359_/Y sky130_fd_sc_hd__xnor2_2
XFILLER_5_836 VGND VGND VPWR VPWR sky130_fd_sc_hd__decap_3
XFILLER_79_169 VGND VGND VPWR VPWR sky130_fd_sc_hd__decap_3
Xhold3491 hold3491/A VGND VGND VPWR VPWR hold3491/X sky130_fd_sc_hd__clkbuf_2
Xhold3480 b_inputs_flat[6] VGND VGND VPWR VPWR hold3480/X sky130_fd_sc_hd__clkbuf_2
XFILLER_57_84 VGND VGND VPWR VPWR sky130_fd_sc_hd__decap_3
XFILLER_75_342 VGND VGND VPWR VPWR sky130_fd_sc_hd__fill_1
XFILLER_91_802 VGND VGND VPWR VPWR sky130_fd_sc_hd__fill_1
Xhold2790 _141_/Y VGND VGND VPWR VPWR hold2790/X sky130_fd_sc_hd__clkbuf_2
XFILLER_16_442 VGND VGND VPWR VPWR sky130_fd_sc_hd__fill_2
XFILLER_71_570 VGND VGND VPWR VPWR sky130_fd_sc_hd__decap_3
XFILLER_31_423 VGND VGND VPWR VPWR sky130_fd_sc_hd__fill_1
XFILLER_31_489 VGND VGND VPWR VPWR sky130_fd_sc_hd__decap_3
XFILLER_8_674 VGND VGND VPWR VPWR sky130_fd_sc_hd__fill_2
XFILLER_7_184 VGND VGND VPWR VPWR sky130_fd_sc_hd__decap_3
Xg_row\[1\].g_col\[1\].pe__2770_ _302_/CLK g_row\[1\].g_col\[1\].pe__2770_/D VGND
+ VGND VPWR VPWR g_row\[1\].g_col\[1\].pe__2770_/Q sky130_fd_sc_hd__dfxtp_2
Xg_row\[1\].g_col\[0\].pe__2754_ clkbuf_leaf_54_clk/X g_row\[1\].g_col\[0\].pe__2754_/D
+ VGND VGND VPWR VPWR g_row\[1\].g_col\[0\].pe__2754_/Q sky130_fd_sc_hd__dfxtp_2
XTAP_TAPCELL_ROW_59_1091 VGND VPWR sky130_fd_sc_hd__tapvpwrvgnd_1
Xg_row\[1\].g_col\[1\].pe__1721_ g_row\[1\].g_col\[1\].pe__1721_/A g_row\[1\].g_col\[1\].pe__1721_/B
+ VGND VGND VPWR VPWR g_row\[1\].g_col\[1\].pe__1722_/A sky130_fd_sc_hd__xnor2_2
Xg_row\[1\].g_col\[0\].pe__1705_ g_row\[1\].g_col\[0\].pe__1808_/A g_row\[1\].g_col\[0\].pe__1705_/B
+ VGND VGND VPWR VPWR g_row\[1\].g_col\[0\].pe__1709_/A sky130_fd_sc_hd__xnor2_2
Xg_row\[1\].g_col\[1\].pe__1652_ g_row\[1\].g_col\[1\].pe__2694_/Q g_row\[1\].g_col\[1\].pe__1748_/B
+ g_row\[1\].g_col\[1\].pe__1738_/B1 g_row\[1\].g_col\[1\].pe__1782_/A2 VGND VGND
+ VPWR VPWR g_row\[1\].g_col\[1\].pe__1653_/B sky130_fd_sc_hd__a22o_2
Xg_row\[1\].g_col\[0\].pe__2685_ hold2048/X g_row\[1\].g_col\[0\].pe__2680_/B g_row\[1\].g_col\[0\].pe__2684_/X
+ g_row\[1\].g_col\[0\].pe__2687_/C1 VGND VGND VPWR VPWR g_row\[1\].g_col\[0\].pe__2685_/X
+ sky130_fd_sc_hd__o211a_2
XFILLER_39_501 VGND VGND VPWR VPWR sky130_fd_sc_hd__decap_3
Xg_row\[1\].g_col\[0\].pe__1636_ g_row\[1\].g_col\[0\].pe__1845_/B g_row\[1\].g_col\[0\].pe__1636_/B
+ VGND VGND VPWR VPWR g_row\[1\].g_col\[0\].pe__1847_/B sky130_fd_sc_hd__xor2_2
XTAP_TAPCELL_ROW_72_1291 VGND VPWR sky130_fd_sc_hd__tapvpwrvgnd_1
Xg_row\[1\].g_col\[1\].pe__1583_ g_row\[1\].g_col\[1\].pe__1583_/A g_row\[1\].g_col\[1\].pe__1583_/B
+ VGND VGND VPWR VPWR g_row\[1\].g_col\[1\].pe__1634_/A sky130_fd_sc_hd__xnor2_2
Xg_row\[1\].g_col\[0\].pe__1567_ g_row\[1\].g_col\[0\].pe__1864_/A g_row\[1\].g_col\[0\].pe__1567_/B
+ VGND VGND VPWR VPWR g_row\[1\].g_col\[0\].pe__1596_/B sky130_fd_sc_hd__xnor2_2
Xg_row\[0\].g_col\[0\].pe__2763_ clkbuf_leaf_51_clk/X g_row\[0\].g_col\[0\].pe__2763_/D
+ VGND VGND VPWR VPWR g_row\[0\].g_col\[0\].pe__2763_/Q sky130_fd_sc_hd__dfxtp_2
Xg_row\[1\].g_col\[0\].pe_hold1731 g_row\[1\].g_col\[0\].pe__2768_/Q VGND VGND VPWR
+ VPWR g_row\[1\].g_col\[0\].pe__2581_/A1 sky130_fd_sc_hd__clkbuf_2
XFILLER_54_526 VGND VGND VPWR VPWR sky130_fd_sc_hd__decap_3
Xg_row\[0\].g_col\[0\].pe__1714_ g_row\[0\].g_col\[0\].pe__1714_/A g_row\[0\].g_col\[0\].pe__1714_/B
+ g_row\[0\].g_col\[0\].pe__1714_/C VGND VGND VPWR VPWR g_row\[0\].g_col\[0\].pe__1742_/B
+ sky130_fd_sc_hd__nand3_2
Xg_row\[0\].g_col\[0\].pe__2694_ clkbuf_leaf_14_clk/X g_row\[0\].g_col\[0\].pe__2694_/D
+ VGND VGND VPWR VPWR place1214/A sky130_fd_sc_hd__dfxtp_2
Xg_row\[0\].g_col\[1\].pe__1730_ g_row\[0\].g_col\[1\].pe__2686_/A g_row\[0\].g_col\[1\].pe__1730_/B
+ VGND VGND VPWR VPWR g_row\[0\].g_col\[1\].pe__1734_/B sky130_fd_sc_hd__xor2_2
Xg_row\[1\].g_col\[0\].pe_hold1786 g_row\[1\].g_col\[0\].pe_hold2915/X VGND VGND VPWR
+ VPWR g_row\[1\].g_col\[0\].pe_hold2916/A sky130_fd_sc_hd__clkbuf_2
Xg_row\[1\].g_col\[0\].pe_hold1775 g_row\[1\].g_col\[0\].pe_hold3002/X VGND VGND VPWR
+ VPWR g_row\[1\].g_col\[0\].pe__2713_/D sky130_fd_sc_hd__clkbuf_2
Xg_row\[1\].g_col\[0\].pe_hold1764 g_row\[1\].g_col\[0\].pe__1387_/X VGND VGND VPWR
+ VPWR g_row\[1\].g_col\[0\].pe__1388_/B1 sky130_fd_sc_hd__clkbuf_2
Xg_row\[1\].g_col\[0\].pe__1498_ g_row\[1\].g_col\[0\].pe__1676_/A g_row\[1\].g_col\[0\].pe__1498_/B
+ VGND VGND VPWR VPWR g_row\[1\].g_col\[0\].pe__1499_/B sky130_fd_sc_hd__xnor2_2
Xg_row\[0\].g_col\[0\].pe__1645_ g_row\[0\].g_col\[0\].pe__1648_/A g_row\[0\].g_col\[0\].pe__1648_/B
+ VGND VGND VPWR VPWR g_row\[0\].g_col\[0\].pe__1688_/A sky130_fd_sc_hd__xor2_2
Xg_row\[0\].g_col\[1\].pe__1661_ g_row\[0\].g_col\[1\].pe__1693_/A g_row\[0\].g_col\[1\].pe__1693_/B
+ g_row\[0\].g_col\[1\].pe__1660_/Y VGND VGND VPWR VPWR g_row\[0\].g_col\[1\].pe__1663_/A
+ sky130_fd_sc_hd__a21o_2
Xg_row\[1\].g_col\[1\].pe__2204_ g_row\[1\].g_col\[1\].pe__2731_/Q VGND VGND VPWR
+ VPWR g_row\[1\].g_col\[1\].pe__2204_/Y sky130_fd_sc_hd__inv_2
XFILLER_50_710 VGND VGND VPWR VPWR sky130_fd_sc_hd__fill_1
XTAP_TAPCELL_ROW_37_768 VGND VPWR sky130_fd_sc_hd__tapvpwrvgnd_1
XTAP_TAPCELL_ROW_17_470 VGND VPWR sky130_fd_sc_hd__tapvpwrvgnd_1
Xg_row\[0\].g_col\[0\].pe__1576_ g_row\[0\].g_col\[0\].pe__1626_/A g_row\[0\].g_col\[0\].pe__1626_/B
+ VGND VGND VPWR VPWR g_row\[0\].g_col\[0\].pe__1579_/A sky130_fd_sc_hd__xor2_2
Xg_row\[0\].g_col\[1\].pe__1592_ g_row\[0\].g_col\[1\].pe__1830_/A g_row\[0\].g_col\[1\].pe__1830_/B
+ g_row\[0\].g_col\[1\].pe__1830_/C VGND VGND VPWR VPWR g_row\[0\].g_col\[1\].pe__1840_/A
+ sky130_fd_sc_hd__o21ai_2
Xg_row\[1\].g_col\[1\].pe__2135_ g_row\[1\].g_col\[1\].pe__2135_/A g_row\[1\].g_col\[1\].pe__2135_/B
+ VGND VGND VPWR VPWR g_row\[1\].g_col\[1\].pe__2144_/A sky130_fd_sc_hd__nand2_2
Xg_row\[1\].g_col\[0\].pe__2119_ g_row\[1\].g_col\[0\].pe__2077_/A g_row\[1\].g_col\[0\].pe__2119_/B
+ VGND VGND VPWR VPWR g_row\[1\].g_col\[0\].pe__2119_/X sky130_fd_sc_hd__and2b_2
Xg_row\[1\].g_col\[1\].pe__2066_ g_row\[1\].g_col\[1\].pe__2153_/A g_row\[1\].g_col\[1\].pe__2153_/B
+ VGND VGND VPWR VPWR g_row\[1\].g_col\[1\].pe__2066_/Y sky130_fd_sc_hd__nand2_2
XTAP_TAPCELL_ROW_79_1401 VGND VPWR sky130_fd_sc_hd__tapvpwrvgnd_1
Xg_row\[0\].g_col\[1\].pe__2213_ g_row\[0\].g_col\[1\].pe__2213_/A g_row\[0\].g_col\[1\].pe__2213_/B
+ VGND VGND VPWR VPWR g_row\[0\].g_col\[1\].pe__2220_/A sky130_fd_sc_hd__nand2_2
Xg_row\[0\].g_col\[1\].pe__2144_ g_row\[0\].g_col\[1\].pe__2144_/A g_row\[0\].g_col\[1\].pe__2144_/B
+ VGND VGND VPWR VPWR g_row\[0\].g_col\[1\].pe__2192_/A sky130_fd_sc_hd__xnor2_2
XFILLER_2_806 VGND VGND VPWR VPWR sky130_fd_sc_hd__decap_3
Xg_row\[0\].g_col\[0\].pe__2128_ g_row\[0\].g_col\[0\].pe__2128_/A g_row\[0\].g_col\[0\].pe__2128_/B
+ g_row\[0\].g_col\[0\].pe__2128_/C VGND VGND VPWR VPWR g_row\[0\].g_col\[0\].pe__2129_/B
+ sky130_fd_sc_hd__and3_2
Xg_row\[0\].g_col\[0\].pe__2059_ g_row\[0\].g_col\[0\].pe__2059_/A g_row\[0\].g_col\[0\].pe__2067_/A
+ VGND VGND VPWR VPWR g_row\[0\].g_col\[0\].pe__2153_/B sky130_fd_sc_hd__xnor2_2
Xg_row\[1\].g_col\[1\].pe__1919_ g_row\[1\].g_col\[1\].pe__2094_/B g_row\[1\].g_col\[1\].pe__1919_/B
+ VGND VGND VPWR VPWR g_row\[1\].g_col\[1\].pe__2043_/A sky130_fd_sc_hd__nand2_2
Xg_row\[0\].g_col\[1\].pe__2075_ g_row\[0\].g_col\[1\].pe__2179_/A g_row\[0\].g_col\[1\].pe__2075_/B
+ VGND VGND VPWR VPWR g_row\[0\].g_col\[1\].pe__2136_/B sky130_fd_sc_hd__xnor2_2
Xhold2042 hold2042/A VGND VGND VPWR VPWR hold2042/X sky130_fd_sc_hd__clkbuf_2
XFILLER_18_707 VGND VGND VPWR VPWR sky130_fd_sc_hd__decap_3
Xhold2097 hold3114/X VGND VGND VPWR VPWR hold2097/X sky130_fd_sc_hd__clkbuf_2
XFILLER_18_729 VGND VGND VPWR VPWR sky130_fd_sc_hd__decap_3
XFILLER_45_537 VGND VGND VPWR VPWR sky130_fd_sc_hd__fill_2
XFILLER_57_386 VGND VGND VPWR VPWR sky130_fd_sc_hd__fill_1
XFILLER_85_673 VGND VGND VPWR VPWR sky130_fd_sc_hd__fill_2
Xg_row\[0\].g_col\[1\].pe__1928_ g_row\[0\].g_col\[1\].pe__2045_/B g_row\[0\].g_col\[1\].pe__1928_/B
+ VGND VGND VPWR VPWR g_row\[0\].g_col\[1\].pe__1928_/X sky130_fd_sc_hd__and2_2
Xg_row\[0\].g_col\[1\].pe__1859_ g_row\[0\].g_col\[1\].pe__1859_/A g_row\[0\].g_col\[1\].pe__1859_/B
+ VGND VGND VPWR VPWR g_row\[0\].g_col\[1\].pe__1860_/B sky130_fd_sc_hd__xor2_2
XTAP_TAPCELL_ROW_15_429 VGND VPWR sky130_fd_sc_hd__tapvpwrvgnd_1
XFILLER_40_253 VGND VGND VPWR VPWR sky130_fd_sc_hd__fill_1
XFILLER_43_75 VGND VGND VPWR VPWR sky130_fd_sc_hd__decap_3
XFILLER_9_449 VGND VGND VPWR VPWR sky130_fd_sc_hd__fill_1
XFILLER_5_644 VGND VGND VPWR VPWR sky130_fd_sc_hd__decap_3
Xinput1295 hold3441/X VGND VGND VPWR VPWR hold3442/A sky130_fd_sc_hd__buf_2
XFILLER_4_25 VGND VGND VPWR VPWR sky130_fd_sc_hd__decap_3
XFILLER_68_618 VGND VGND VPWR VPWR sky130_fd_sc_hd__decap_3
Xg_row\[1\].g_col\[0\].pe__2470_ g_row\[1\].g_col\[0\].pe__2551_/A g_row\[1\].g_col\[0\].pe__2551_/B
+ g_row\[1\].g_col\[0\].pe__2551_/C g_row\[1\].g_col\[0\].pe__2444_/A g_row\[1\].g_col\[0\].pe__2496_/B
+ VGND VGND VPWR VPWR g_row\[1\].g_col\[0\].pe__2471_/C sky130_fd_sc_hd__a311o_2
XFILLER_67_117 VGND VGND VPWR VPWR sky130_fd_sc_hd__fill_1
Xg_row\[1\].g_col\[0\].pe__1421_ g_row\[1\].g_col\[0\].pe__1870_/A g_row\[1\].g_col\[0\].pe__2727_/Q
+ VGND VGND VPWR VPWR g_row\[1\].g_col\[0\].pe__1982_/B sky130_fd_sc_hd__xor2_2
XFILLER_48_331 VGND VGND VPWR VPWR sky130_fd_sc_hd__fill_2
Xg_row\[1\].g_col\[0\].pe__1352_ g_row\[1\].g_col\[0\].pe__2761_/Q g_row\[1\].g_col\[0\].pe__2760_/Q
+ g_row\[1\].g_col\[0\].pe__1348_/B g_row\[1\].g_col\[0\].pe__2771_/Q VGND VGND VPWR
+ VPWR g_row\[1\].g_col\[0\].pe__1353_/B sky130_fd_sc_hd__o31a_2
XFILLER_76_684 VGND VGND VPWR VPWR sky130_fd_sc_hd__decap_3
XFILLER_91_643 VGND VGND VPWR VPWR sky130_fd_sc_hd__fill_1
XFILLER_17_762 VGND VGND VPWR VPWR sky130_fd_sc_hd__fill_1
XTAP_TAPCELL_ROW_34_716 VGND VPWR sky130_fd_sc_hd__tapvpwrvgnd_1
XFILLER_44_581 VGND VGND VPWR VPWR sky130_fd_sc_hd__fill_1
XFILLER_44_592 VGND VGND VPWR VPWR sky130_fd_sc_hd__decap_3
XFILLER_90_197 VGND VGND VPWR VPWR sky130_fd_sc_hd__fill_1
XTAP_TAPCELL_ROW_34_727 VGND VPWR sky130_fd_sc_hd__tapvpwrvgnd_1
XFILLER_31_220 VGND VGND VPWR VPWR sky130_fd_sc_hd__decap_3
Xg_row\[0\].g_col\[0\].pe__1361_ g_row\[0\].g_col\[0\].pe__2766_/Q g_row\[0\].g_col\[0\].pe__1361_/B
+ VGND VGND VPWR VPWR output1356/A sky130_fd_sc_hd__xor2_2
XFILLER_83_3 VGND VGND VPWR VPWR sky130_fd_sc_hd__decap_3
XTAP_TAPCELL_ROW_74_1320 VGND VPWR sky130_fd_sc_hd__tapvpwrvgnd_1
Xg_row\[1\].g_col\[1\].pe__2753_ clkbuf_leaf_77_clk/X g_row\[1\].g_col\[1\].pe__2753_/D
+ VGND VGND VPWR VPWR g_row\[1\].g_col\[1\].pe__2753_/Q sky130_fd_sc_hd__dfxtp_2
Xg_row\[1\].g_col\[1\].pe__1704_ g_row\[1\].g_col\[1\].pe__1727_/A1 g_row\[1\].g_col\[1\].pe__1704_/A2
+ g_row\[1\].g_col\[1\].pe__2614_/B g_row\[1\].g_col\[1\].pe__1727_/B2 VGND VGND VPWR
+ VPWR g_row\[1\].g_col\[1\].pe__1705_/B sky130_fd_sc_hd__a22o_2
Xg_row\[1\].g_col\[0\].pe__2737_ clkbuf_leaf_46_clk/X g_row\[1\].g_col\[0\].pe__2737_/D
+ VGND VGND VPWR VPWR g_row\[1\].g_col\[0\].pe__2737_/Q sky130_fd_sc_hd__dfxtp_2
XFILLER_59_629 VGND VGND VPWR VPWR sky130_fd_sc_hd__fill_2
Xg_row\[1\].g_col\[1\].pe__2684_ g_row\[1\].g_col\[1\].pe__2684_/A g_row\[1\].g_col\[1\].pe__2686_/B
+ VGND VGND VPWR VPWR g_row\[1\].g_col\[1\].pe__2684_/X sky130_fd_sc_hd__or2_2
Xg_row\[1\].g_col\[0\].pe__2668_ g_row\[1\].g_col\[0\].pe__2670_/A1 g_row\[1\].g_col\[0\].pe__2668_/A2
+ g_row\[1\].g_col\[0\].pe__2670_/B1 g_row\[1\].g_col\[0\].pe__2668_/C1 VGND VGND
+ VPWR VPWR g_row\[1\].g_col\[0\].pe__2668_/X sky130_fd_sc_hd__o211a_2
Xg_row\[1\].g_col\[1\].pe__1635_ g_row\[1\].g_col\[1\].pe__1587_/A g_row\[1\].g_col\[1\].pe__1587_/B
+ g_row\[1\].g_col\[1\].pe__1634_/X VGND VGND VPWR VPWR g_row\[1\].g_col\[1\].pe__1636_/B
+ sky130_fd_sc_hd__o21a_2
Xg_row\[1\].g_col\[0\].pe_hold2240 g_row\[1\].g_col\[0\].pe__2749_/Q VGND VGND VPWR
+ VPWR g_row\[1\].g_col\[0\].pe__2269_/A sky130_fd_sc_hd__clkbuf_2
Xg_row\[1\].g_col\[0\].pe__1619_ g_row\[1\].g_col\[0\].pe__1875_/A g_row\[1\].g_col\[0\].pe__1875_/B
+ VGND VGND VPWR VPWR g_row\[1\].g_col\[0\].pe__1622_/A sky130_fd_sc_hd__nand2_2
XFILLER_67_662 VGND VGND VPWR VPWR sky130_fd_sc_hd__decap_3
Xg_row\[1\].g_col\[1\].pe_place821 g_row\[1\].g_col\[1\].pe__2510_/X VGND VGND VPWR
+ VPWR g_row\[1\].g_col\[1\].pe__2590_/A sky130_fd_sc_hd__buf_6
Xg_row\[1\].g_col\[1\].pe_place832 g_row\[1\].g_col\[1\].pe__1504_/Y VGND VGND VPWR
+ VPWR g_row\[1\].g_col\[1\].pe__1549_/B sky130_fd_sc_hd__buf_6
Xg_row\[1\].g_col\[1\].pe__1566_ g_row\[1\].g_col\[1\].pe__2138_/B2 g_row\[1\].g_col\[1\].pe__1715_/B
+ g_row\[1\].g_col\[1\].pe__1863_/B1 g_row\[1\].g_col\[1\].pe__2073_/B2 VGND VGND
+ VPWR VPWR g_row\[1\].g_col\[1\].pe__1567_/B sky130_fd_sc_hd__a22o_2
Xg_row\[1\].g_col\[0\].pe__2599_ g_row\[1\].g_col\[0\].pe__2639_/A g_row\[1\].g_col\[0\].pe__2599_/B
+ VGND VGND VPWR VPWR g_row\[1\].g_col\[0\].pe__2599_/X sky130_fd_sc_hd__or2_2
XFILLER_39_364 VGND VGND VPWR VPWR sky130_fd_sc_hd__fill_1
XFILLER_66_150 VGND VGND VPWR VPWR sky130_fd_sc_hd__decap_3
XFILLER_67_673 VGND VGND VPWR VPWR sky130_fd_sc_hd__decap_3
Xg_row\[1\].g_col\[1\].pe_place876 g_row\[1\].g_col\[1\].pe__2177_/B1 VGND VGND VPWR
+ VPWR g_row\[1\].g_col\[1\].pe__2388_/B sky130_fd_sc_hd__buf_6
Xg_row\[0\].g_col\[1\].pe__2762_ clkbuf_leaf_13_clk/X g_row\[0\].g_col\[1\].pe__2762_/D
+ VGND VGND VPWR VPWR g_row\[0\].g_col\[1\].pe__2762_/Q sky130_fd_sc_hd__dfxtp_2
XFILLER_81_131 VGND VGND VPWR VPWR sky130_fd_sc_hd__fill_1
Xg_row\[0\].g_col\[0\].pe__2746_ _309_/CLK g_row\[0\].g_col\[0\].pe__2746_/D VGND
+ VGND VPWR VPWR ANTENNA_180/DIODE sky130_fd_sc_hd__dfxtp_2
Xg_row\[0\].g_col\[1\].pe__1713_ g_row\[0\].g_col\[1\].pe__1713_/A g_row\[0\].g_col\[1\].pe__1713_/B
+ VGND VGND VPWR VPWR g_row\[0\].g_col\[1\].pe__1714_/C sky130_fd_sc_hd__xnor2_2
Xg_row\[1\].g_col\[1\].pe_place887 g_row\[1\].g_col\[1\].pe__1611_/A VGND VGND VPWR
+ VPWR g_row\[1\].g_col\[1\].pe__2085_/A sky130_fd_sc_hd__buf_6
Xg_row\[1\].g_col\[1\].pe_place898 g_row\[1\].g_col\[1\].pe__2633_/A1 VGND VGND VPWR
+ VPWR g_row\[1\].g_col\[1\].pe__2656_/A1 sky130_fd_sc_hd__buf_6
Xg_row\[1\].g_col\[1\].pe__1497_ g_row\[1\].g_col\[1\].pe__1901_/B2 g_row\[1\].g_col\[1\].pe__1657_/B
+ g_row\[1\].g_col\[1\].pe__1613_/B1 g_row\[1\].g_col\[1\].pe__1853_/B2 VGND VGND
+ VPWR VPWR g_row\[1\].g_col\[1\].pe__1498_/B sky130_fd_sc_hd__a22o_2
Xg_row\[0\].g_col\[0\].pe__2677_ hold2015/X g_row\[0\].g_col\[0\].pe__2676_/A g_row\[0\].g_col\[0\].pe__2677_/B1
+ g_row\[0\].g_col\[0\].pe__2676_/Y VGND VGND VPWR VPWR g_row\[0\].g_col\[0\].pe__2677_/X
+ sky130_fd_sc_hd__o211a_2
Xg_row\[0\].g_col\[1\].pe__2693_ clkbuf_leaf_10_clk/X g_row\[0\].g_col\[1\].pe__2693_/D
+ VGND VGND VPWR VPWR g_row\[0\].g_col\[1\].pe__2693_/Q sky130_fd_sc_hd__dfxtp_2
XFILLER_23_732 VGND VGND VPWR VPWR sky130_fd_sc_hd__fill_2
XTAP_TAPCELL_ROW_85_1482 VGND VPWR sky130_fd_sc_hd__tapvpwrvgnd_1
Xg_row\[0\].g_col\[0\].pe__1628_ g_row\[0\].g_col\[0\].pe__1879_/A g_row\[0\].g_col\[0\].pe__1879_/B
+ VGND VGND VPWR VPWR g_row\[0\].g_col\[0\].pe__1629_/B sky130_fd_sc_hd__xor2_2
Xg_row\[0\].g_col\[1\].pe__1644_ g_row\[0\].g_col\[1\].pe__1707_/A g_row\[0\].g_col\[1\].pe__1644_/B
+ VGND VGND VPWR VPWR g_row\[0\].g_col\[1\].pe__1648_/B sky130_fd_sc_hd__xor2_2
Xg_row\[0\].g_col\[0\].pe__1559_ place1223/X g_row\[0\].g_col\[0\].pe__1558_/B g_row\[0\].g_col\[0\].pe__1558_/C
+ VGND VGND VPWR VPWR g_row\[0\].g_col\[0\].pe__1560_/B sky130_fd_sc_hd__a21o_2
Xg_row\[0\].g_col\[1\].pe__1575_ g_row\[0\].g_col\[1\].pe__2045_/A g_row\[0\].g_col\[1\].pe__1575_/B
+ VGND VGND VPWR VPWR g_row\[0\].g_col\[1\].pe__1626_/B sky130_fd_sc_hd__xor2_2
Xg_row\[1\].g_col\[1\].pe__2118_ g_row\[1\].g_col\[1\].pe__2107_/A g_row\[1\].g_col\[1\].pe__2105_/X
+ g_row\[1\].g_col\[1\].pe__2106_/A VGND VGND VPWR VPWR g_row\[1\].g_col\[1\].pe__2148_/A
+ sky130_fd_sc_hd__a21oi_2
XFILLER_50_573 VGND VGND VPWR VPWR sky130_fd_sc_hd__fill_2
Xg_row\[1\].g_col\[1\].pe__2049_ g_row\[1\].g_col\[1\].pe__2048_/A g_row\[1\].g_col\[1\].pe__2048_/B
+ g_row\[1\].g_col\[1\].pe__2048_/C VGND VGND VPWR VPWR g_row\[1\].g_col\[1\].pe__2049_/X
+ sky130_fd_sc_hd__a21o_2
Xg_row\[0\].g_col\[1\].pe__2127_ g_row\[0\].g_col\[1\].pe__2128_/B g_row\[0\].g_col\[1\].pe__2128_/C
+ g_row\[0\].g_col\[1\].pe__2128_/A VGND VGND VPWR VPWR g_row\[0\].g_col\[1\].pe__2129_/A
+ sky130_fd_sc_hd__a21oi_2
XPHY_EDGE_ROW_8_Left_102 VGND VGND VPWR VPWR sky130_fd_sc_hd__decap_3
Xg_row\[0\].g_col\[1\].pe__2058_ g_row\[0\].g_col\[1\].pe__2058_/A g_row\[0\].g_col\[1\].pe__2058_/B
+ VGND VGND VPWR VPWR g_row\[0\].g_col\[1\].pe__2067_/A sky130_fd_sc_hd__xnor2_2
XFILLER_49_128 VGND VGND VPWR VPWR sky130_fd_sc_hd__fill_1
XFILLER_89_275 VGND VGND VPWR VPWR sky130_fd_sc_hd__fill_1
XFILLER_45_301 VGND VGND VPWR VPWR sky130_fd_sc_hd__decap_3
XFILLER_46_813 VGND VGND VPWR VPWR sky130_fd_sc_hd__fill_1
XFILLER_72_164 VGND VGND VPWR VPWR sky130_fd_sc_hd__fill_1
XFILLER_73_676 VGND VGND VPWR VPWR sky130_fd_sc_hd__decap_3
XFILLER_45_389 VGND VGND VPWR VPWR sky130_fd_sc_hd__decap_3
XFILLER_54_74 VGND VGND VPWR VPWR sky130_fd_sc_hd__fill_2
XTAP_TAPCELL_ROW_0_190 VGND VPWR sky130_fd_sc_hd__tapvpwrvgnd_1
Xg_row\[0\].g_col\[0\].pe_hold2305 g_row\[0\].g_col\[0\].pe__2626_/X VGND VGND VPWR
+ VPWR g_row\[0\].g_col\[0\].pe__2701_/D sky130_fd_sc_hd__clkbuf_2
Xg_row\[0\].g_col\[0\].pe_hold2316 g_row\[0\].g_col\[0\].pe__2628_/X VGND VGND VPWR
+ VPWR g_row\[0\].g_col\[0\].pe__2702_/D sky130_fd_sc_hd__clkbuf_2
Xg_row\[0\].g_col\[0\].pe_hold3039 g_row\[0\].g_col\[0\].pe__1398_/A VGND VGND VPWR
+ VPWR g_row\[0\].g_col\[0\].pe__2666_/A2 sky130_fd_sc_hd__clkbuf_2
XFILLER_54_85 VGND VGND VPWR VPWR sky130_fd_sc_hd__fill_2
XFILLER_14_776 VGND VGND VPWR VPWR sky130_fd_sc_hd__decap_3
Xg_row\[1\].g_col\[0\].pe__1970_ place1086/X g_row\[1\].g_col\[0\].pe__2163_/B VGND
+ VGND VPWR VPWR g_row\[1\].g_col\[0\].pe__1972_/B sky130_fd_sc_hd__nand2_2
Xclkload16 clkload16/A VGND VGND VPWR VPWR clkload16/X sky130_fd_sc_hd__buf_2
Xoutput1407 output1407/A VGND VGND VPWR VPWR results_flat[57] sky130_fd_sc_hd__buf_2
XTAP_TAPCELL_ROW_56_1050 VGND VPWR sky130_fd_sc_hd__tapvpwrvgnd_1
Xg_row\[1\].g_col\[1\].pe_hold3071 g_row\[1\].g_col\[1\].pe__2735_/Q VGND VGND VPWR
+ VPWR g_row\[1\].g_col\[1\].pe_hold3071/X sky130_fd_sc_hd__clkbuf_2
Xg_row\[1\].g_col\[1\].pe_hold3093 g_row\[1\].g_col\[1\].pe__2743_/Q VGND VGND VPWR
+ VPWR g_row\[1\].g_col\[1\].pe_hold3093/X sky130_fd_sc_hd__clkbuf_2
Xoutput1418 output1418/A VGND VGND VPWR VPWR results_flat[9] sky130_fd_sc_hd__buf_2
Xg_row\[1\].g_col\[0\].pe__2522_ g_row\[1\].g_col\[0\].pe__2561_/A g_row\[1\].g_col\[0\].pe__2522_/B
+ VGND VGND VPWR VPWR g_row\[1\].g_col\[0\].pe__2757_/D sky130_fd_sc_hd__and2_2
Xg_row\[1\].g_col\[1\].pe_hold1691 g_row\[1\].g_col\[1\].pe__2766_/Q VGND VGND VPWR
+ VPWR g_row\[1\].g_col\[1\].pe__2572_/A1 sky130_fd_sc_hd__clkbuf_2
Xg_row\[1\].g_col\[1\].pe_hold1680 g_row\[1\].g_col\[1\].pe_hold3125/X VGND VGND VPWR
+ VPWR g_row\[1\].g_col\[1\].pe__2639_/B sky130_fd_sc_hd__clkbuf_2
Xg_row\[1\].g_col\[0\].pe__2453_ g_row\[1\].g_col\[0\].pe__2742_/Q g_row\[1\].g_col\[0\].pe__2453_/B
+ VGND VGND VPWR VPWR g_row\[1\].g_col\[0\].pe__2464_/B sky130_fd_sc_hd__xnor2_2
XFILLER_1_691 VGND VGND VPWR VPWR sky130_fd_sc_hd__fill_1
Xg_row\[1\].g_col\[1\].pe__1420_ g_row\[1\].g_col\[1\].pe__1428_/A g_row\[1\].g_col\[1\].pe__1428_/B
+ VGND VGND VPWR VPWR g_row\[1\].g_col\[1\].pe__1650_/A sky130_fd_sc_hd__xor2_2
Xg_row\[1\].g_col\[0\].pe__1404_ place1263/X VGND VGND VPWR VPWR g_row\[1\].g_col\[0\].pe__1838_/A
+ sky130_fd_sc_hd__inv_2
XFILLER_49_673 VGND VGND VPWR VPWR sky130_fd_sc_hd__fill_2
Xg_row\[0\].g_col\[0\].pe__2600_ g_row\[0\].g_col\[0\].pe__2640_/A1 g_row\[0\].g_col\[0\].pe__2600_/A2
+ g_row\[0\].g_col\[0\].pe__2685_/C1 g_row\[0\].g_col\[0\].pe__2599_/X VGND VGND VPWR
+ VPWR g_row\[0\].g_col\[0\].pe__2600_/X sky130_fd_sc_hd__o211a_2
Xg_row\[1\].g_col\[1\].pe_place1004 g_row\[1\].g_col\[1\].pe__2734_/Q VGND VGND VPWR
+ VPWR g_row\[1\].g_col\[1\].pe__1540_/C sky130_fd_sc_hd__buf_6
Xg_row\[1\].g_col\[0\].pe__2384_ g_row\[1\].g_col\[0\].pe__2375_/A g_row\[1\].g_col\[0\].pe__2356_/A
+ g_row\[1\].g_col\[0\].pe__2375_/B VGND VGND VPWR VPWR g_row\[1\].g_col\[0\].pe__2384_/Y
+ sky130_fd_sc_hd__o21ai_2
XFILLER_36_312 VGND VGND VPWR VPWR sky130_fd_sc_hd__decap_3
Xg_row\[1\].g_col\[1\].pe_place1015 g_row\[1\].g_col\[1\].pe__2726_/Q VGND VGND VPWR
+ VPWR g_row\[1\].g_col\[1\].pe__2686_/A sky130_fd_sc_hd__buf_6
Xg_row\[1\].g_col\[1\].pe_place1026 g_row\[1\].g_col\[1\].pe__2701_/Q VGND VGND VPWR
+ VPWR g_row\[1\].g_col\[1\].pe__2625_/B sky130_fd_sc_hd__buf_6
Xg_row\[1\].g_col\[1\].pe_place1037 g_row\[1\].g_col\[1\].pe__2612_/B VGND VGND VPWR
+ VPWR g_row\[1\].g_col\[1\].pe__2073_/B2 sky130_fd_sc_hd__buf_6
Xg_row\[1\].g_col\[1\].pe__1351_ g_row\[1\].g_col\[1\].pe__2761_/Q g_row\[1\].g_col\[1\].pe__1351_/B
+ VGND VGND VPWR VPWR output1403/A sky130_fd_sc_hd__xnor2_2
XFILLER_51_304 VGND VGND VPWR VPWR sky130_fd_sc_hd__decap_3
XFILLER_91_462 VGND VGND VPWR VPWR sky130_fd_sc_hd__fill_2
Xg_row\[0\].g_col\[0\].pe__2531_ g_row\[0\].g_col\[0\].pe__2526_/A g_row\[0\].g_col\[0\].pe__2526_/B
+ g_row\[0\].g_col\[0\].pe__2458_/A VGND VGND VPWR VPWR g_row\[0\].g_col\[0\].pe__2533_/A
+ sky130_fd_sc_hd__a21oi_2
Xg_row\[1\].g_col\[1\].pe_place1048 g_row\[1\].g_col\[1\].pe__2690_/Q VGND VGND VPWR
+ VPWR g_row\[1\].g_col\[1\].pe__2599_/B sky130_fd_sc_hd__buf_6
XFILLER_51_337 VGND VGND VPWR VPWR sky130_fd_sc_hd__decap_3
Xg_row\[0\].g_col\[0\].pe__2462_ g_row\[0\].g_col\[0\].pe__2757_/Q g_row\[0\].g_col\[0\].pe__2462_/B
+ VGND VGND VPWR VPWR g_row\[0\].g_col\[0\].pe__2462_/Y sky130_fd_sc_hd__nand2_2
XFILLER_51_359 VGND VGND VPWR VPWR sky130_fd_sc_hd__fill_1
Xg_row\[0\].g_col\[0\].pe__1413_ g_row\[0\].g_col\[0\].pe__1705_/A g_row\[0\].g_col\[0\].pe__1413_/B
+ VGND VGND VPWR VPWR g_row\[0\].g_col\[0\].pe__1428_/A sky130_fd_sc_hd__xnor2_2
Xg_row\[0\].g_col\[0\].pe__2393_ g_row\[0\].g_col\[0\].pe__2378_/X g_row\[0\].g_col\[0\].pe__2384_/Y
+ g_row\[0\].g_col\[0\].pe__2392_/Y VGND VGND VPWR VPWR g_row\[0\].g_col\[0\].pe__2393_/Y
+ sky130_fd_sc_hd__a21oi_2
Xg_row\[0\].g_col\[0\].pe_hold3595 hold3118/A VGND VGND VPWR VPWR g_row\[0\].g_col\[0\].pe__2607_/B
+ sky130_fd_sc_hd__clkbuf_2
Xg_row\[0\].g_col\[1\].pe__1360_ g_row\[0\].g_col\[1\].pe__2765_/Q g_row\[0\].g_col\[1\].pe__1359_/B
+ ANTENNA_146/DIODE VGND VGND VPWR VPWR g_row\[0\].g_col\[1\].pe__1361_/B sky130_fd_sc_hd__o21a_2
XFILLER_20_757 VGND VGND VPWR VPWR sky130_fd_sc_hd__decap_3
Xg_row\[0\].g_col\[0\].pe__1344_ g_row\[0\].g_col\[0\].pe__2758_/Q g_row\[0\].g_col\[0\].pe__1344_/B
+ VGND VGND VPWR VPWR output1377/A sky130_fd_sc_hd__xnor2_2
XFILLER_9_780 VGND VGND VPWR VPWR sky130_fd_sc_hd__decap_3
XFILLER_8_290 VGND VGND VPWR VPWR sky130_fd_sc_hd__fill_1
XFILLER_59_404 VGND VGND VPWR VPWR sky130_fd_sc_hd__fill_1
Xg_row\[1\].g_col\[1\].pe__2736_ clkbuf_leaf_83_clk/X g_row\[1\].g_col\[1\].pe__2736_/D
+ VGND VGND VPWR VPWR g_row\[1\].g_col\[1\].pe__2736_/Q sky130_fd_sc_hd__dfxtp_2
Xg_row\[1\].g_col\[1\].pe__2667_ g_row\[1\].g_col\[1\].pe__2669_/A g_row\[1\].g_col\[1\].pe__2667_/B
+ VGND VGND VPWR VPWR g_row\[1\].g_col\[1\].pe__2667_/X sky130_fd_sc_hd__or2_2
Xg_row\[1\].g_col\[1\].pe__1618_ g_row\[1\].g_col\[1\].pe__1808_/A g_row\[1\].g_col\[1\].pe__2125_/A
+ g_row\[1\].g_col\[1\].pe__1804_/B VGND VGND VPWR VPWR g_row\[1\].g_col\[1\].pe__1875_/B
+ sky130_fd_sc_hd__or3b_2
XFILLER_74_418 VGND VGND VPWR VPWR sky130_fd_sc_hd__fill_2
XTAP_TAPCELL_ROW_87_1511 VGND VPWR sky130_fd_sc_hd__tapvpwrvgnd_1
Xg_row\[1\].g_col\[0\].pe_hold2081 g_row\[1\].g_col\[0\].pe_hold3061/X VGND VGND VPWR
+ VPWR g_row\[1\].g_col\[0\].pe__2707_/D sky130_fd_sc_hd__clkbuf_2
Xg_row\[1\].g_col\[0\].pe_hold2070 g_row\[1\].g_col\[0\].pe_hold2856/X VGND VGND VPWR
+ VPWR g_row\[1\].g_col\[0\].pe_hold2857/A sky130_fd_sc_hd__clkbuf_2
Xg_row\[0\].g_col\[1\].pe_hold2402 g_row\[0\].g_col\[1\].pe__2740_/Q VGND VGND VPWR
+ VPWR g_row\[0\].g_col\[1\].pe_hold2402/X sky130_fd_sc_hd__clkbuf_2
XTAP_TAPCELL_ROW_87_1522 VGND VPWR sky130_fd_sc_hd__tapvpwrvgnd_1
Xg_row\[1\].g_col\[1\].pe__1549_ g_row\[1\].g_col\[1\].pe__1657_/A g_row\[1\].g_col\[1\].pe__1549_/B
+ g_row\[1\].g_col\[1\].pe__1549_/C VGND VGND VPWR VPWR g_row\[1\].g_col\[1\].pe__1669_/A
+ sky130_fd_sc_hd__and3_2
XFILLER_70_602 VGND VGND VPWR VPWR sky130_fd_sc_hd__decap_3
XFILLER_82_462 VGND VGND VPWR VPWR sky130_fd_sc_hd__decap_3
Xg_row\[0\].g_col\[0\].pe__2729_ clkbuf_leaf_22_clk/X g_row\[0\].g_col\[0\].pe__2729_/D
+ VGND VGND VPWR VPWR g_row\[0\].g_col\[0\].pe__2729_/Q sky130_fd_sc_hd__dfxtp_2
Xg_row\[0\].g_col\[1\].pe__2745_ clkload9/A g_row\[0\].g_col\[1\].pe__2745_/D VGND
+ VGND VPWR VPWR g_row\[0\].g_col\[1\].pe__2745_/Q sky130_fd_sc_hd__dfxtp_2
XFILLER_42_315 VGND VGND VPWR VPWR sky130_fd_sc_hd__fill_2
XFILLER_42_326 VGND VGND VPWR VPWR sky130_fd_sc_hd__decap_3
XFILLER_91_17 VGND VGND VPWR VPWR sky130_fd_sc_hd__fill_2
Xg_row\[0\].g_col\[1\].pe__2676_ place1241/X g_row\[0\].g_col\[1\].pe__2678_/B VGND
+ VGND VPWR VPWR g_row\[0\].g_col\[1\].pe__2676_/Y sky130_fd_sc_hd__nand2_2
Xg_row\[0\].g_col\[1\].pe__1627_ g_row\[0\].g_col\[1\].pe__1579_/A g_row\[0\].g_col\[1\].pe__1579_/B
+ g_row\[0\].g_col\[1\].pe__1626_/X VGND VGND VPWR VPWR g_row\[0\].g_col\[1\].pe__1879_/B
+ sky130_fd_sc_hd__a21oi_2
XTAP_TAPCELL_ROW_25_579 VGND VPWR sky130_fd_sc_hd__tapvpwrvgnd_1
XFILLER_11_746 VGND VGND VPWR VPWR sky130_fd_sc_hd__fill_2
Xg_row\[0\].g_col\[1\].pe__1558_ g_row\[0\].g_col\[1\].pe__2599_/B g_row\[0\].g_col\[1\].pe__1558_/B
+ g_row\[0\].g_col\[1\].pe__1558_/C VGND VGND VPWR VPWR g_row\[0\].g_col\[1\].pe__1607_/A
+ sky130_fd_sc_hd__nand3_2
Xg_row\[0\].g_col\[1\].pe__1489_ g_row\[0\].g_col\[1\].pe__1624_/A g_row\[0\].g_col\[1\].pe__1489_/B
+ VGND VGND VPWR VPWR g_row\[0\].g_col\[1\].pe__1490_/B sky130_fd_sc_hd__xor2_2
XFILLER_2_477 VGND VGND VPWR VPWR sky130_fd_sc_hd__decap_3
XFILLER_78_735 VGND VGND VPWR VPWR sky130_fd_sc_hd__fill_2
XFILLER_78_757 VGND VGND VPWR VPWR sky130_fd_sc_hd__decap_3
XFILLER_1_37 VGND VGND VPWR VPWR sky130_fd_sc_hd__fill_1
XFILLER_93_738 VGND VGND VPWR VPWR sky130_fd_sc_hd__decap_3
XTAP_TAPCELL_ROW_5_282 VGND VPWR sky130_fd_sc_hd__tapvpwrvgnd_1
XFILLER_46_643 VGND VGND VPWR VPWR sky130_fd_sc_hd__fill_1
XFILLER_61_602 VGND VGND VPWR VPWR sky130_fd_sc_hd__fill_1
XANTENNA_130 hold3322/A VGND VGND VPWR VPWR sky130_fd_sc_hd__diode_2
XANTENNA_141 output1406/A VGND VGND VPWR VPWR sky130_fd_sc_hd__diode_2
XANTENNA_152 hold3423/A VGND VGND VPWR VPWR sky130_fd_sc_hd__diode_2
XANTENNA_163 hold2568/X VGND VGND VPWR VPWR sky130_fd_sc_hd__diode_2
XANTENNA_174 hold3314/X VGND VGND VPWR VPWR sky130_fd_sc_hd__diode_2
XFILLER_14_540 VGND VGND VPWR VPWR sky130_fd_sc_hd__decap_3
XTAP_TAPCELL_ROW_44_866 VGND VPWR sky130_fd_sc_hd__tapvpwrvgnd_1
Xg_row\[0\].g_col\[0\].pe_hold2102 g_row\[0\].g_col\[0\].pe__2591_/X VGND VGND VPWR
+ VPWR g_row\[0\].g_col\[0\].pe__2592_/B sky130_fd_sc_hd__clkbuf_2
XFILLER_14_562 VGND VGND VPWR VPWR sky130_fd_sc_hd__decap_3
XFILLER_60_178 VGND VGND VPWR VPWR sky130_fd_sc_hd__decap_3
XTAP_TAPCELL_ROW_44_877 VGND VPWR sky130_fd_sc_hd__tapvpwrvgnd_1
Xg_row\[0\].g_col\[0\].pe_hold2179 g_row\[0\].g_col\[0\].pe_hold3040/X VGND VGND VPWR
+ VPWR g_row\[0\].g_col\[0\].pe__2718_/D sky130_fd_sc_hd__clkbuf_2
X_289_ _289_/CLK _289_/D VGND VGND VPWR VPWR _289_/Q sky130_fd_sc_hd__dfxtp_2
Xg_row\[1\].g_col\[0\].pe__1953_ g_row\[1\].g_col\[0\].pe__1939_/A g_row\[1\].g_col\[0\].pe__1939_/B
+ g_row\[1\].g_col\[0\].pe__1952_/X VGND VGND VPWR VPWR g_row\[1\].g_col\[0\].pe__2013_/A
+ sky130_fd_sc_hd__a21boi_2
Xg_row\[1\].g_col\[0\].pe__1884_ g_row\[1\].g_col\[0\].pe__1633_/A g_row\[1\].g_col\[0\].pe__1633_/B
+ g_row\[1\].g_col\[0\].pe__1883_/X VGND VGND VPWR VPWR g_row\[1\].g_col\[0\].pe__1896_/A
+ sky130_fd_sc_hd__o21a_2
Xhold3309 hold3309/A VGND VGND VPWR VPWR hold3309/X sky130_fd_sc_hd__clkbuf_2
XPHY_EDGE_ROW_18_Right_18 VGND VGND VPWR VPWR sky130_fd_sc_hd__decap_3
Xhold2608 hold3365/X VGND VGND VPWR VPWR hold3366/A sky130_fd_sc_hd__clkbuf_2
Xhold2619 hold3398/X VGND VGND VPWR VPWR hold3399/A sky130_fd_sc_hd__clkbuf_2
Xg_row\[1\].g_col\[1\].pe__2521_ g_row\[1\].g_col\[1\].pe__2521_/A1 g_row\[1\].g_col\[1\].pe__2591_/A2
+ g_row\[1\].g_col\[1\].pe__2591_/B1 g_row\[1\].g_col\[1\].pe__2520_/X VGND VGND VPWR
+ VPWR g_row\[1\].g_col\[1\].pe__2522_/B sky130_fd_sc_hd__a22o_2
XFILLER_68_234 VGND VGND VPWR VPWR sky130_fd_sc_hd__fill_1
Xg_row\[0\].g_col\[0\].pe__1962_ g_row\[0\].g_col\[0\].pe__2024_/A g_row\[0\].g_col\[0\].pe__1962_/B
+ VGND VGND VPWR VPWR g_row\[0\].g_col\[0\].pe__1963_/B sky130_fd_sc_hd__and2_2
Xg_row\[1\].g_col\[0\].pe__2505_ g_row\[1\].g_col\[0\].pe__2505_/A g_row\[1\].g_col\[0\].pe__2504_/X
+ VGND VGND VPWR VPWR g_row\[1\].g_col\[0\].pe__2505_/X sky130_fd_sc_hd__or2b_2
XFILLER_84_738 VGND VGND VPWR VPWR sky130_fd_sc_hd__decap_3
Xg_row\[0\].g_col\[0\].pe__1893_ place1269/X g_row\[0\].g_col\[0\].pe__1893_/B VGND
+ VGND VPWR VPWR g_row\[0\].g_col\[0\].pe__1893_/Y sky130_fd_sc_hd__nor2_2
Xhold1929 hold1929/A VGND VGND VPWR VPWR hold1929/X sky130_fd_sc_hd__clkbuf_2
Xg_row\[1\].g_col\[1\].pe__2452_ g_row\[1\].g_col\[1\].pe__2760_/Q g_row\[1\].g_col\[1\].pe__2452_/B
+ VGND VGND VPWR VPWR g_row\[1\].g_col\[1\].pe__2538_/A sky130_fd_sc_hd__xnor2_2
Xg_row\[1\].g_col\[0\].pe__2436_ g_row\[1\].g_col\[0\].pe__2436_/A g_row\[1\].g_col\[0\].pe__2436_/B
+ VGND VGND VPWR VPWR g_row\[1\].g_col\[0\].pe__2438_/B sky130_fd_sc_hd__xnor2_2
Xg_row\[1\].g_col\[1\].pe__2383_ g_row\[1\].g_col\[1\].pe__2383_/A VGND VGND VPWR
+ VPWR g_row\[1\].g_col\[1\].pe__2422_/A sky130_fd_sc_hd__inv_2
Xg_row\[1\].g_col\[1\].pe__1403_ g_row\[1\].g_col\[1\].pe__1403_/A1 g_row\[1\].g_col\[1\].pe__1403_/A2
+ g_row\[1\].g_col\[1\].pe__1402_/X g_row\[1\].g_col\[1\].pe__2666_/B1 VGND VGND VPWR
+ VPWR g_row\[1\].g_col\[1\].pe__1403_/X sky130_fd_sc_hd__o211a_2
Xg_row\[1\].g_col\[0\].pe__2367_ g_row\[1\].g_col\[0\].pe__2343_/A g_row\[1\].g_col\[0\].pe__2365_/X
+ g_row\[1\].g_col\[0\].pe__2366_/X VGND VGND VPWR VPWR g_row\[1\].g_col\[0\].pe__2367_/X
+ sky130_fd_sc_hd__a21bo_2
XTAP_TAPCELL_ROW_69_1241 VGND VPWR sky130_fd_sc_hd__tapvpwrvgnd_1
XTAP_TAPCELL_ROW_69_1252 VGND VPWR sky130_fd_sc_hd__tapvpwrvgnd_1
XFILLER_52_635 VGND VGND VPWR VPWR sky130_fd_sc_hd__fill_2
XFILLER_91_281 VGND VGND VPWR VPWR sky130_fd_sc_hd__fill_1
Xg_row\[0\].g_col\[0\].pe__2514_ _237_/A g_row\[0\].g_col\[0\].pe__2514_/B VGND VGND
+ VPWR VPWR g_row\[0\].g_col\[0\].pe__2514_/Y sky130_fd_sc_hd__nor2_2
Xg_row\[1\].g_col\[0\].pe__2298_ g_row\[1\].g_col\[0\].pe__2298_/A g_row\[1\].g_col\[0\].pe__2263_/X
+ VGND VGND VPWR VPWR g_row\[1\].g_col\[0\].pe__2299_/B sky130_fd_sc_hd__or2b_2
XFILLER_36_197 VGND VGND VPWR VPWR sky130_fd_sc_hd__decap_3
XPHY_EDGE_ROW_27_Right_27 VGND VGND VPWR VPWR sky130_fd_sc_hd__decap_3
XTAP_TAPCELL_ROW_82_1441 VGND VPWR sky130_fd_sc_hd__tapvpwrvgnd_1
Xg_row\[0\].g_col\[1\].pe__2461_ g_row\[0\].g_col\[1\].pe__2757_/Q g_row\[0\].g_col\[1\].pe__2462_/B
+ VGND VGND VPWR VPWR g_row\[0\].g_col\[1\].pe__2519_/B sky130_fd_sc_hd__xnor2_2
Xg_row\[0\].g_col\[0\].pe__2445_ g_row\[0\].g_col\[0\].pe__2445_/A g_row\[0\].g_col\[0\].pe__2445_/B
+ VGND VGND VPWR VPWR g_row\[0\].g_col\[0\].pe__2446_/B sky130_fd_sc_hd__xnor2_2
Xg_row\[0\].g_col\[1\].pe__1412_ g_row\[0\].g_col\[1\].pe__1704_/A1 g_row\[0\].g_col\[1\].pe__1970_/A
+ g_row\[0\].g_col\[1\].pe__1911_/A1 g_row\[0\].g_col\[1\].pe__1704_/B2 VGND VGND
+ VPWR VPWR g_row\[0\].g_col\[1\].pe__1413_/B sky130_fd_sc_hd__a22o_2
XTAP_TAPCELL_ROW_22_538 VGND VPWR sky130_fd_sc_hd__tapvpwrvgnd_1
Xg_row\[0\].g_col\[0\].pe__2376_ g_row\[0\].g_col\[0\].pe__2377_/A g_row\[0\].g_col\[0\].pe__2359_/B
+ g_row\[0\].g_col\[0\].pe__2377_/B g_row\[0\].g_col\[0\].pe__2356_/A VGND VGND VPWR
+ VPWR g_row\[0\].g_col\[0\].pe__2376_/X sky130_fd_sc_hd__a211o_2
Xg_row\[0\].g_col\[1\].pe__2392_ g_row\[0\].g_col\[1\].pe__2392_/A g_row\[0\].g_col\[1\].pe__2392_/B
+ VGND VGND VPWR VPWR g_row\[0\].g_col\[1\].pe__2392_/Y sky130_fd_sc_hd__xnor2_2
Xg_row\[0\].g_col\[1\].pe__1343_ g_row\[0\].g_col\[1\].pe__2757_/Q g_row\[0\].g_col\[1\].pe__2775_/A
+ g_row\[0\].g_col\[1\].pe__1348_/A VGND VGND VPWR VPWR g_row\[0\].g_col\[1\].pe__1344_/B
+ sky130_fd_sc_hd__o21ai_2
XFILLER_20_587 VGND VGND VPWR VPWR sky130_fd_sc_hd__fill_1
Xg_row\[1\].g_col\[0\].pe__2689__1425 VGND VGND VPWR VPWR g_row\[1\].g_col\[0\].pe__2689__1425/HI
+ g_row\[1\].g_col\[0\].pe__2689_/CIN sky130_fd_sc_hd__conb_1
XPHY_EDGE_ROW_36_Right_36 VGND VGND VPWR VPWR sky130_fd_sc_hd__decap_3
Xg_row\[1\].g_col\[1\].pe__2719_ clkbuf_leaf_80_clk/X g_row\[1\].g_col\[1\].pe__2719_/D
+ VGND VGND VPWR VPWR g_row\[1\].g_col\[1\].pe__2719_/Q sky130_fd_sc_hd__dfxtp_2
XFILLER_87_532 VGND VGND VPWR VPWR sky130_fd_sc_hd__decap_3
Xg_row\[0\].g_col\[1\].pe_hold2210 g_row\[0\].g_col\[1\].pe__2660_/X VGND VGND VPWR
+ VPWR g_row\[0\].g_col\[1\].pe__2715_/D sky130_fd_sc_hd__clkbuf_2
XFILLER_27_153 VGND VGND VPWR VPWR sky130_fd_sc_hd__fill_2
XTAP_TAPCELL_ROW_2_241 VGND VPWR sky130_fd_sc_hd__tapvpwrvgnd_1
Xg_row\[0\].g_col\[1\].pe_hold2243 _334_/Q VGND VGND VPWR VPWR g_row\[0\].g_col\[1\].pe_hold2243/X
+ sky130_fd_sc_hd__clkbuf_2
Xg_row\[0\].g_col\[1\].pe_hold2221 g_row\[0\].g_col\[1\].pe__2685_/X VGND VGND VPWR
+ VPWR g_row\[0\].g_col\[1\].pe__2725_/D sky130_fd_sc_hd__clkbuf_2
XPHY_EDGE_ROW_45_Right_45 VGND VGND VPWR VPWR sky130_fd_sc_hd__decap_3
Xg_row\[0\].g_col\[1\].pe__2728_ _332_/CLK g_row\[0\].g_col\[1\].pe__2728_/D VGND
+ VGND VPWR VPWR g_row\[0\].g_col\[1\].pe__2728_/Q sky130_fd_sc_hd__dfxtp_2
XTAP_TAPCELL_ROW_41_825 VGND VPWR sky130_fd_sc_hd__tapvpwrvgnd_1
Xg_row\[0\].g_col\[1\].pe__2659_ g_row\[0\].g_col\[1\].pe__2661_/A hold2099/X VGND
+ VGND VPWR VPWR g_row\[0\].g_col\[1\].pe__2659_/X sky130_fd_sc_hd__or2_2
X_143_ _235_/A _143_/B_N VGND VGND VPWR VPWR _143_/Y sky130_fd_sc_hd__nor2b_4
XPHY_EDGE_ROW_54_Right_54 VGND VGND VPWR VPWR sky130_fd_sc_hd__decap_3
Xg_row\[0\].g_col\[0\].pe_place972 g_row\[0\].g_col\[0\].pe__2388_/B VGND VGND VPWR
+ VPWR g_row\[0\].g_col\[0\].pe__2278_/B1 sky130_fd_sc_hd__buf_6
Xg_row\[0\].g_col\[0\].pe_place983 g_row\[0\].g_col\[0\].pe__2123_/A VGND VGND VPWR
+ VPWR g_row\[0\].g_col\[0\].pe__2165_/A sky130_fd_sc_hd__buf_6
Xg_row\[0\].g_col\[0\].pe_place994 g_row\[0\].g_col\[0\].pe__1838_/A VGND VGND VPWR
+ VPWR g_row\[0\].g_col\[0\].pe__1950_/A sky130_fd_sc_hd__buf_6
XFILLER_2_285 VGND VGND VPWR VPWR sky130_fd_sc_hd__fill_1
XFILLER_78_554 VGND VGND VPWR VPWR sky130_fd_sc_hd__decap_3
Xg_row\[1\].g_col\[0\].pe_hold2817 g_row\[1\].g_col\[0\].pe__2645_/X VGND VGND VPWR
+ VPWR g_row\[1\].g_col\[0\].pe__2646_/C1 sky130_fd_sc_hd__clkbuf_2
XFILLER_66_727 VGND VGND VPWR VPWR sky130_fd_sc_hd__fill_1
XFILLER_93_513 VGND VGND VPWR VPWR sky130_fd_sc_hd__fill_1
XTAP_TAPCELL_ROW_49_947 VGND VPWR sky130_fd_sc_hd__tapvpwrvgnd_1
Xg_row\[1\].g_col\[0\].pe__2221_ g_row\[1\].g_col\[0\].pe__2221_/A g_row\[1\].g_col\[0\].pe__2221_/B
+ VGND VGND VPWR VPWR g_row\[1\].g_col\[0\].pe__2258_/A sky130_fd_sc_hd__xor2_2
XFILLER_18_131 VGND VGND VPWR VPWR sky130_fd_sc_hd__decap_3
XFILLER_19_654 VGND VGND VPWR VPWR sky130_fd_sc_hd__decap_3
XFILLER_80_207 VGND VGND VPWR VPWR sky130_fd_sc_hd__fill_1
XPHY_EDGE_ROW_63_Right_63 VGND VGND VPWR VPWR sky130_fd_sc_hd__decap_3
XFILLER_34_624 VGND VGND VPWR VPWR sky130_fd_sc_hd__fill_1
XFILLER_46_495 VGND VGND VPWR VPWR sky130_fd_sc_hd__fill_2
Xg_row\[1\].g_col\[0\].pe__2152_ g_row\[1\].g_col\[0\].pe__1894_/Y g_row\[1\].g_col\[0\].pe__1895_/X
+ g_row\[1\].g_col\[0\].pe__2151_/X VGND VGND VPWR VPWR g_row\[1\].g_col\[0\].pe__2155_/B
+ sky130_fd_sc_hd__a21o_2
Xg_row\[1\].g_col\[0\].pe__2083_ place1082/X g_row\[1\].g_col\[0\].pe__2163_/B VGND
+ VGND VPWR VPWR g_row\[1\].g_col\[0\].pe__2085_/B sky130_fd_sc_hd__nand2_2
XFILLER_61_487 VGND VGND VPWR VPWR sky130_fd_sc_hd__fill_1
XFILLER_33_189 VGND VGND VPWR VPWR sky130_fd_sc_hd__decap_3
XTAP_TAPCELL_ROW_64_1171 VGND VPWR sky130_fd_sc_hd__tapvpwrvgnd_1
Xg_row\[0\].g_col\[0\].pe__2230_ g_row\[0\].g_col\[0\].pe__2238_/A g_row\[0\].g_col\[0\].pe__2238_/B
+ VGND VGND VPWR VPWR g_row\[0\].g_col\[0\].pe__2298_/A sky130_fd_sc_hd__xnor2_2
Xg_row\[0\].g_col\[0\].pe__2161_ g_row\[0\].g_col\[0\].pe__2161_/A g_row\[0\].g_col\[0\].pe__2161_/B
+ VGND VGND VPWR VPWR g_row\[0\].g_col\[0\].pe__2161_/Y sky130_fd_sc_hd__nand2_2
XPHY_EDGE_ROW_72_Right_72 VGND VGND VPWR VPWR sky130_fd_sc_hd__decap_3
Xg_row\[0\].g_col\[0\].pe__2092_ g_row\[0\].g_col\[0\].pe__2091_/A g_row\[0\].g_col\[0\].pe__2091_/B
+ g_row\[0\].g_col\[0\].pe__2091_/C VGND VGND VPWR VPWR g_row\[0\].g_col\[0\].pe__2097_/C
+ sky130_fd_sc_hd__a21oi_2
Xg_row\[1\].g_col\[1\].pe__1952_ g_row\[1\].g_col\[1\].pe__1952_/A g_row\[1\].g_col\[1\].pe__1938_/A
+ VGND VGND VPWR VPWR g_row\[1\].g_col\[1\].pe__1952_/X sky130_fd_sc_hd__or2b_2
Xg_row\[1\].g_col\[0\].pe__1936_ g_row\[1\].g_col\[0\].pe__1936_/A g_row\[1\].g_col\[0\].pe__1936_/B
+ VGND VGND VPWR VPWR g_row\[1\].g_col\[0\].pe__1936_/X sky130_fd_sc_hd__or2_4
Xg_row\[1\].g_col\[1\].pe__1883_ g_row\[1\].g_col\[1\].pe__1883_/A g_row\[1\].g_col\[1\].pe__1883_/B
+ VGND VGND VPWR VPWR g_row\[1\].g_col\[1\].pe__1883_/X sky130_fd_sc_hd__or2_2
Xhold3106 hold3106/A VGND VGND VPWR VPWR hold3106/X sky130_fd_sc_hd__clkbuf_2
Xg_row\[1\].g_col\[0\].pe__1867_ g_row\[1\].g_col\[0\].pe__2209_/A g_row\[1\].g_col\[0\].pe__1867_/B
+ VGND VGND VPWR VPWR g_row\[1\].g_col\[0\].pe__1868_/B sky130_fd_sc_hd__xnor2_2
Xhold3139 hold3139/A VGND VGND VPWR VPWR hold3139/X sky130_fd_sc_hd__clkbuf_2
Xg_row\[1\].g_col\[0\].pe__1798_ place1106/X g_row\[1\].g_col\[0\].pe__1801_/B VGND
+ VGND VPWR VPWR g_row\[1\].g_col\[0\].pe__1806_/B sky130_fd_sc_hd__nand2_2
Xhold2416 hold3141/X VGND VGND VPWR VPWR hold3142/A sky130_fd_sc_hd__clkbuf_2
Xhold2427 hold3174/X VGND VGND VPWR VPWR hold3175/A sky130_fd_sc_hd__clkbuf_2
Xg_row\[0\].g_col\[0\].pe__1945_ g_row\[0\].g_col\[0\].pe__1894_/Y g_row\[0\].g_col\[0\].pe__1895_/X
+ g_row\[0\].g_col\[0\].pe__2151_/A VGND VGND VPWR VPWR g_row\[0\].g_col\[0\].pe__2008_/A
+ sky130_fd_sc_hd__a21o_2
Xhold2438 hold3179/X VGND VGND VPWR VPWR hold3180/A sky130_fd_sc_hd__clkbuf_2
Xhold2449 hold2449/A VGND VGND VPWR VPWR _286_/D sky130_fd_sc_hd__clkbuf_2
Xg_row\[1\].g_col\[1\].pe__2504_ g_row\[1\].g_col\[1\].pe__2495_/A g_row\[1\].g_col\[1\].pe__2471_/C
+ g_row\[1\].g_col\[1\].pe__2471_/A VGND VGND VPWR VPWR g_row\[1\].g_col\[1\].pe__2504_/X
+ sky130_fd_sc_hd__a21o_2
Xg_row\[0\].g_col\[1\].pe__1961_ g_row\[0\].g_col\[1\].pe__1961_/A g_row\[0\].g_col\[1\].pe__1961_/B
+ VGND VGND VPWR VPWR g_row\[0\].g_col\[1\].pe__1962_/B sky130_fd_sc_hd__or2_2
XFILLER_69_598 VGND VGND VPWR VPWR sky130_fd_sc_hd__decap_3
XPHY_EDGE_ROW_81_Right_81 VGND VGND VPWR VPWR sky130_fd_sc_hd__decap_3
Xg_row\[1\].g_col\[1\].pe__2435_ g_row\[1\].g_col\[1\].pe__2472_/B g_row\[1\].g_col\[1\].pe__2765_/Q
+ VGND VGND VPWR VPWR g_row\[1\].g_col\[1\].pe__2489_/B sky130_fd_sc_hd__or2b_2
Xg_row\[0\].g_col\[1\].pe__1892_ g_row\[0\].g_col\[1\].pe__1950_/A g_row\[0\].g_col\[1\].pe_hold2402/X
+ g_row\[0\].g_col\[1\].pe__2404_/B2 g_row\[0\].g_col\[1\].pe__1891_/Y VGND VGND VPWR
+ VPWR g_row\[0\].g_col\[1\].pe__1892_/X sky130_fd_sc_hd__o2bb2a_2
XTAP_TAPCELL_ROW_27_608 VGND VPWR sky130_fd_sc_hd__tapvpwrvgnd_1
Xg_row\[0\].g_col\[0\].pe__1876_ g_row\[0\].g_col\[0\].pe__1625_/A g_row\[0\].g_col\[0\].pe__1625_/B
+ g_row\[0\].g_col\[0\].pe__1875_/X VGND VGND VPWR VPWR g_row\[0\].g_col\[0\].pe__1877_/B
+ sky130_fd_sc_hd__a21oi_2
Xg_row\[1\].g_col\[0\].pe__2419_ g_row\[1\].g_col\[0\].pe__2421_/A1 g_row\[1\].g_col\[0\].pe__2750_/Q
+ g_row\[1\].g_col\[0\].pe__2430_/B VGND VGND VPWR VPWR g_row\[1\].g_col\[0\].pe__2429_/B
+ sky130_fd_sc_hd__a21oi_2
XFILLER_24_101 VGND VGND VPWR VPWR sky130_fd_sc_hd__fill_2
XTAP_TAPCELL_ROW_27_619 VGND VPWR sky130_fd_sc_hd__tapvpwrvgnd_1
Xg_row\[1\].g_col\[1\].pe__2366_ g_row\[1\].g_col\[1\].pe__2343_/A g_row\[1\].g_col\[1\].pe__2365_/A
+ g_row\[1\].g_col\[1\].pe__2365_/B VGND VGND VPWR VPWR g_row\[1\].g_col\[1\].pe__2366_/X
+ sky130_fd_sc_hd__a21o_2
XFILLER_25_646 VGND VGND VPWR VPWR sky130_fd_sc_hd__fill_1
XFILLER_52_421 VGND VGND VPWR VPWR sky130_fd_sc_hd__decap_3
Xg_row\[1\].g_col\[1\].pe__2297_ g_row\[1\].g_col\[1\].pe__2297_/A g_row\[1\].g_col\[1\].pe__2330_/C
+ VGND VGND VPWR VPWR g_row\[1\].g_col\[1\].pe__2305_/A sky130_fd_sc_hd__xor2_2
Xg_row\[0\].g_col\[1\].pe__2513_ g_row\[0\].g_col\[1\].pe__2513_/A1 g_row\[0\].g_col\[1\].pe__2591_/A2
+ g_row\[0\].g_col\[1\].pe__2512_/X VGND VGND VPWR VPWR g_row\[0\].g_col\[1\].pe__2513_/Y
+ sky130_fd_sc_hd__a21oi_2
XFILLER_21_841 VGND VGND VPWR VPWR sky130_fd_sc_hd__fill_1
Xg_row\[0\].g_col\[0\].pe__2428_ g_row\[0\].g_col\[0\].pe__2427_/B g_row\[0\].g_col\[0\].pe__2769_/Q
+ VGND VGND VPWR VPWR g_row\[0\].g_col\[0\].pe__2494_/B sky130_fd_sc_hd__and2b_2
Xg_row\[0\].g_col\[1\].pe__2444_ g_row\[0\].g_col\[1\].pe__2444_/A g_row\[0\].g_col\[1\].pe__2444_/B
+ VGND VGND VPWR VPWR g_row\[0\].g_col\[1\].pe__2551_/A sky130_fd_sc_hd__nor2_2
XANTENNA_30 compute_enable VGND VGND VPWR VPWR sky130_fd_sc_hd__diode_2
XANTENNA_41 output1411/A VGND VGND VPWR VPWR sky130_fd_sc_hd__diode_2
Xg_row\[0\].g_col\[1\].pe__2375_ g_row\[0\].g_col\[1\].pe__2375_/A g_row\[0\].g_col\[1\].pe__2375_/B
+ VGND VGND VPWR VPWR g_row\[0\].g_col\[1\].pe__2377_/B sky130_fd_sc_hd__xor2_2
XANTENNA_52 hold3321/A VGND VGND VPWR VPWR sky130_fd_sc_hd__diode_2
XANTENNA_63 hold3296/A VGND VGND VPWR VPWR sky130_fd_sc_hd__diode_2
XANTENNA_74 hold3204/X VGND VGND VPWR VPWR sky130_fd_sc_hd__diode_2
XFILLER_20_362 VGND VGND VPWR VPWR sky130_fd_sc_hd__fill_2
XPHY_EDGE_ROW_90_Right_90 VGND VGND VPWR VPWR sky130_fd_sc_hd__decap_3
Xg_row\[0\].g_col\[0\].pe__2359_ g_row\[0\].g_col\[0\].pe__2377_/A g_row\[0\].g_col\[0\].pe__2359_/B
+ VGND VGND VPWR VPWR g_row\[0\].g_col\[0\].pe__2359_/Y sky130_fd_sc_hd__xnor2_2
XANTENNA_85 hold3261/X VGND VGND VPWR VPWR sky130_fd_sc_hd__diode_2
XANTENNA_96 hold3385/X VGND VGND VPWR VPWR sky130_fd_sc_hd__diode_2
XTAP_TAPCELL_ROW_7_311 VGND VPWR sky130_fd_sc_hd__tapvpwrvgnd_1
XTAP_TAPCELL_ROW_7_322 VGND VPWR sky130_fd_sc_hd__tapvpwrvgnd_1
XFILLER_47_237 VGND VGND VPWR VPWR sky130_fd_sc_hd__decap_3
XTAP_TAPCELL_ROW_46_906 VGND VPWR sky130_fd_sc_hd__tapvpwrvgnd_1
Xg_row\[0\].g_col\[1\].pe_hold2040 g_row\[0\].g_col\[1\].pe__2758_/Q VGND VGND VPWR
+ VPWR g_row\[0\].g_col\[1\].pe__2528_/A1 sky130_fd_sc_hd__clkbuf_2
XFILLER_24_690 VGND VGND VPWR VPWR sky130_fd_sc_hd__decap_3
XFILLER_62_41 VGND VGND VPWR VPWR sky130_fd_sc_hd__fill_2
XFILLER_62_85 VGND VGND VPWR VPWR sky130_fd_sc_hd__fill_2
XFILLER_8_801 VGND VGND VPWR VPWR sky130_fd_sc_hd__decap_3
XFILLER_11_351 VGND VGND VPWR VPWR sky130_fd_sc_hd__fill_2
Xg_row\[1\].g_col\[0\].pe__2770_ clkbuf_leaf_52_clk/X g_row\[1\].g_col\[0\].pe__2770_/D
+ VGND VGND VPWR VPWR g_row\[1\].g_col\[0\].pe__2770_/Q sky130_fd_sc_hd__dfxtp_2
Xg_row\[1\].g_col\[0\].pe__1721_ g_row\[1\].g_col\[0\].pe__1721_/A g_row\[1\].g_col\[0\].pe__1721_/B
+ VGND VGND VPWR VPWR g_row\[1\].g_col\[0\].pe__1722_/A sky130_fd_sc_hd__xnor2_2
Xg_row\[1\].g_col\[0\].pe__1652_ g_row\[1\].g_col\[0\].pe__2610_/B g_row\[1\].g_col\[0\].pe__1748_/B
+ g_row\[1\].g_col\[0\].pe__1738_/B1 place1099/X VGND VGND VPWR VPWR g_row\[1\].g_col\[0\].pe__1653_/B
+ sky130_fd_sc_hd__a22o_2
XFILLER_79_841 VGND VGND VPWR VPWR sky130_fd_sc_hd__fill_1
Xg_row\[1\].g_col\[0\].pe__1583_ g_row\[1\].g_col\[0\].pe__1583_/A g_row\[1\].g_col\[0\].pe__1583_/B
+ VGND VGND VPWR VPWR g_row\[1\].g_col\[0\].pe__1634_/A sky130_fd_sc_hd__xnor2_2
XFILLER_39_705 VGND VGND VPWR VPWR sky130_fd_sc_hd__fill_1
XFILLER_39_727 VGND VGND VPWR VPWR sky130_fd_sc_hd__fill_1
Xg_row\[1\].g_col\[0\].pe_hold1902 g_row\[1\].g_col\[0\].pe_hold2821/X VGND VGND VPWR
+ VPWR g_row\[1\].g_col\[0\].pe__2709_/D sky130_fd_sc_hd__clkbuf_2
Xg_row\[0\].g_col\[0\].pe__1730_ g_row\[0\].g_col\[0\].pe__1785_/A g_row\[0\].g_col\[0\].pe__1730_/B
+ VGND VGND VPWR VPWR g_row\[0\].g_col\[0\].pe__1734_/B sky130_fd_sc_hd__xor2_2
Xg_row\[1\].g_col\[0\].pe_hold1924 g_row\[1\].g_col\[0\].pe__2740_/Q VGND VGND VPWR
+ VPWR g_row\[1\].g_col\[0\].pe_hold1924/X sky130_fd_sc_hd__clkbuf_2
Xg_row\[1\].g_col\[0\].pe_hold1913 g_row\[1\].g_col\[0\].pe__2439_/A VGND VGND VPWR
+ VPWR g_row\[1\].g_col\[0\].pe__2198_/A2 sky130_fd_sc_hd__clkbuf_2
XFILLER_66_579 VGND VGND VPWR VPWR sky130_fd_sc_hd__decap_3
Xg_row\[1\].g_col\[1\].pe__2220_ g_row\[1\].g_col\[1\].pe__2220_/A g_row\[1\].g_col\[1\].pe__2220_/B
+ VGND VGND VPWR VPWR g_row\[1\].g_col\[1\].pe__2221_/B sky130_fd_sc_hd__xor2_2
XFILLER_81_538 VGND VGND VPWR VPWR sky130_fd_sc_hd__fill_2
XTAP_TAPCELL_ROW_66_1200 VGND VPWR sky130_fd_sc_hd__tapvpwrvgnd_1
Xg_row\[0\].g_col\[0\].pe__1661_ g_row\[0\].g_col\[0\].pe__1693_/A g_row\[0\].g_col\[0\].pe__1693_/B
+ g_row\[0\].g_col\[0\].pe__1660_/Y VGND VGND VPWR VPWR g_row\[0\].g_col\[0\].pe__1663_/A
+ sky130_fd_sc_hd__a21o_2
Xg_row\[1\].g_col\[0\].pe__2204_ g_row\[1\].g_col\[0\].pe__2731_/Q VGND VGND VPWR
+ VPWR g_row\[1\].g_col\[0\].pe__2204_/Y sky130_fd_sc_hd__inv_2
Xg_row\[0\].g_col\[0\].pe__1592_ g_row\[0\].g_col\[0\].pe__1830_/A g_row\[0\].g_col\[0\].pe__1830_/B
+ g_row\[0\].g_col\[0\].pe__1830_/C VGND VGND VPWR VPWR g_row\[0\].g_col\[0\].pe__1840_/A
+ sky130_fd_sc_hd__o21ai_2
Xg_row\[1\].g_col\[1\].pe__2151_ g_row\[1\].g_col\[1\].pe__2151_/A g_row\[1\].g_col\[1\].pe__2151_/B
+ g_row\[1\].g_col\[1\].pe__2150_/X VGND VGND VPWR VPWR g_row\[1\].g_col\[1\].pe__2151_/X
+ sky130_fd_sc_hd__or3b_4
Xg_row\[1\].g_col\[0\].pe__2135_ g_row\[1\].g_col\[0\].pe__2135_/A g_row\[1\].g_col\[0\].pe__2135_/B
+ VGND VGND VPWR VPWR g_row\[1\].g_col\[0\].pe__2144_/A sky130_fd_sc_hd__nand2_2
Xg_row\[1\].g_col\[1\].pe__2082_ g_row\[1\].g_col\[1\].pe__2081_/B g_row\[1\].g_col\[1\].pe__2081_/C
+ g_row\[1\].g_col\[1\].pe__2126_/B2 VGND VGND VPWR VPWR g_row\[1\].g_col\[1\].pe__2087_/B
+ sky130_fd_sc_hd__a21bo_2
XFILLER_22_638 VGND VGND VPWR VPWR sky130_fd_sc_hd__fill_1
Xg_row\[1\].g_col\[0\].pe__2066_ g_row\[1\].g_col\[0\].pe__2153_/A g_row\[1\].g_col\[0\].pe__2153_/B
+ VGND VGND VPWR VPWR g_row\[1\].g_col\[0\].pe__2066_/Y sky130_fd_sc_hd__nand2_2
XFILLER_30_671 VGND VGND VPWR VPWR sky130_fd_sc_hd__fill_1
XTAP_TAPCELL_ROW_32_688 VGND VPWR sky130_fd_sc_hd__tapvpwrvgnd_1
Xg_row\[0\].g_col\[0\].pe__2213_ g_row\[0\].g_col\[0\].pe__2213_/A g_row\[0\].g_col\[0\].pe__2213_/B
+ VGND VGND VPWR VPWR g_row\[0\].g_col\[0\].pe__2220_/A sky130_fd_sc_hd__nand2_2
XTAP_TAPCELL_ROW_12_390 VGND VPWR sky130_fd_sc_hd__tapvpwrvgnd_1
Xg_row\[0\].g_col\[0\].pe__2144_ g_row\[0\].g_col\[0\].pe__2144_/A g_row\[0\].g_col\[0\].pe__2144_/B
+ VGND VGND VPWR VPWR g_row\[0\].g_col\[0\].pe__2192_/A sky130_fd_sc_hd__xnor2_2
Xg_row\[0\].g_col\[1\].pe__2160_ g_row\[0\].g_col\[1\].pe__2160_/A VGND VGND VPWR
+ VPWR g_row\[0\].g_col\[1\].pe__2439_/A sky130_fd_sc_hd__inv_2
Xg_row\[0\].g_col\[0\].pe__2075_ g_row\[0\].g_col\[0\].pe__2217_/A g_row\[0\].g_col\[0\].pe__2075_/B
+ VGND VGND VPWR VPWR g_row\[0\].g_col\[0\].pe__2136_/B sky130_fd_sc_hd__xnor2_2
Xg_row\[1\].g_col\[1\].pe__1935_ g_row\[1\].g_col\[1\].pe__1935_/A g_row\[1\].g_col\[1\].pe__1935_/B
+ VGND VGND VPWR VPWR g_row\[1\].g_col\[1\].pe__1938_/A sky130_fd_sc_hd__xnor2_2
Xg_row\[0\].g_col\[1\].pe__2091_ g_row\[0\].g_col\[1\].pe__2091_/A g_row\[0\].g_col\[1\].pe__2091_/B
+ g_row\[0\].g_col\[1\].pe__2091_/C VGND VGND VPWR VPWR g_row\[0\].g_col\[1\].pe__2097_/B
+ sky130_fd_sc_hd__and3_4
XTAP_TAPCELL_ROW_77_1362 VGND VPWR sky130_fd_sc_hd__tapvpwrvgnd_1
Xg_row\[1\].g_col\[0\].pe__1919_ g_row\[1\].g_col\[0\].pe__2094_/B g_row\[1\].g_col\[0\].pe__1919_/B
+ VGND VGND VPWR VPWR g_row\[1\].g_col\[0\].pe__2043_/A sky130_fd_sc_hd__nand2_2
XFILLER_1_509 VGND VGND VPWR VPWR sky130_fd_sc_hd__fill_1
Xg_row\[1\].g_col\[1\].pe__1866_ g_row\[1\].g_col\[1\].pe__2138_/B2 g_row\[1\].g_col\[1\].pe__1471_/X
+ g_row\[1\].g_col\[1\].pe__2247_/B1 g_row\[1\].g_col\[1\].pe__2073_/B2 VGND VGND
+ VPWR VPWR g_row\[1\].g_col\[1\].pe__1867_/B sky130_fd_sc_hd__a22o_2
Xg_row\[1\].g_col\[1\].pe__1797_ g_row\[1\].g_col\[1\].pe__1797_/A g_row\[1\].g_col\[1\].pe__1797_/B
+ VGND VGND VPWR VPWR g_row\[1\].g_col\[1\].pe__1807_/A sky130_fd_sc_hd__and2_4
XTAP_TAPCELL_ROW_90_1562 VGND VPWR sky130_fd_sc_hd__tapvpwrvgnd_1
Xhold1501 hold3327/X VGND VGND VPWR VPWR hold3328/A sky130_fd_sc_hd__clkbuf_2
Xhold1512 hold2598/X VGND VGND VPWR VPWR hold2599/A sky130_fd_sc_hd__clkbuf_2
Xhold1523 hold3338/X VGND VGND VPWR VPWR hold3339/A sky130_fd_sc_hd__clkbuf_2
Xhold1534 hold3376/X VGND VGND VPWR VPWR hold3377/A sky130_fd_sc_hd__clkbuf_2
Xg_row\[0\].g_col\[1\].pe__1944_ g_row\[0\].g_col\[1\].pe__1894_/Y g_row\[0\].g_col\[1\].pe__1895_/X
+ g_row\[0\].g_col\[1\].pe__2151_/A g_row\[0\].g_col\[1\].pe__2404_/B2 VGND VGND VPWR
+ VPWR g_row\[0\].g_col\[1\].pe__1944_/Y sky130_fd_sc_hd__a31oi_2
Xg_row\[0\].g_col\[0\].pe__1928_ g_row\[0\].g_col\[0\].pe__2045_/B g_row\[0\].g_col\[0\].pe__1928_/B
+ VGND VGND VPWR VPWR g_row\[0\].g_col\[0\].pe__1928_/X sky130_fd_sc_hd__and2_2
Xhold1545 hold2634/X VGND VGND VPWR VPWR hold2635/A sky130_fd_sc_hd__clkbuf_2
Xhold1556 hold3373/X VGND VGND VPWR VPWR hold3374/A sky130_fd_sc_hd__clkbuf_2
Xhold1567 hold3383/X VGND VGND VPWR VPWR hold3384/A sky130_fd_sc_hd__clkbuf_2
Xg_row\[0\].g_col\[0\].pe__1859_ g_row\[0\].g_col\[0\].pe__1859_/A g_row\[0\].g_col\[0\].pe__1859_/B
+ VGND VGND VPWR VPWR g_row\[0\].g_col\[0\].pe__1860_/B sky130_fd_sc_hd__xor2_2
Xhold1578 hold2682/X VGND VGND VPWR VPWR hold2683/A sky130_fd_sc_hd__clkbuf_2
Xhold1589 hold3471/X VGND VGND VPWR VPWR hold3472/A sky130_fd_sc_hd__clkbuf_2
Xg_row\[1\].g_col\[1\].pe__2418_ g_row\[1\].g_col\[1\].pe__2450_/A1 g_row\[1\].g_col\[1\].pe__2749_/Q
+ g_row\[1\].g_col\[1\].pe__2432_/B VGND VGND VPWR VPWR g_row\[1\].g_col\[1\].pe__2430_/B
+ sky130_fd_sc_hd__a21o_2
Xg_row\[1\].g_col\[0\].pe_place906 g_row\[1\].g_col\[0\].pe__1901_/A2 VGND VGND VPWR
+ VPWR g_row\[1\].g_col\[0\].pe__2363_/A2 sky130_fd_sc_hd__buf_6
Xg_row\[0\].g_col\[1\].pe__1875_ g_row\[0\].g_col\[1\].pe__1875_/A g_row\[0\].g_col\[1\].pe__1875_/B
+ g_row\[0\].g_col\[1\].pe__1875_/C VGND VGND VPWR VPWR g_row\[0\].g_col\[1\].pe__1875_/X
+ sky130_fd_sc_hd__and3_2
Xg_row\[1\].g_col\[1\].pe__2349_ g_row\[1\].g_col\[1\].pe__2368_/B g_row\[1\].g_col\[1\].pe__2349_/B
+ VGND VGND VPWR VPWR g_row\[1\].g_col\[1\].pe__2350_/B sky130_fd_sc_hd__xor2_2
Xg_row\[1\].g_col\[0\].pe_place928 g_row\[1\].g_col\[0\].pe__1838_/A VGND VGND VPWR
+ VPWR g_row\[1\].g_col\[0\].pe__2652_/A1 sky130_fd_sc_hd__buf_6
Xg_row\[1\].g_col\[0\].pe_place917 g_row\[1\].g_col\[0\].pe__1453_/Y VGND VGND VPWR
+ VPWR g_row\[1\].g_col\[0\].pe__2085_/A sky130_fd_sc_hd__buf_6
XPHY_EDGE_ROW_0_Right_0 VGND VGND VPWR VPWR sky130_fd_sc_hd__decap_3
XFILLER_13_649 VGND VGND VPWR VPWR sky130_fd_sc_hd__decap_3
Xg_row\[1\].g_col\[0\].pe_place1072 g_row\[1\].g_col\[0\].pe__1785_/A VGND VGND VPWR
+ VPWR g_row\[1\].g_col\[0\].pe__1870_/A sky130_fd_sc_hd__buf_6
Xg_row\[1\].g_col\[0\].pe_place1061 g_row\[1\].g_col\[0\].pe_hold3090/X VGND VGND
+ VPWR VPWR g_row\[1\].g_col\[0\].pe__2368_/A sky130_fd_sc_hd__buf_6
XTAP_TAPCELL_ROW_51_975 VGND VPWR sky130_fd_sc_hd__tapvpwrvgnd_1
Xg_row\[1\].g_col\[0\].pe_place1083 place1084/X VGND VGND VPWR VPWR g_row\[1\].g_col\[0\].pe__2030_/A
+ sky130_fd_sc_hd__buf_6
Xg_row\[0\].g_col\[1\].pe__2427_ g_row\[0\].g_col\[1\].pe__2769_/Q g_row\[0\].g_col\[1\].pe__2427_/B
+ VGND VGND VPWR VPWR g_row\[0\].g_col\[1\].pe__2494_/A sky130_fd_sc_hd__and2b_2
XFILLER_20_170 VGND VGND VPWR VPWR sky130_fd_sc_hd__decap_3
Xg_row\[0\].g_col\[1\].pe__2358_ g_row\[0\].g_col\[1\].pe__2358_/A g_row\[0\].g_col\[1\].pe__2358_/B
+ VGND VGND VPWR VPWR g_row\[0\].g_col\[1\].pe__2359_/B sky130_fd_sc_hd__nand2_2
Xg_row\[0\].g_col\[1\].pe__2289_ g_row\[0\].g_col\[1\].pe__2246_/A g_row\[0\].g_col\[1\].pe__2246_/B
+ g_row\[0\].g_col\[1\].pe__2288_/Y VGND VGND VPWR VPWR g_row\[0\].g_col\[1\].pe__2291_/B
+ sky130_fd_sc_hd__o21ai_2
Xhold3470 hold3470/A VGND VGND VPWR VPWR hold3470/X sky130_fd_sc_hd__clkbuf_2
XFILLER_48_524 VGND VGND VPWR VPWR sky130_fd_sc_hd__decap_3
Xhold3492 hold3492/A VGND VGND VPWR VPWR hold3492/X sky130_fd_sc_hd__clkbuf_2
Xhold3481 hold3481/A VGND VGND VPWR VPWR hold3481/X sky130_fd_sc_hd__clkbuf_2
Xhold2780 hold3559/X VGND VGND VPWR VPWR hold3560/A sky130_fd_sc_hd__clkbuf_2
Xhold2791 hold2791/A VGND VGND VPWR VPWR _276_/D sky130_fd_sc_hd__clkbuf_2
XFILLER_63_505 VGND VGND VPWR VPWR sky130_fd_sc_hd__decap_3
XPHY_EDGE_ROW_35_Left_129 VGND VGND VPWR VPWR sky130_fd_sc_hd__decap_3
XFILLER_31_402 VGND VGND VPWR VPWR sky130_fd_sc_hd__fill_2
XTAP_TAPCELL_ROW_61_1130 VGND VPWR sky130_fd_sc_hd__tapvpwrvgnd_1
XFILLER_85_7 VGND VGND VPWR VPWR sky130_fd_sc_hd__fill_1
XFILLER_8_620 VGND VGND VPWR VPWR sky130_fd_sc_hd__decap_3
XFILLER_12_693 VGND VGND VPWR VPWR sky130_fd_sc_hd__decap_3
XFILLER_7_130 VGND VGND VPWR VPWR sky130_fd_sc_hd__decap_3
XPHY_EDGE_ROW_44_Left_138 VGND VGND VPWR VPWR sky130_fd_sc_hd__decap_3
Xg_row\[1\].g_col\[0\].pe__2753_ clkbuf_leaf_51_clk/X g_row\[1\].g_col\[0\].pe__2753_/D
+ VGND VGND VPWR VPWR g_row\[1\].g_col\[0\].pe__2753_/Q sky130_fd_sc_hd__dfxtp_2
XTAP_TAPCELL_ROW_59_1092 VGND VPWR sky130_fd_sc_hd__tapvpwrvgnd_1
Xg_row\[1\].g_col\[1\].pe__1720_ g_row\[1\].g_col\[1\].pe__1742_/B g_row\[1\].g_col\[1\].pe__1743_/B
+ g_row\[1\].g_col\[1\].pe__1719_/Y VGND VGND VPWR VPWR g_row\[1\].g_col\[1\].pe__1723_/A
+ sky130_fd_sc_hd__a21o_2
Xg_row\[1\].g_col\[0\].pe__1704_ g_row\[1\].g_col\[0\].pe__1804_/A place1092/X place1093/X
+ g_row\[1\].g_col\[0\].pe__1804_/B VGND VGND VPWR VPWR g_row\[1\].g_col\[0\].pe__1705_/B
+ sky130_fd_sc_hd__a22o_2
Xg_row\[1\].g_col\[1\].pe__1651_ g_row\[1\].g_col\[1\].pe__1660_/A g_row\[1\].g_col\[1\].pe__1660_/B
+ VGND VGND VPWR VPWR g_row\[1\].g_col\[1\].pe__1693_/A sky130_fd_sc_hd__xor2_2
Xg_row\[1\].g_col\[0\].pe__2684_ g_row\[1\].g_col\[0\].pe__2684_/A g_row\[1\].g_col\[0\].pe__2684_/B
+ VGND VGND VPWR VPWR g_row\[1\].g_col\[0\].pe__2684_/X sky130_fd_sc_hd__or2_2
XFILLER_67_800 VGND VGND VPWR VPWR sky130_fd_sc_hd__fill_1
Xg_row\[1\].g_col\[0\].pe__1635_ g_row\[1\].g_col\[0\].pe__1587_/A g_row\[1\].g_col\[0\].pe__1587_/B
+ g_row\[1\].g_col\[0\].pe__1634_/X VGND VGND VPWR VPWR g_row\[1\].g_col\[0\].pe__1636_/B
+ sky130_fd_sc_hd__o21a_2
XFILLER_85_129 VGND VGND VPWR VPWR sky130_fd_sc_hd__fill_1
XTAP_TAPCELL_ROW_72_1292 VGND VPWR sky130_fd_sc_hd__tapvpwrvgnd_1
Xg_row\[1\].g_col\[1\].pe__1582_ g_row\[1\].g_col\[1\].pe__1630_/B g_row\[1\].g_col\[1\].pe__1582_/B
+ VGND VGND VPWR VPWR g_row\[1\].g_col\[1\].pe__1583_/B sky130_fd_sc_hd__xnor2_2
Xg_row\[1\].g_col\[0\].pe__1566_ place1094/X g_row\[1\].g_col\[0\].pe__1715_/B g_row\[1\].g_col\[0\].pe__1863_/B1
+ hold1950/A VGND VGND VPWR VPWR g_row\[1\].g_col\[0\].pe__1567_/B sky130_fd_sc_hd__a22o_2
Xg_row\[0\].g_col\[0\].pe__2762_ clkbuf_leaf_50_clk/X g_row\[0\].g_col\[0\].pe__2762_/D
+ VGND VGND VPWR VPWR g_row\[0\].g_col\[0\].pe__2762_/Q sky130_fd_sc_hd__dfxtp_2
Xg_row\[1\].g_col\[0\].pe_hold1732 g_row\[1\].g_col\[0\].pe__2581_/X VGND VGND VPWR
+ VPWR g_row\[1\].g_col\[0\].pe__2582_/B sky130_fd_sc_hd__clkbuf_2
Xg_row\[1\].g_col\[0\].pe__1497_ g_row\[1\].g_col\[0\].pe__2605_/B g_row\[1\].g_col\[0\].pe__1657_/B
+ g_row\[1\].g_col\[0\].pe__2036_/B1 g_row\[1\].g_col\[0\].pe__2603_/B VGND VGND VPWR
+ VPWR g_row\[1\].g_col\[0\].pe__1498_/B sky130_fd_sc_hd__a22o_2
XFILLER_66_365 VGND VGND VPWR VPWR sky130_fd_sc_hd__fill_1
XPHY_EDGE_ROW_53_Left_147 VGND VGND VPWR VPWR sky130_fd_sc_hd__decap_3
Xg_row\[0\].g_col\[0\].pe__1713_ g_row\[0\].g_col\[0\].pe__1713_/A g_row\[0\].g_col\[0\].pe__1713_/B
+ VGND VGND VPWR VPWR g_row\[0\].g_col\[0\].pe__1714_/C sky130_fd_sc_hd__xnor2_2
Xg_row\[0\].g_col\[0\].pe__2693_ _278_/CLK g_row\[0\].g_col\[0\].pe__2693_/D VGND
+ VGND VPWR VPWR hold3118/A sky130_fd_sc_hd__dfxtp_2
Xg_row\[1\].g_col\[0\].pe_hold1787 g_row\[1\].g_col\[0\].pe_hold2917/X VGND VGND VPWR
+ VPWR g_row\[1\].g_col\[0\].pe__2700_/D sky130_fd_sc_hd__clkbuf_2
Xg_row\[1\].g_col\[0\].pe_hold1765 g_row\[1\].g_col\[0\].pe__1388_/X VGND VGND VPWR
+ VPWR g_row\[1\].g_col\[0\].pe__2730_/D sky130_fd_sc_hd__clkbuf_2
XTAP_TAPCELL_ROW_37_758 VGND VPWR sky130_fd_sc_hd__tapvpwrvgnd_1
Xg_row\[0\].g_col\[0\].pe__1644_ g_row\[0\].g_col\[0\].pe__2686_/A g_row\[0\].g_col\[0\].pe__1644_/B
+ VGND VGND VPWR VPWR g_row\[0\].g_col\[0\].pe__1648_/B sky130_fd_sc_hd__xor2_2
Xg_row\[0\].g_col\[1\].pe__1660_ g_row\[0\].g_col\[1\].pe__1660_/A g_row\[0\].g_col\[1\].pe__1660_/B
+ VGND VGND VPWR VPWR g_row\[0\].g_col\[1\].pe__1660_/Y sky130_fd_sc_hd__nor2_2
Xg_row\[1\].g_col\[1\].pe__2203_ g_row\[1\].g_col\[1\].pe__2186_/B g_row\[1\].g_col\[1\].pe__2203_/B
+ VGND VGND VPWR VPWR g_row\[1\].g_col\[1\].pe__2228_/A sky130_fd_sc_hd__and2b_2
XTAP_TAPCELL_ROW_37_769 VGND VPWR sky130_fd_sc_hd__tapvpwrvgnd_1
Xg_row\[0\].g_col\[1\].pe__1591_ g_row\[0\].g_col\[1\].pe__1591_/A g_row\[0\].g_col\[1\].pe__1591_/B
+ VGND VGND VPWR VPWR g_row\[0\].g_col\[1\].pe__1830_/C sky130_fd_sc_hd__xnor2_2
Xg_row\[1\].g_col\[1\].pe__2134_ g_row\[1\].g_col\[1\].pe__2222_/A g_row\[1\].g_col\[1\].pe__2184_/B
+ g_row\[1\].g_col\[1\].pe__2184_/C VGND VGND VPWR VPWR g_row\[1\].g_col\[1\].pe__2135_/B
+ sky130_fd_sc_hd__nand3b_2
XFILLER_35_785 VGND VGND VPWR VPWR sky130_fd_sc_hd__fill_1
XTAP_TAPCELL_ROW_17_460 VGND VPWR sky130_fd_sc_hd__tapvpwrvgnd_1
XTAP_TAPCELL_ROW_17_471 VGND VPWR sky130_fd_sc_hd__tapvpwrvgnd_1
Xg_row\[0\].g_col\[0\].pe__1575_ g_row\[0\].g_col\[0\].pe__2726_/Q g_row\[0\].g_col\[0\].pe__1575_/B
+ VGND VGND VPWR VPWR g_row\[0\].g_col\[0\].pe__1626_/B sky130_fd_sc_hd__xor2_2
Xg_row\[1\].g_col\[0\].pe__2118_ g_row\[1\].g_col\[0\].pe__2107_/A g_row\[1\].g_col\[0\].pe__2105_/X
+ g_row\[1\].g_col\[0\].pe__2106_/A VGND VGND VPWR VPWR g_row\[1\].g_col\[0\].pe__2148_/A
+ sky130_fd_sc_hd__a21oi_2
Xg_row\[1\].g_col\[1\].pe__2065_ g_row\[1\].g_col\[1\].pe__2065_/A VGND VGND VPWR
+ VPWR g_row\[1\].g_col\[1\].pe__2445_/A sky130_fd_sc_hd__inv_2
Xg_row\[1\].g_col\[0\].pe__2049_ g_row\[1\].g_col\[0\].pe__2048_/A g_row\[1\].g_col\[0\].pe__2048_/B
+ g_row\[1\].g_col\[0\].pe__2048_/C VGND VGND VPWR VPWR g_row\[1\].g_col\[0\].pe__2049_/X
+ sky130_fd_sc_hd__a21o_2
XFILLER_50_799 VGND VGND VPWR VPWR sky130_fd_sc_hd__fill_2
XPHY_EDGE_ROW_62_Left_156 VGND VGND VPWR VPWR sky130_fd_sc_hd__decap_3
XTAP_TAPCELL_ROW_79_1402 VGND VPWR sky130_fd_sc_hd__tapvpwrvgnd_1
Xg_row\[0\].g_col\[1\].pe__2212_ g_row\[0\].g_col\[1\].pe__2253_/A g_row\[0\].g_col\[1\].pe__2253_/B
+ VGND VGND VPWR VPWR g_row\[0\].g_col\[1\].pe__2221_/A sky130_fd_sc_hd__xnor2_2
Xg_row\[0\].g_col\[1\].pe__2143_ g_row\[0\].g_col\[1\].pe__2143_/A g_row\[0\].g_col\[1\].pe__2143_/B
+ VGND VGND VPWR VPWR g_row\[0\].g_col\[1\].pe__2144_/B sky130_fd_sc_hd__xnor2_2
Xg_row\[0\].g_col\[0\].pe__2127_ g_row\[0\].g_col\[0\].pe__2128_/B g_row\[0\].g_col\[0\].pe__2128_/C
+ g_row\[0\].g_col\[0\].pe__2128_/A VGND VGND VPWR VPWR g_row\[0\].g_col\[0\].pe__2129_/A
+ sky130_fd_sc_hd__a21oi_2
Xg_row\[0\].g_col\[0\].pe__2058_ g_row\[0\].g_col\[0\].pe__2058_/A g_row\[0\].g_col\[0\].pe__2058_/B
+ VGND VGND VPWR VPWR g_row\[0\].g_col\[0\].pe__2067_/A sky130_fd_sc_hd__xnor2_2
Xg_row\[1\].g_col\[1\].pe__1918_ g_row\[1\].g_col\[1\].pe__2726_/Q g_row\[1\].g_col\[1\].pe__2682_/A
+ VGND VGND VPWR VPWR g_row\[1\].g_col\[1\].pe__1919_/B sky130_fd_sc_hd__nand2_2
Xg_row\[0\].g_col\[1\].pe__2074_ g_row\[0\].g_col\[1\].pe__2177_/A1 g_row\[0\].g_col\[1\].pe__1549_/B
+ g_row\[0\].g_col\[1\].pe__2216_/B1 g_row\[0\].g_col\[1\].pe__2616_/B VGND VGND VPWR
+ VPWR g_row\[0\].g_col\[1\].pe__2075_/B sky130_fd_sc_hd__a22o_2
XFILLER_89_435 VGND VGND VPWR VPWR sky130_fd_sc_hd__fill_1
Xg_row\[1\].g_col\[1\].pe__1849_ g_row\[1\].g_col\[1\].pe__1607_/A g_row\[1\].g_col\[1\].pe__1849_/B
+ VGND VGND VPWR VPWR g_row\[1\].g_col\[1\].pe__1850_/B sky130_fd_sc_hd__and2b_2
Xhold2043 hold2043/A VGND VGND VPWR VPWR hold2043/X sky130_fd_sc_hd__clkbuf_2
XPHY_EDGE_ROW_71_Left_165 VGND VGND VPWR VPWR sky130_fd_sc_hd__decap_3
Xclkbuf_leaf_96_clk clkbuf_4_2_0_clk/X VGND VGND VPWR VPWR clkbuf_leaf_96_clk/X sky130_fd_sc_hd__clkbuf_16
XFILLER_17_207 VGND VGND VPWR VPWR sky130_fd_sc_hd__decap_3
Xg_row\[0\].g_col\[1\].pe__1927_ g_row\[0\].g_col\[1\].pe__1980_/A g_row\[0\].g_col\[1\].pe__1927_/B
+ VGND VGND VPWR VPWR g_row\[0\].g_col\[1\].pe__1994_/A sky130_fd_sc_hd__xnor2_2
Xg_row\[0\].g_col\[1\].pe__1858_ g_row\[0\].g_col\[1\].pe__1908_/A g_row\[0\].g_col\[1\].pe__1858_/B
+ VGND VGND VPWR VPWR g_row\[0\].g_col\[1\].pe__1859_/B sky130_fd_sc_hd__and2_2
XFILLER_41_733 VGND VGND VPWR VPWR sky130_fd_sc_hd__fill_2
XFILLER_53_593 VGND VGND VPWR VPWR sky130_fd_sc_hd__decap_3
Xg_row\[0\].g_col\[1\].pe__1789_ g_row\[0\].g_col\[1\].pe__1789_/A g_row\[0\].g_col\[1\].pe__1789_/B
+ VGND VGND VPWR VPWR g_row\[0\].g_col\[1\].pe__1790_/B sky130_fd_sc_hd__or2_2
XFILLER_43_54 VGND VGND VPWR VPWR sky130_fd_sc_hd__fill_2
XFILLER_41_799 VGND VGND VPWR VPWR sky130_fd_sc_hd__fill_1
XPHY_EDGE_ROW_80_Left_174 VGND VGND VPWR VPWR sky130_fd_sc_hd__decap_3
Xclkbuf_leaf_20_clk clkbuf_4_4_0_clk/X VGND VGND VPWR VPWR clkbuf_leaf_20_clk/X sky130_fd_sc_hd__clkbuf_16
Xinput1296 hold3434/X VGND VGND VPWR VPWR hold3435/A sky130_fd_sc_hd__buf_2
XFILLER_4_166 VGND VGND VPWR VPWR sky130_fd_sc_hd__decap_3
Xg_row\[1\].g_col\[0\].pe__1420_ g_row\[1\].g_col\[0\].pe__1428_/A g_row\[1\].g_col\[0\].pe__1428_/B
+ VGND VGND VPWR VPWR g_row\[1\].g_col\[0\].pe__1650_/A sky130_fd_sc_hd__xor2_2
XFILLER_64_803 VGND VGND VPWR VPWR sky130_fd_sc_hd__fill_1
XFILLER_76_630 VGND VGND VPWR VPWR sky130_fd_sc_hd__decap_3
Xclkbuf_leaf_87_clk clkload4/A VGND VGND VPWR VPWR clkbuf_leaf_87_clk/X sky130_fd_sc_hd__clkbuf_16
Xg_row\[1\].g_col\[0\].pe__1351_ g_row\[1\].g_col\[0\].pe__2761_/Q g_row\[1\].g_col\[0\].pe__1351_/B
+ VGND VGND VPWR VPWR output1385/A sky130_fd_sc_hd__xnor2_2
XFILLER_48_365 VGND VGND VPWR VPWR sky130_fd_sc_hd__fill_1
XFILLER_63_313 VGND VGND VPWR VPWR sky130_fd_sc_hd__fill_1
XFILLER_84_50 VGND VGND VPWR VPWR sky130_fd_sc_hd__fill_2
XFILLER_84_72 VGND VGND VPWR VPWR sky130_fd_sc_hd__fill_2
XFILLER_51_508 VGND VGND VPWR VPWR sky130_fd_sc_hd__decap_3
XFILLER_17_796 VGND VGND VPWR VPWR sky130_fd_sc_hd__fill_1
XTAP_TAPCELL_ROW_34_717 VGND VPWR sky130_fd_sc_hd__tapvpwrvgnd_1
XFILLER_31_243 VGND VGND VPWR VPWR sky130_fd_sc_hd__decap_3
Xg_row\[0\].g_col\[0\].pe__1360_ g_row\[0\].g_col\[0\].pe__2765_/Q g_row\[0\].g_col\[0\].pe__1359_/B
+ g_row\[0\].g_col\[0\].pe__2776_/A VGND VGND VPWR VPWR g_row\[0\].g_col\[0\].pe__1361_/B
+ sky130_fd_sc_hd__o21a_2
Xclkbuf_leaf_11_clk clkload4/A VGND VGND VPWR VPWR _307_/CLK sky130_fd_sc_hd__clkbuf_16
XFILLER_8_494 VGND VGND VPWR VPWR sky130_fd_sc_hd__fill_2
XTAP_TAPCELL_ROW_74_1321 VGND VPWR sky130_fd_sc_hd__tapvpwrvgnd_1
Xg_row\[1\].g_col\[1\].pe__2752_ clkbuf_leaf_78_clk/X g_row\[1\].g_col\[1\].pe__2752_/D
+ VGND VGND VPWR VPWR g_row\[1\].g_col\[1\].pe__2752_/Q sky130_fd_sc_hd__dfxtp_2
Xg_row\[1\].g_col\[1\].pe__1703_ g_row\[1\].g_col\[1\].pe__1703_/A g_row\[1\].g_col\[1\].pe__1703_/B
+ VGND VGND VPWR VPWR g_row\[1\].g_col\[1\].pe__1824_/B sky130_fd_sc_hd__xnor2_2
Xg_row\[1\].g_col\[0\].pe__2736_ clkbuf_leaf_47_clk/X g_row\[1\].g_col\[0\].pe__2736_/D
+ VGND VGND VPWR VPWR g_row\[1\].g_col\[0\].pe__2736_/Q sky130_fd_sc_hd__dfxtp_2
Xg_row\[1\].g_col\[1\].pe__2683_ g_row\[1\].g_col\[1\].pe__2683_/A1 g_row\[1\].g_col\[1\].pe__2680_/B
+ g_row\[1\].g_col\[1\].pe__2682_/X g_row\[1\].g_col\[1\].pe__2683_/C1 VGND VGND VPWR
+ VPWR g_row\[1\].g_col\[1\].pe__2683_/X sky130_fd_sc_hd__o211a_2
Xg_row\[1\].g_col\[0\].pe__2667_ g_row\[1\].g_col\[0\].pe__2669_/A g_row\[1\].g_col\[0\].pe__2667_/B
+ VGND VGND VPWR VPWR g_row\[1\].g_col\[0\].pe__2667_/X sky130_fd_sc_hd__or2_2
Xg_row\[1\].g_col\[1\].pe__1634_ g_row\[1\].g_col\[1\].pe__1634_/A g_row\[1\].g_col\[1\].pe__1634_/B
+ VGND VGND VPWR VPWR g_row\[1\].g_col\[1\].pe__1634_/X sky130_fd_sc_hd__or2_2
Xg_row\[1\].g_col\[0\].pe__1618_ g_row\[1\].g_col\[0\].pe__1642_/A g_row\[1\].g_col\[0\].pe__2125_/A
+ g_row\[1\].g_col\[0\].pe__1641_/B2 VGND VGND VPWR VPWR g_row\[1\].g_col\[0\].pe__1875_/B
+ sky130_fd_sc_hd__or3b_2
XFILLER_67_641 VGND VGND VPWR VPWR sky130_fd_sc_hd__fill_2
Xclkbuf_leaf_78_clk clkbuf_4_10_0_clk/X VGND VGND VPWR VPWR clkbuf_leaf_78_clk/X sky130_fd_sc_hd__clkbuf_16
Xg_row\[1\].g_col\[1\].pe_place833 g_row\[1\].g_col\[1\].pe__1504_/Y VGND VGND VPWR
+ VPWR g_row\[1\].g_col\[1\].pe__2313_/A2 sky130_fd_sc_hd__buf_6
Xg_row\[1\].g_col\[1\].pe__1565_ g_row\[1\].g_col\[1\].pe__1739_/A g_row\[1\].g_col\[1\].pe__1565_/B
+ VGND VGND VPWR VPWR g_row\[1\].g_col\[1\].pe__1596_/A sky130_fd_sc_hd__xor2_2
Xg_row\[1\].g_col\[0\].pe_hold2241 g_row\[1\].g_col\[0\].pe__2432_/A VGND VGND VPWR
+ VPWR g_row\[1\].g_col\[0\].pe__2306_/A2 sky130_fd_sc_hd__clkbuf_2
XFILLER_27_505 VGND VGND VPWR VPWR sky130_fd_sc_hd__decap_3
Xg_row\[0\].g_col\[0\].pe__2745_ _277_/CLK g_row\[0\].g_col\[0\].pe__2745_/D VGND
+ VGND VPWR VPWR ANTENNA_145/DIODE sky130_fd_sc_hd__dfxtp_2
Xg_row\[1\].g_col\[0\].pe__1549_ g_row\[1\].g_col\[0\].pe__2599_/B g_row\[1\].g_col\[0\].pe__1549_/B
+ g_row\[1\].g_col\[0\].pe__1549_/C VGND VGND VPWR VPWR g_row\[1\].g_col\[0\].pe__1669_/A
+ sky130_fd_sc_hd__and3_2
Xg_row\[0\].g_col\[1\].pe__2761_ clkbuf_leaf_13_clk/X g_row\[0\].g_col\[1\].pe__2761_/D
+ VGND VGND VPWR VPWR g_row\[0\].g_col\[1\].pe__2761_/Q sky130_fd_sc_hd__dfxtp_2
XFILLER_66_195 VGND VGND VPWR VPWR sky130_fd_sc_hd__fill_1
Xg_row\[0\].g_col\[1\].pe__1712_ g_row\[0\].g_col\[1\].pe__1736_/A g_row\[0\].g_col\[1\].pe__1736_/B
+ VGND VGND VPWR VPWR g_row\[0\].g_col\[1\].pe__1714_/B sky130_fd_sc_hd__nand2_2
Xg_row\[1\].g_col\[1\].pe_place877 g_row\[1\].g_col\[1\].pe__2591_/A2 VGND VGND VPWR
+ VPWR g_row\[1\].g_col\[1\].pe__2568_/A2 sky130_fd_sc_hd__buf_6
Xg_row\[1\].g_col\[1\].pe_place888 g_row\[1\].g_col\[1\].pe__2026_/B VGND VGND VPWR
+ VPWR g_row\[1\].g_col\[1\].pe__1748_/B sky130_fd_sc_hd__buf_6
Xg_row\[1\].g_col\[1\].pe_place899 g_row\[1\].g_col\[1\].pe__1950_/A VGND VGND VPWR
+ VPWR g_row\[1\].g_col\[1\].pe__2633_/A1 sky130_fd_sc_hd__buf_6
Xg_row\[1\].g_col\[1\].pe__1496_ g_row\[1\].g_col\[1\].pe__1536_/A g_row\[1\].g_col\[1\].pe__1536_/B
+ VGND VGND VPWR VPWR g_row\[1\].g_col\[1\].pe__1499_/A sky130_fd_sc_hd__xor2_2
Xg_row\[0\].g_col\[1\].pe__2692_ clkbuf_leaf_90_clk/X g_row\[0\].g_col\[1\].pe__2692_/D
+ VGND VGND VPWR VPWR g_row\[0\].g_col\[1\].pe__2692_/Q sky130_fd_sc_hd__dfxtp_2
XFILLER_54_368 VGND VGND VPWR VPWR sky130_fd_sc_hd__decap_3
Xg_row\[0\].g_col\[0\].pe__2676_ g_row\[0\].g_col\[0\].pe__2676_/A g_row\[0\].g_col\[0\].pe__2678_/B
+ VGND VGND VPWR VPWR g_row\[0\].g_col\[0\].pe__2676_/Y sky130_fd_sc_hd__nand2_2
Xg_row\[0\].g_col\[1\].pe__1643_ g_row\[0\].g_col\[1\].pe__1727_/A2 g_row\[0\].g_col\[1\].pe__1729_/A2
+ g_row\[0\].g_col\[1\].pe__1729_/A3 g_row\[0\].g_col\[1\].pe__1729_/B1 g_row\[0\].g_col\[1\].pe__1704_/A2
+ VGND VGND VPWR VPWR g_row\[0\].g_col\[1\].pe__1644_/B sky130_fd_sc_hd__a32o_2
XFILLER_81_187 VGND VGND VPWR VPWR sky130_fd_sc_hd__decap_3
XTAP_TAPCELL_ROW_85_1483 VGND VPWR sky130_fd_sc_hd__tapvpwrvgnd_1
Xg_row\[0\].g_col\[0\].pe__1627_ g_row\[0\].g_col\[0\].pe__1579_/A g_row\[0\].g_col\[0\].pe__1579_/B
+ g_row\[0\].g_col\[0\].pe__1626_/X VGND VGND VPWR VPWR g_row\[0\].g_col\[0\].pe__1879_/B
+ sky130_fd_sc_hd__a21oi_2
XFILLER_50_552 VGND VGND VPWR VPWR sky130_fd_sc_hd__fill_1
Xg_row\[0\].g_col\[0\].pe__1558_ place1223/X g_row\[0\].g_col\[0\].pe__1558_/B g_row\[0\].g_col\[0\].pe__1558_/C
+ VGND VGND VPWR VPWR g_row\[0\].g_col\[0\].pe__1607_/A sky130_fd_sc_hd__nand3_2
Xg_row\[0\].g_col\[1\].pe__1574_ g_row\[0\].g_col\[1\].pe__2625_/B g_row\[0\].g_col\[1\].pe__1414_/X
+ g_row\[0\].g_col\[1\].pe__1415_/Y g_row\[0\].g_col\[1\].pe__1801_/B g_row\[0\].g_col\[1\].pe__2702_/Q
+ VGND VGND VPWR VPWR g_row\[0\].g_col\[1\].pe__1575_/B sky130_fd_sc_hd__a32o_2
Xg_row\[1\].g_col\[1\].pe__2117_ g_row\[1\].g_col\[1\].pe__2117_/A g_row\[1\].g_col\[1\].pe__2117_/B
+ VGND VGND VPWR VPWR g_row\[1\].g_col\[1\].pe__2161_/A sky130_fd_sc_hd__nor2_2
Xg_row\[1\].g_col\[1\].pe__2048_ g_row\[1\].g_col\[1\].pe__2048_/A g_row\[1\].g_col\[1\].pe__2048_/B
+ g_row\[1\].g_col\[1\].pe__2048_/C VGND VGND VPWR VPWR g_row\[1\].g_col\[1\].pe__2048_/Y
+ sky130_fd_sc_hd__nand3_2
XFILLER_10_438 VGND VGND VPWR VPWR sky130_fd_sc_hd__fill_2
Xg_row\[0\].g_col\[0\].pe__1489_ g_row\[0\].g_col\[0\].pe__1789_/A g_row\[0\].g_col\[0\].pe__1489_/B
+ VGND VGND VPWR VPWR g_row\[0\].g_col\[0\].pe__1490_/B sky130_fd_sc_hd__xor2_2
Xg_row\[0\].g_col\[1\].pe__2126_ g_row\[0\].g_col\[1\].pe__2125_/A g_row\[0\].g_col\[1\].pe__1449_/A
+ g_row\[0\].g_col\[1\].pe__2125_/X g_row\[0\].g_col\[1\].pe__2167_/A VGND VGND VPWR
+ VPWR g_row\[0\].g_col\[1\].pe__2128_/A sky130_fd_sc_hd__a2bb2o_2
XFILLER_2_648 VGND VGND VPWR VPWR sky130_fd_sc_hd__fill_1
Xg_row\[0\].g_col\[1\].pe__2057_ g_row\[0\].g_col\[1\].pe__2068_/A g_row\[0\].g_col\[1\].pe__2068_/B
+ VGND VGND VPWR VPWR g_row\[0\].g_col\[1\].pe__2058_/B sky130_fd_sc_hd__xnor2_2
XFILLER_1_169 VGND VGND VPWR VPWR sky130_fd_sc_hd__fill_1
Xclkbuf_leaf_69_clk clkload4/A VGND VGND VPWR VPWR clkbuf_leaf_69_clk/X sky130_fd_sc_hd__clkbuf_16
XFILLER_73_600 VGND VGND VPWR VPWR sky130_fd_sc_hd__decap_3
XFILLER_45_313 VGND VGND VPWR VPWR sky130_fd_sc_hd__decap_3
XFILLER_72_110 VGND VGND VPWR VPWR sky130_fd_sc_hd__decap_3
XFILLER_45_357 VGND VGND VPWR VPWR sky130_fd_sc_hd__decap_3
XFILLER_73_688 VGND VGND VPWR VPWR sky130_fd_sc_hd__fill_1
XFILLER_14_733 VGND VGND VPWR VPWR sky130_fd_sc_hd__decap_3
Xg_row\[0\].g_col\[0\].pe_hold2306 g_row\[0\].g_col\[0\].pe_hold2889/X VGND VGND VPWR
+ VPWR g_row\[0\].g_col\[0\].pe_hold2890/A sky130_fd_sc_hd__clkbuf_2
Xg_row\[0\].g_col\[0\].pe_hold2317 g_row\[0\].g_col\[0\].pe_hold2910/X VGND VGND VPWR
+ VPWR g_row\[0\].g_col\[0\].pe_hold2911/A sky130_fd_sc_hd__clkbuf_2
XFILLER_14_755 VGND VGND VPWR VPWR sky130_fd_sc_hd__fill_1
XFILLER_53_390 VGND VGND VPWR VPWR sky130_fd_sc_hd__fill_2
XTAP_TAPCELL_ROW_0_191 VGND VPWR sky130_fd_sc_hd__tapvpwrvgnd_1
XFILLER_14_799 VGND VGND VPWR VPWR sky130_fd_sc_hd__fill_1
Xclkload17 clkload17/A VGND VGND VPWR VPWR clkload17/X sky130_fd_sc_hd__buf_2
Xoutput1408 output1408/A VGND VGND VPWR VPWR results_flat[58] sky130_fd_sc_hd__buf_2
XFILLER_5_497 VGND VGND VPWR VPWR sky130_fd_sc_hd__fill_1
XFILLER_79_61 VGND VGND VPWR VPWR sky130_fd_sc_hd__fill_1
Xg_row\[1\].g_col\[1\].pe_hold3072 g_row\[1\].g_col\[1\].pe__1399_/X VGND VGND VPWR
+ VPWR g_row\[1\].g_col\[1\].pe_hold3072/X sky130_fd_sc_hd__clkbuf_2
XTAP_TAPCELL_ROW_56_1051 VGND VPWR sky130_fd_sc_hd__tapvpwrvgnd_1
Xg_row\[1\].g_col\[0\].pe__2521_ g_row\[1\].g_col\[0\].pe__2521_/A1 g_row\[1\].g_col\[0\].pe__2560_/A2
+ g_row\[1\].g_col\[0\].pe__2560_/B1 g_row\[1\].g_col\[0\].pe__2520_/X VGND VGND VPWR
+ VPWR g_row\[1\].g_col\[0\].pe__2522_/B sky130_fd_sc_hd__a22o_2
Xg_row\[1\].g_col\[1\].pe_hold1681 g_row\[1\].g_col\[1\].pe__2397_/Y VGND VGND VPWR
+ VPWR g_row\[1\].g_col\[1\].pe__2401_/A2 sky130_fd_sc_hd__clkbuf_2
Xg_row\[1\].g_col\[1\].pe_hold1670 g_row\[1\].g_col\[1\].pe__2752_/Q VGND VGND VPWR
+ VPWR g_row\[1\].g_col\[1\].pe__2380_/B1 sky130_fd_sc_hd__clkbuf_2
Xg_row\[1\].g_col\[0\].pe__2452_ g_row\[1\].g_col\[0\].pe__2760_/Q g_row\[1\].g_col\[0\].pe__2452_/B
+ VGND VGND VPWR VPWR g_row\[1\].g_col\[0\].pe__2538_/A sky130_fd_sc_hd__xnor2_2
Xg_row\[1\].g_col\[0\].pe__1403_ g_row\[1\].g_col\[0\].pe__1403_/A1 g_row\[1\].g_col\[0\].pe__2679_/A2
+ g_row\[1\].g_col\[0\].pe__1402_/X g_row\[1\].g_col\[0\].pe__1403_/C1 VGND VGND VPWR
+ VPWR g_row\[1\].g_col\[0\].pe__1403_/X sky130_fd_sc_hd__o211a_2
Xclkbuf_leaf_0_clk clkbuf_4_0_0_clk/X VGND VGND VPWR VPWR _332_/CLK sky130_fd_sc_hd__clkbuf_16
Xg_row\[1\].g_col\[1\].pe__1350_ g_row\[1\].g_col\[1\].pe__2760_/Q g_row\[1\].g_col\[1\].pe__1348_/B
+ g_row\[1\].g_col\[1\].pe__2776_/A VGND VGND VPWR VPWR g_row\[1\].g_col\[1\].pe__1351_/B
+ sky130_fd_sc_hd__o21ai_2
Xg_row\[1\].g_col\[0\].pe__2383_ g_row\[1\].g_col\[0\].pe__2383_/A VGND VGND VPWR
+ VPWR g_row\[1\].g_col\[0\].pe__2422_/A sky130_fd_sc_hd__inv_2
XFILLER_64_633 VGND VGND VPWR VPWR sky130_fd_sc_hd__decap_3
XTAP_TAPCELL_ROW_19_500 VGND VPWR sky130_fd_sc_hd__tapvpwrvgnd_1
Xg_row\[1\].g_col\[1\].pe_place1005 g_row\[1\].g_col\[1\].pe__2732_/Q VGND VGND VPWR
+ VPWR g_row\[1\].g_col\[1\].pe__2250_/A sky130_fd_sc_hd__buf_6
Xg_row\[1\].g_col\[1\].pe_place1016 g_row\[1\].g_col\[1\].pe__2682_/A VGND VGND VPWR
+ VPWR g_row\[1\].g_col\[1\].pe__1928_/A sky130_fd_sc_hd__buf_6
Xg_row\[1\].g_col\[1\].pe_place1027 g_row\[1\].g_col\[1\].pe__1970_/A VGND VGND VPWR
+ VPWR g_row\[1\].g_col\[1\].pe__2278_/B2 sky130_fd_sc_hd__buf_6
XFILLER_64_655 VGND VGND VPWR VPWR sky130_fd_sc_hd__decap_3
Xg_row\[1\].g_col\[1\].pe_place1038 g_row\[1\].g_col\[1\].pe__2695_/Q VGND VGND VPWR
+ VPWR g_row\[1\].g_col\[1\].pe__2612_/B sky130_fd_sc_hd__buf_6
Xg_row\[1\].g_col\[1\].pe_place1049 g_row\[1\].g_col\[1\].pe__2666_/B1 VGND VGND VPWR
+ VPWR g_row\[1\].g_col\[1\].pe__2670_/B1 sky130_fd_sc_hd__buf_6
XFILLER_17_582 VGND VGND VPWR VPWR sky130_fd_sc_hd__fill_1
XFILLER_51_316 VGND VGND VPWR VPWR sky130_fd_sc_hd__fill_1
XFILLER_64_699 VGND VGND VPWR VPWR sky130_fd_sc_hd__fill_1
Xg_row\[0\].g_col\[0\].pe__2461_ g_row\[0\].g_col\[0\].pe__2757_/Q g_row\[0\].g_col\[0\].pe__2462_/B
+ VGND VGND VPWR VPWR g_row\[0\].g_col\[0\].pe__2519_/B sky130_fd_sc_hd__xnor2_2
Xg_row\[0\].g_col\[0\].pe__1412_ g_row\[0\].g_col\[0\].pe__1761_/A1 place1201/X place1204/X
+ g_row\[0\].g_col\[0\].pe__1616_/A2 VGND VGND VPWR VPWR g_row\[0\].g_col\[0\].pe__1413_/B
+ sky130_fd_sc_hd__a22o_2
Xg_row\[0\].g_col\[0\].pe__2392_ g_row\[0\].g_col\[0\].pe__2392_/A g_row\[0\].g_col\[0\].pe__2392_/B
+ VGND VGND VPWR VPWR g_row\[0\].g_col\[0\].pe__2392_/Y sky130_fd_sc_hd__xnor2_2
Xg_row\[0\].g_col\[0\].pe__1343_ g_row\[0\].g_col\[0\].pe__2757_/Q g_row\[0\].g_col\[0\].pe__2775_/A
+ g_row\[0\].g_col\[0\].pe__1348_/A VGND VGND VPWR VPWR g_row\[0\].g_col\[0\].pe__1344_/B
+ sky130_fd_sc_hd__o21ai_2
Xg_row\[1\].g_col\[1\].pe__2735_ clkbuf_leaf_84_clk/X g_row\[1\].g_col\[1\].pe__2735_/D
+ VGND VGND VPWR VPWR g_row\[1\].g_col\[1\].pe__2735_/Q sky130_fd_sc_hd__dfxtp_2
Xg_row\[1\].g_col\[0\].pe__2719_ clkbuf_leaf_48_clk/X g_row\[1\].g_col\[0\].pe__2719_/D
+ VGND VGND VPWR VPWR g_row\[1\].g_col\[0\].pe__2719_/Q sky130_fd_sc_hd__dfxtp_2
Xg_row\[1\].g_col\[1\].pe__2666_ g_row\[1\].g_col\[1\].pe__2670_/A1 hold1976/X g_row\[1\].g_col\[1\].pe__2666_/B1
+ g_row\[1\].g_col\[1\].pe__2666_/C1 VGND VGND VPWR VPWR g_row\[1\].g_col\[1\].pe__2666_/X
+ sky130_fd_sc_hd__o211a_2
XFILLER_59_449 VGND VGND VPWR VPWR sky130_fd_sc_hd__decap_3
XFILLER_87_769 VGND VGND VPWR VPWR sky130_fd_sc_hd__decap_3
Xg_row\[1\].g_col\[1\].pe__1617_ g_row\[1\].g_col\[1\].pe__2163_/A VGND VGND VPWR
+ VPWR g_row\[1\].g_col\[1\].pe__2125_/A sky130_fd_sc_hd__inv_2
XFILLER_86_268 VGND VGND VPWR VPWR sky130_fd_sc_hd__fill_1
Xg_row\[1\].g_col\[0\].pe_hold2071 g_row\[1\].g_col\[0\].pe_hold2927/X VGND VGND VPWR
+ VPWR g_row\[1\].g_col\[0\].pe_hold2928/A sky130_fd_sc_hd__clkbuf_2
Xg_row\[1\].g_col\[0\].pe_hold2060 g_row\[1\].g_col\[0\].pe_hold2986/X VGND VGND VPWR
+ VPWR g_row\[1\].g_col\[0\].pe__2719_/D sky130_fd_sc_hd__clkbuf_2
XTAP_TAPCELL_ROW_87_1512 VGND VPWR sky130_fd_sc_hd__tapvpwrvgnd_1
Xg_row\[1\].g_col\[1\].pe__1548_ g_row\[1\].g_col\[1\].pe__1550_/A g_row\[1\].g_col\[1\].pe__1550_/B
+ VGND VGND VPWR VPWR g_row\[1\].g_col\[1\].pe__1830_/A sky130_fd_sc_hd__and2b_2
Xg_row\[0\].g_col\[1\].pe_hold2403 g_row\[0\].g_col\[1\].pe__1892_/X VGND VGND VPWR
+ VPWR g_row\[0\].g_col\[1\].pe__1893_/B sky130_fd_sc_hd__clkbuf_2
Xg_row\[0\].g_col\[0\].pe__2728_ clkbuf_leaf_39_clk/X g_row\[0\].g_col\[0\].pe__2728_/D
+ VGND VGND VPWR VPWR g_row\[0\].g_col\[0\].pe__2728_/Q sky130_fd_sc_hd__dfxtp_2
Xg_row\[1\].g_col\[1\].pe__1479_ g_row\[1\].g_col\[1\].pe__1479_/A g_row\[1\].g_col\[1\].pe__1479_/B
+ VGND VGND VPWR VPWR g_row\[1\].g_col\[1\].pe__1479_/Y sky130_fd_sc_hd__nor2_2
Xg_row\[0\].g_col\[1\].pe__2744_ clkbuf_leaf_4_clk/X g_row\[0\].g_col\[1\].pe__2744_/D
+ VGND VGND VPWR VPWR g_row\[0\].g_col\[1\].pe__2744_/Q sky130_fd_sc_hd__dfxtp_2
XFILLER_43_839 VGND VGND VPWR VPWR sky130_fd_sc_hd__fill_1
XFILLER_70_636 VGND VGND VPWR VPWR sky130_fd_sc_hd__fill_1
XFILLER_82_474 VGND VGND VPWR VPWR sky130_fd_sc_hd__fill_2
Xg_row\[0\].g_col\[0\].pe__2659_ g_row\[0\].g_col\[0\].pe__2669_/A hold1898/X VGND
+ VGND VPWR VPWR g_row\[0\].g_col\[0\].pe__2659_/X sky130_fd_sc_hd__or2_2
Xg_row\[0\].g_col\[1\].pe__2675_ g_row\[0\].g_col\[1\].pe__2672_/X g_row\[0\].g_col\[1\].pe__2673_/X
+ g_row\[0\].g_col\[1\].pe__2674_/X g_row\[0\].g_col\[1\].pe__2675_/B1 VGND VGND VPWR
+ VPWR g_row\[0\].g_col\[1\].pe__2675_/Y sky130_fd_sc_hd__o31ai_2
XFILLER_23_530 VGND VGND VPWR VPWR sky130_fd_sc_hd__fill_1
Xg_row\[0\].g_col\[1\].pe__1626_ g_row\[0\].g_col\[1\].pe__1626_/A g_row\[0\].g_col\[1\].pe__1626_/B
+ VGND VGND VPWR VPWR g_row\[0\].g_col\[1\].pe__1626_/X sky130_fd_sc_hd__and2_2
XFILLER_11_703 VGND VGND VPWR VPWR sky130_fd_sc_hd__fill_1
Xg_row\[0\].g_col\[1\].pe__1557_ g_row\[0\].g_col\[1\].pe__1557_/A g_row\[0\].g_col\[1\].pe__1557_/B
+ VGND VGND VPWR VPWR g_row\[0\].g_col\[1\].pe__1558_/C sky130_fd_sc_hd__xnor2_2
Xg_row\[0\].g_col\[1\].pe__1488_ g_row\[0\].g_col\[1\].pe__2036_/B2 g_row\[0\].g_col\[1\].pe__1732_/A2
+ g_row\[0\].g_col\[1\].pe__1732_/B1 g_row\[0\].g_col\[1\].pe__1704_/A2 VGND VGND
+ VPWR VPWR g_row\[0\].g_col\[1\].pe__1489_/B sky130_fd_sc_hd__a22o_2
Xg_row\[0\].g_col\[1\].pe__2109_ g_row\[0\].g_col\[1\].pe__2110_/A g_row\[0\].g_col\[1\].pe__2110_/B
+ VGND VGND VPWR VPWR g_row\[0\].g_col\[1\].pe__2111_/A sky130_fd_sc_hd__and2_4
XFILLER_18_302 VGND VGND VPWR VPWR sky130_fd_sc_hd__fill_1
XFILLER_46_633 VGND VGND VPWR VPWR sky130_fd_sc_hd__decap_3
XFILLER_58_493 VGND VGND VPWR VPWR sky130_fd_sc_hd__decap_3
XTAP_TAPCELL_ROW_5_283 VGND VPWR sky130_fd_sc_hd__tapvpwrvgnd_1
XFILLER_46_655 VGND VGND VPWR VPWR sky130_fd_sc_hd__decap_3
XANTENNA_120 hold3295/X VGND VGND VPWR VPWR sky130_fd_sc_hd__diode_2
XANTENNA_131 a_inputs_flat[15] VGND VGND VPWR VPWR sky130_fd_sc_hd__diode_2
XANTENNA_142 ANTENNA_142/DIODE VGND VGND VPWR VPWR sky130_fd_sc_hd__diode_2
Xg_row\[0\].g_col\[1\].pe_hold2970 _331_/Q VGND VGND VPWR VPWR g_row\[0\].g_col\[1\].pe_hold2970/X
+ sky130_fd_sc_hd__clkbuf_2
XANTENNA_153 ANTENNA_153/DIODE VGND VGND VPWR VPWR sky130_fd_sc_hd__diode_2
XANTENNA_164 hold3366/A VGND VGND VPWR VPWR sky130_fd_sc_hd__diode_2
XANTENNA_175 hold3317/X VGND VGND VPWR VPWR sky130_fd_sc_hd__diode_2
XFILLER_14_530 VGND VGND VPWR VPWR sky130_fd_sc_hd__fill_2
Xg_row\[0\].g_col\[0\].pe_hold2103 g_row\[0\].g_col\[0\].pe__2592_/X VGND VGND VPWR
+ VPWR g_row\[0\].g_col\[0\].pe__2770_/D sky130_fd_sc_hd__clkbuf_2
Xg_row\[0\].g_col\[0\].pe_hold2114 _276_/Q VGND VGND VPWR VPWR g_row\[0\].g_col\[0\].pe__1374_/B
+ sky130_fd_sc_hd__clkbuf_2
Xg_row\[0\].g_col\[0\].pe_hold2125 g_row\[0\].g_col\[0\].pe__2760_/Q VGND VGND VPWR
+ VPWR g_row\[0\].g_col\[0\].pe__2541_/A1 sky130_fd_sc_hd__clkbuf_2
XFILLER_14_574 VGND VGND VPWR VPWR sky130_fd_sc_hd__fill_2
XTAP_TAPCELL_ROW_44_867 VGND VPWR sky130_fd_sc_hd__tapvpwrvgnd_1
XFILLER_14_585 VGND VGND VPWR VPWR sky130_fd_sc_hd__decap_3
XFILLER_41_393 VGND VGND VPWR VPWR sky130_fd_sc_hd__fill_2
XFILLER_10_780 VGND VGND VPWR VPWR sky130_fd_sc_hd__decap_3
X_288_ _288_/CLK _288_/D VGND VGND VPWR VPWR _288_/Q sky130_fd_sc_hd__dfxtp_2
Xg_row\[1\].g_col\[0\].pe__1952_ g_row\[1\].g_col\[0\].pe__1952_/A g_row\[1\].g_col\[0\].pe__1938_/A
+ VGND VGND VPWR VPWR g_row\[1\].g_col\[0\].pe__1952_/X sky130_fd_sc_hd__or2b_2
Xg_row\[1\].g_col\[0\].pe__1883_ g_row\[1\].g_col\[0\].pe__1883_/A g_row\[1\].g_col\[0\].pe__1883_/B
+ VGND VGND VPWR VPWR g_row\[1\].g_col\[0\].pe__1883_/X sky130_fd_sc_hd__or2_2
XFILLER_69_714 VGND VGND VPWR VPWR sky130_fd_sc_hd__decap_3
XFILLER_69_725 VGND VGND VPWR VPWR sky130_fd_sc_hd__decap_3
Xg_row\[0\].g_col\[0\].pe__1961_ g_row\[0\].g_col\[0\].pe__1961_/A g_row\[0\].g_col\[0\].pe__1961_/B
+ VGND VGND VPWR VPWR g_row\[0\].g_col\[0\].pe__1962_/B sky130_fd_sc_hd__or2_2
Xhold2609 hold3367/X VGND VGND VPWR VPWR _209_/B_N sky130_fd_sc_hd__clkbuf_2
Xg_row\[1\].g_col\[1\].pe__2520_ g_row\[1\].g_col\[1\].pe__2499_/B g_row\[1\].g_col\[1\].pe__2519_/Y
+ g_row\[1\].g_col\[1\].pe__2559_/A VGND VGND VPWR VPWR g_row\[1\].g_col\[1\].pe__2520_/X
+ sky130_fd_sc_hd__a21o_2
Xg_row\[1\].g_col\[0\].pe__2504_ g_row\[1\].g_col\[0\].pe__2495_/A g_row\[1\].g_col\[0\].pe__2471_/C
+ g_row\[1\].g_col\[0\].pe__2471_/A VGND VGND VPWR VPWR g_row\[1\].g_col\[0\].pe__2504_/X
+ sky130_fd_sc_hd__a21o_2
Xg_row\[1\].g_col\[1\].pe__2451_ g_row\[1\].g_col\[1\].pe__2451_/A g_row\[1\].g_col\[1\].pe__2451_/B
+ VGND VGND VPWR VPWR g_row\[1\].g_col\[1\].pe__2452_/B sky130_fd_sc_hd__xnor2_2
Xg_row\[0\].g_col\[0\].pe__1892_ g_row\[0\].g_col\[0\].pe__1950_/A g_row\[0\].g_col\[0\].pe_hold1933/X
+ g_row\[0\].g_col\[0\].pe__2010_/A g_row\[0\].g_col\[0\].pe__1891_/Y VGND VGND VPWR
+ VPWR g_row\[0\].g_col\[0\].pe__1892_/X sky130_fd_sc_hd__o2bb2a_2
Xg_row\[1\].g_col\[1\].pe__1402_ hold2088/X g_row\[1\].g_col\[1\].pe__1402_/B VGND
+ VGND VPWR VPWR g_row\[1\].g_col\[1\].pe__1402_/X sky130_fd_sc_hd__or2_2
Xg_row\[1\].g_col\[0\].pe__2435_ g_row\[1\].g_col\[0\].pe__2472_/B g_row\[1\].g_col\[0\].pe__2765_/Q
+ VGND VGND VPWR VPWR g_row\[1\].g_col\[0\].pe__2489_/B sky130_fd_sc_hd__or2b_2
Xg_row\[1\].g_col\[0\].pe__2366_ g_row\[1\].g_col\[0\].pe__2343_/A g_row\[1\].g_col\[0\].pe__2365_/A
+ g_row\[1\].g_col\[0\].pe__2365_/B VGND VGND VPWR VPWR g_row\[1\].g_col\[0\].pe__2366_/X
+ sky130_fd_sc_hd__a21o_2
XTAP_TAPCELL_ROW_69_1242 VGND VPWR sky130_fd_sc_hd__tapvpwrvgnd_1
XFILLER_52_603 VGND VGND VPWR VPWR sky130_fd_sc_hd__decap_3
Xg_row\[0\].g_col\[0\].pe__2513_ g_row\[0\].g_col\[0\].pe__2513_/A1 g_row\[0\].g_col\[0\].pe__2406_/Y
+ g_row\[0\].g_col\[0\].pe__2512_/X VGND VGND VPWR VPWR g_row\[0\].g_col\[0\].pe__2513_/Y
+ sky130_fd_sc_hd__a21oi_2
Xg_row\[1\].g_col\[0\].pe__2297_ g_row\[1\].g_col\[0\].pe__2297_/A g_row\[1\].g_col\[0\].pe__2330_/C
+ VGND VGND VPWR VPWR g_row\[1\].g_col\[0\].pe__2305_/A sky130_fd_sc_hd__xor2_2
XFILLER_17_390 VGND VGND VPWR VPWR sky130_fd_sc_hd__fill_2
XFILLER_52_658 VGND VGND VPWR VPWR sky130_fd_sc_hd__decap_3
Xg_row\[0\].g_col\[1\].pe__2460_ g_row\[0\].g_col\[1\].pe__2740_/Q g_row\[0\].g_col\[1\].pe__2460_/B
+ VGND VGND VPWR VPWR g_row\[0\].g_col\[1\].pe__2462_/B sky130_fd_sc_hd__xnor2_2
XTAP_TAPCELL_ROW_82_1442 VGND VPWR sky130_fd_sc_hd__tapvpwrvgnd_1
Xg_row\[0\].g_col\[0\].pe__2444_ g_row\[0\].g_col\[0\].pe__2444_/A g_row\[0\].g_col\[0\].pe__2444_/B
+ VGND VGND VPWR VPWR g_row\[0\].g_col\[0\].pe__2551_/A sky130_fd_sc_hd__nor2_2
Xg_row\[0\].g_col\[1\].pe__1411_ g_row\[0\].g_col\[1\].pe__2045_/B VGND VGND VPWR
+ VPWR g_row\[0\].g_col\[1\].pe__1808_/A sky130_fd_sc_hd__inv_4
XTAP_TAPCELL_ROW_22_539 VGND VPWR sky130_fd_sc_hd__tapvpwrvgnd_1
Xg_row\[0\].g_col\[0\].pe__2375_ g_row\[0\].g_col\[0\].pe__2375_/A g_row\[0\].g_col\[0\].pe__2375_/B
+ VGND VGND VPWR VPWR g_row\[0\].g_col\[0\].pe__2377_/B sky130_fd_sc_hd__xor2_2
Xg_row\[0\].g_col\[1\].pe__2391_ g_row\[0\].g_col\[1\].pe__2391_/A g_row\[0\].g_col\[1\].pe__2391_/B
+ VGND VGND VPWR VPWR g_row\[0\].g_col\[1\].pe__2392_/B sky130_fd_sc_hd__xor2_2
Xg_row\[0\].g_col\[1\].pe__1342_ g_row\[0\].g_col\[1\].pe__2757_/Q g_row\[0\].g_col\[1\].pe__1342_/B
+ VGND VGND VPWR VPWR output1363/A sky130_fd_sc_hd__xnor2_2
XFILLER_59_213 VGND VGND VPWR VPWR sky130_fd_sc_hd__fill_2
Xg_row\[1\].g_col\[1\].pe__2718_ clkbuf_leaf_81_clk/X g_row\[1\].g_col\[1\].pe__2718_/D
+ VGND VGND VPWR VPWR g_row\[1\].g_col\[1\].pe__2718_/Q sky130_fd_sc_hd__dfxtp_2
XFILLER_59_279 VGND VGND VPWR VPWR sky130_fd_sc_hd__fill_1
Xg_row\[1\].g_col\[1\].pe__2649_ place1239/X g_row\[1\].g_col\[1\].pe__2649_/B VGND
+ VGND VPWR VPWR g_row\[1\].g_col\[1\].pe__2649_/X sky130_fd_sc_hd__or2_2
XTAP_TAPCELL_ROW_2_242 VGND VPWR sky130_fd_sc_hd__tapvpwrvgnd_1
Xg_row\[0\].g_col\[1\].pe_hold2244 g_row\[0\].g_col\[1\].pe_hold2244/A VGND VGND VPWR
+ VPWR g_row\[0\].g_col\[1\].pe__1392_/A sky130_fd_sc_hd__clkbuf_2
Xg_row\[0\].g_col\[1\].pe__2727_ clkbuf_leaf_94_clk/X g_row\[0\].g_col\[1\].pe__2727_/D
+ VGND VGND VPWR VPWR g_row\[0\].g_col\[1\].pe__2727_/Q sky130_fd_sc_hd__dfxtp_2
Xg_row\[0\].g_col\[1\].pe__2658_ g_row\[0\].g_col\[1\].pe__2670_/A1 g_row\[0\].g_col\[1\].pe__2658_/A2
+ g_row\[0\].g_col\[1\].pe__2670_/B1 g_row\[0\].g_col\[1\].pe__2657_/X VGND VGND VPWR
+ VPWR g_row\[0\].g_col\[1\].pe__2658_/X sky130_fd_sc_hd__o211a_2
XTAP_TAPCELL_ROW_41_826 VGND VPWR sky130_fd_sc_hd__tapvpwrvgnd_1
X_211_ _219_/A _211_/B_N VGND VGND VPWR VPWR _211_/Y sky130_fd_sc_hd__nor2b_4
Xg_row\[0\].g_col\[1\].pe__1609_ g_row\[0\].g_col\[1\].pe__1862_/A g_row\[0\].g_col\[1\].pe__1609_/B
+ VGND VGND VPWR VPWR g_row\[0\].g_col\[1\].pe__1851_/A sky130_fd_sc_hd__xor2_2
XFILLER_50_190 VGND VGND VPWR VPWR sky130_fd_sc_hd__decap_3
XFILLER_7_559 VGND VGND VPWR VPWR sky130_fd_sc_hd__fill_1
Xg_row\[0\].g_col\[0\].pe_place973 g_row\[0\].g_col\[0\].pe__2554_/A2 VGND VGND VPWR
+ VPWR g_row\[0\].g_col\[0\].pe__2591_/A2 sky130_fd_sc_hd__buf_6
Xg_row\[0\].g_col\[0\].pe_place984 g_row\[0\].g_col\[0\].pe__2026_/B VGND VGND VPWR
+ VPWR g_row\[0\].g_col\[0\].pe__1748_/B sky130_fd_sc_hd__buf_6
Xg_row\[0\].g_col\[0\].pe_place995 g_row\[0\].g_col\[0\].pe__2670_/A1 VGND VGND VPWR
+ VPWR g_row\[0\].g_col\[0\].pe__2656_/A1 sky130_fd_sc_hd__buf_6
XTAP_TAPCELL_ROW_53_1010 VGND VPWR sky130_fd_sc_hd__tapvpwrvgnd_1
Xg_row\[1\].g_col\[0\].pe_hold2818 g_row\[1\].g_col\[0\].pe__2646_/X VGND VGND VPWR
+ VPWR g_row\[1\].g_col\[0\].pe_hold2818/X sky130_fd_sc_hd__clkbuf_2
XFILLER_76_40 VGND VGND VPWR VPWR sky130_fd_sc_hd__decap_3
XFILLER_18_8 VGND VGND VPWR VPWR sky130_fd_sc_hd__fill_1
XTAP_TAPCELL_ROW_49_948 VGND VPWR sky130_fd_sc_hd__tapvpwrvgnd_1
Xg_row\[1\].g_col\[0\].pe__2220_ g_row\[1\].g_col\[0\].pe__2220_/A g_row\[1\].g_col\[0\].pe__2220_/B
+ VGND VGND VPWR VPWR g_row\[1\].g_col\[0\].pe__2221_/B sky130_fd_sc_hd__xor2_2
XFILLER_18_110 VGND VGND VPWR VPWR sky130_fd_sc_hd__decap_3
XTAP_TAPCELL_ROW_29_650 VGND VPWR sky130_fd_sc_hd__tapvpwrvgnd_1
Xg_row\[1\].g_col\[0\].pe__2151_ g_row\[1\].g_col\[0\].pe__2151_/A g_row\[1\].g_col\[0\].pe__2151_/B
+ g_row\[1\].g_col\[0\].pe__2150_/X VGND VGND VPWR VPWR g_row\[1\].g_col\[0\].pe__2151_/X
+ sky130_fd_sc_hd__or3b_4
XFILLER_61_433 VGND VGND VPWR VPWR sky130_fd_sc_hd__fill_1
Xg_row\[1\].g_col\[0\].pe__2082_ g_row\[1\].g_col\[0\].pe__2081_/B g_row\[1\].g_col\[0\].pe__2081_/C
+ g_row\[1\].g_col\[0\].pe__1460_/B VGND VGND VPWR VPWR g_row\[1\].g_col\[0\].pe__2087_/B
+ sky130_fd_sc_hd__a21bo_2
XTAP_TAPCELL_ROW_64_1172 VGND VPWR sky130_fd_sc_hd__tapvpwrvgnd_1
Xg_row\[0\].g_col\[0\].pe__2160_ g_row\[0\].g_col\[0\].pe__2160_/A VGND VGND VPWR
+ VPWR g_row\[0\].g_col\[0\].pe__2439_/A sky130_fd_sc_hd__inv_2
Xg_row\[0\].g_col\[0\].pe__2091_ g_row\[0\].g_col\[0\].pe__2091_/A g_row\[0\].g_col\[0\].pe__2091_/B
+ g_row\[0\].g_col\[0\].pe__2091_/C VGND VGND VPWR VPWR g_row\[0\].g_col\[0\].pe__2097_/B
+ sky130_fd_sc_hd__and3_4
Xg_row\[1\].g_col\[1\].pe__1951_ g_row\[1\].g_col\[1\].pe__1951_/A g_row\[1\].g_col\[1\].pe__1951_/B
+ VGND VGND VPWR VPWR g_row\[1\].g_col\[1\].pe__2009_/C sky130_fd_sc_hd__and2_2
Xg_row\[1\].g_col\[0\].pe__1935_ g_row\[1\].g_col\[0\].pe__1935_/A g_row\[1\].g_col\[0\].pe__1935_/B
+ VGND VGND VPWR VPWR g_row\[1\].g_col\[0\].pe__1938_/A sky130_fd_sc_hd__xnor2_2
XFILLER_6_570 VGND VGND VPWR VPWR sky130_fd_sc_hd__decap_3
Xg_row\[1\].g_col\[1\].pe__1882_ g_row\[1\].g_col\[1\].pe__1882_/A g_row\[1\].g_col\[1\].pe__1882_/B
+ VGND VGND VPWR VPWR g_row\[1\].g_col\[1\].pe__1885_/A sky130_fd_sc_hd__xor2_2
XFILLER_6_592 VGND VGND VPWR VPWR sky130_fd_sc_hd__decap_3
Xg_row\[1\].g_col\[0\].pe__1866_ place1094/X g_row\[1\].g_col\[0\].pe__1657_/B g_row\[1\].g_col\[0\].pe__2036_/B1
+ g_row\[1\].g_col\[0\].pe__2612_/B VGND VGND VPWR VPWR g_row\[1\].g_col\[0\].pe__1867_/B
+ sky130_fd_sc_hd__a22o_2
Xhold3118 hold3118/A VGND VGND VPWR VPWR hold3118/X sky130_fd_sc_hd__clkbuf_2
Xhold3129 hold3129/A VGND VGND VPWR VPWR hold3129/X sky130_fd_sc_hd__clkbuf_2
Xg_row\[1\].g_col\[0\].pe__1797_ g_row\[1\].g_col\[0\].pe__1797_/A g_row\[1\].g_col\[0\].pe__1797_/B
+ VGND VGND VPWR VPWR g_row\[1\].g_col\[0\].pe__1807_/A sky130_fd_sc_hd__and2_4
Xhold2417 hold3143/X VGND VGND VPWR VPWR _137_/B_N sky130_fd_sc_hd__clkbuf_2
Xhold2428 hold3176/X VGND VGND VPWR VPWR hold3177/A sky130_fd_sc_hd__clkbuf_2
Xg_row\[0\].g_col\[0\].pe__1944_ g_row\[0\].g_col\[0\].pe__1894_/Y g_row\[0\].g_col\[0\].pe__1895_/X
+ g_row\[0\].g_col\[0\].pe__2151_/A g_row\[0\].g_col\[0\].pe__2394_/B1 VGND VGND VPWR
+ VPWR g_row\[0\].g_col\[0\].pe__1944_/Y sky130_fd_sc_hd__a31oi_2
Xhold2439 hold3181/X VGND VGND VPWR VPWR hold3182/A sky130_fd_sc_hd__clkbuf_2
Xg_row\[1\].g_col\[1\].pe__2503_ g_row\[1\].g_col\[1\].pe__2579_/A g_row\[1\].g_col\[1\].pe__2503_/B
+ g_row\[1\].g_col\[1\].pe__2585_/B g_row\[1\].g_col\[1\].pe__2502_/X VGND VGND VPWR
+ VPWR g_row\[1\].g_col\[1\].pe__2506_/C sky130_fd_sc_hd__or4b_2
Xg_row\[0\].g_col\[1\].pe__1960_ g_row\[0\].g_col\[1\].pe__1961_/A g_row\[0\].g_col\[1\].pe__1961_/B
+ VGND VGND VPWR VPWR g_row\[0\].g_col\[1\].pe__2024_/A sky130_fd_sc_hd__nand2_2
Xg_row\[0\].g_col\[0\].pe__1875_ g_row\[0\].g_col\[0\].pe__1875_/A g_row\[0\].g_col\[0\].pe__1875_/B
+ g_row\[0\].g_col\[0\].pe__1875_/C VGND VGND VPWR VPWR g_row\[0\].g_col\[0\].pe__1875_/X
+ sky130_fd_sc_hd__and3_2
Xg_row\[1\].g_col\[1\].pe__2434_ g_row\[1\].g_col\[1\].pe__2748_/Q g_row\[1\].g_col\[1\].pe__2434_/B
+ VGND VGND VPWR VPWR g_row\[1\].g_col\[1\].pe__2472_/B sky130_fd_sc_hd__xnor2_2
Xg_row\[1\].g_col\[0\].pe__2418_ g_row\[1\].g_col\[0\].pe__2421_/A1 g_row\[1\].g_col\[0\].pe__2749_/Q
+ g_row\[1\].g_col\[0\].pe__2432_/B VGND VGND VPWR VPWR g_row\[1\].g_col\[0\].pe__2430_/B
+ sky130_fd_sc_hd__a21o_2
Xg_row\[0\].g_col\[1\].pe__1891_ g_row\[0\].g_col\[1\].pe__1891_/A g_row\[0\].g_col\[1\].pe__1891_/B
+ VGND VGND VPWR VPWR g_row\[0\].g_col\[1\].pe__1891_/Y sky130_fd_sc_hd__xnor2_2
XFILLER_65_750 VGND VGND VPWR VPWR sky130_fd_sc_hd__fill_1
Xg_row\[1\].g_col\[1\].pe__2365_ g_row\[1\].g_col\[1\].pe__2365_/A g_row\[1\].g_col\[1\].pe__2365_/B
+ VGND VGND VPWR VPWR g_row\[1\].g_col\[1\].pe__2365_/X sky130_fd_sc_hd__and2_2
XTAP_TAPCELL_ROW_27_609 VGND VPWR sky130_fd_sc_hd__tapvpwrvgnd_1
Xg_row\[1\].g_col\[0\].pe__2349_ g_row\[1\].g_col\[0\].pe__2368_/B g_row\[1\].g_col\[0\].pe__2349_/B
+ VGND VGND VPWR VPWR g_row\[1\].g_col\[0\].pe__2350_/B sky130_fd_sc_hd__xor2_2
XFILLER_24_113 VGND VGND VPWR VPWR sky130_fd_sc_hd__fill_2
XFILLER_52_444 VGND VGND VPWR VPWR sky130_fd_sc_hd__fill_2
Xg_row\[1\].g_col\[1\].pe__2296_ g_row\[1\].g_col\[1\].pe__2329_/A g_row\[1\].g_col\[1\].pe__2296_/B
+ VGND VGND VPWR VPWR g_row\[1\].g_col\[1\].pe__2330_/C sky130_fd_sc_hd__nand2_2
Xg_row\[0\].g_col\[1\].pe__2512_ g_row\[0\].g_col\[1\].pe__2519_/A g_row\[0\].g_col\[1\].pe__2499_/A
+ g_row\[0\].g_col\[1\].pe__2559_/A g_row\[0\].g_col\[1\].pe__2157_/A g_row\[0\].g_col\[1\].pe__2403_/A
+ VGND VGND VPWR VPWR g_row\[0\].g_col\[1\].pe__2512_/X sky130_fd_sc_hd__o311a_2
XFILLER_52_477 VGND VGND VPWR VPWR sky130_fd_sc_hd__decap_3
Xg_row\[0\].g_col\[0\].pe__2427_ g_row\[0\].g_col\[0\].pe__2769_/Q g_row\[0\].g_col\[0\].pe__2427_/B
+ VGND VGND VPWR VPWR g_row\[0\].g_col\[0\].pe__2494_/A sky130_fd_sc_hd__and2b_2
Xg_row\[0\].g_col\[1\].pe__2443_ g_row\[0\].g_col\[1\].pe__2762_/Q g_row\[0\].g_col\[1\].pe__2443_/B
+ VGND VGND VPWR VPWR g_row\[0\].g_col\[1\].pe__2444_/B sky130_fd_sc_hd__and2b_2
XANTENNA_20 b_inputs_flat[20] VGND VGND VPWR VPWR sky130_fd_sc_hd__diode_2
XANTENNA_31 enable VGND VGND VPWR VPWR sky130_fd_sc_hd__diode_2
Xg_row\[0\].g_col\[1\].pe__2374_ g_row\[0\].g_col\[1\].pe__2385_/A g_row\[0\].g_col\[1\].pe__2385_/B
+ VGND VGND VPWR VPWR g_row\[0\].g_col\[1\].pe__2375_/B sky130_fd_sc_hd__xor2_2
XANTENNA_42 ANTENNA_42/DIODE VGND VGND VPWR VPWR sky130_fd_sc_hd__diode_2
XANTENNA_53 hold3409/A VGND VGND VPWR VPWR sky130_fd_sc_hd__diode_2
XANTENNA_64 hold3257/A VGND VGND VPWR VPWR sky130_fd_sc_hd__diode_2
XANTENNA_75 hold3207/X VGND VGND VPWR VPWR sky130_fd_sc_hd__diode_2
Xg_row\[0\].g_col\[0\].pe__2358_ g_row\[0\].g_col\[0\].pe__2358_/A g_row\[0\].g_col\[0\].pe__2358_/B
+ VGND VGND VPWR VPWR g_row\[0\].g_col\[0\].pe__2359_/B sky130_fd_sc_hd__nand2_2
XANTENNA_86 hold3270/X VGND VGND VPWR VPWR sky130_fd_sc_hd__diode_2
XANTENNA_97 hold3478/X VGND VGND VPWR VPWR sky130_fd_sc_hd__diode_2
Xg_row\[0\].g_col\[0\].pe__2289_ g_row\[0\].g_col\[0\].pe__2246_/A g_row\[0\].g_col\[0\].pe__2246_/B
+ g_row\[0\].g_col\[0\].pe__2288_/Y VGND VGND VPWR VPWR g_row\[0\].g_col\[0\].pe__2291_/B
+ sky130_fd_sc_hd__o21ai_2
XTAP_TAPCELL_ROW_7_312 VGND VPWR sky130_fd_sc_hd__tapvpwrvgnd_1
XFILLER_0_757 VGND VGND VPWR VPWR sky130_fd_sc_hd__decap_3
XFILLER_0_779 VGND VGND VPWR VPWR sky130_fd_sc_hd__decap_3
XFILLER_75_503 VGND VGND VPWR VPWR sky130_fd_sc_hd__fill_1
Xhold2984 hold2984/A VGND VGND VPWR VPWR hold2984/X sky130_fd_sc_hd__clkbuf_2
XFILLER_28_441 VGND VGND VPWR VPWR sky130_fd_sc_hd__fill_1
XFILLER_63_709 VGND VGND VPWR VPWR sky130_fd_sc_hd__decap_3
XFILLER_75_558 VGND VGND VPWR VPWR sky130_fd_sc_hd__fill_2
XTAP_TAPCELL_ROW_46_907 VGND VPWR sky130_fd_sc_hd__tapvpwrvgnd_1
XFILLER_28_452 VGND VGND VPWR VPWR sky130_fd_sc_hd__decap_3
XFILLER_28_474 VGND VGND VPWR VPWR sky130_fd_sc_hd__fill_2
Xg_row\[0\].g_col\[1\].pe_hold2041 g_row\[0\].g_col\[1\].pe__2528_/X VGND VGND VPWR
+ VPWR g_row\[0\].g_col\[1\].pe__2529_/B sky130_fd_sc_hd__clkbuf_2
Xg_row\[0\].g_col\[1\].pe_hold2030 g_row\[0\].g_col\[1\].pe__2576_/X VGND VGND VPWR
+ VPWR g_row\[0\].g_col\[1\].pe__2577_/B sky130_fd_sc_hd__clkbuf_2
XFILLER_15_113 VGND VGND VPWR VPWR sky130_fd_sc_hd__decap_3
XFILLER_28_496 VGND VGND VPWR VPWR sky130_fd_sc_hd__decap_3
XFILLER_46_98 VGND VGND VPWR VPWR sky130_fd_sc_hd__decap_3
XFILLER_31_606 VGND VGND VPWR VPWR sky130_fd_sc_hd__decap_3
XFILLER_31_617 VGND VGND VPWR VPWR sky130_fd_sc_hd__decap_3
XFILLER_43_488 VGND VGND VPWR VPWR sky130_fd_sc_hd__decap_3
XFILLER_23_190 VGND VGND VPWR VPWR sky130_fd_sc_hd__decap_3
XFILLER_30_138 VGND VGND VPWR VPWR sky130_fd_sc_hd__fill_2
XFILLER_8_813 VGND VGND VPWR VPWR sky130_fd_sc_hd__fill_2
XFILLER_7_26 VGND VGND VPWR VPWR sky130_fd_sc_hd__fill_2
XFILLER_8_835 VGND VGND VPWR VPWR sky130_fd_sc_hd__fill_1
XFILLER_7_389 VGND VGND VPWR VPWR sky130_fd_sc_hd__decap_3
Xg_row\[1\].g_col\[0\].pe__1720_ g_row\[1\].g_col\[0\].pe__1742_/B g_row\[1\].g_col\[0\].pe__1743_/B
+ g_row\[1\].g_col\[0\].pe__1719_/Y VGND VGND VPWR VPWR g_row\[1\].g_col\[0\].pe__1723_/A
+ sky130_fd_sc_hd__a21o_2
XFILLER_3_551 VGND VGND VPWR VPWR sky130_fd_sc_hd__fill_2
Xg_row\[1\].g_col\[0\].pe__1651_ g_row\[1\].g_col\[0\].pe__1660_/A g_row\[1\].g_col\[0\].pe__1660_/B
+ VGND VGND VPWR VPWR g_row\[1\].g_col\[0\].pe__1693_/A sky130_fd_sc_hd__xor2_2
Xg_row\[1\].g_col\[0\].pe__1582_ g_row\[1\].g_col\[0\].pe__1630_/B g_row\[1\].g_col\[0\].pe__1582_/B
+ VGND VGND VPWR VPWR g_row\[1\].g_col\[0\].pe__1583_/B sky130_fd_sc_hd__xnor2_2
XFILLER_66_536 VGND VGND VPWR VPWR sky130_fd_sc_hd__fill_1
Xg_row\[1\].g_col\[0\].pe_hold1936 g_row\[1\].g_col\[0\].pe__2741_/Q VGND VGND VPWR
+ VPWR g_row\[1\].g_col\[0\].pe__1946_/A sky130_fd_sc_hd__clkbuf_2
Xg_row\[1\].g_col\[0\].pe_hold1925 g_row\[1\].g_col\[0\].pe__1892_/X VGND VGND VPWR
+ VPWR g_row\[1\].g_col\[0\].pe__1893_/B sky130_fd_sc_hd__clkbuf_2
Xg_row\[1\].g_col\[0\].pe_hold1914 g_row\[1\].g_col\[0\].pe__2198_/X VGND VGND VPWR
+ VPWR g_row\[1\].g_col\[0\].pe__2199_/B sky130_fd_sc_hd__clkbuf_2
XFILLER_66_569 VGND VGND VPWR VPWR sky130_fd_sc_hd__fill_1
XFILLER_19_463 VGND VGND VPWR VPWR sky130_fd_sc_hd__fill_1
XFILLER_53_219 VGND VGND VPWR VPWR sky130_fd_sc_hd__decap_3
XTAP_TAPCELL_ROW_66_1201 VGND VPWR sky130_fd_sc_hd__tapvpwrvgnd_1
Xg_row\[0\].g_col\[0\].pe__1660_ g_row\[0\].g_col\[0\].pe__1660_/A g_row\[0\].g_col\[0\].pe__1660_/B
+ VGND VGND VPWR VPWR g_row\[0\].g_col\[0\].pe__1660_/Y sky130_fd_sc_hd__nor2_2
Xg_row\[1\].g_col\[0\].pe__2203_ g_row\[1\].g_col\[0\].pe__2186_/B g_row\[1\].g_col\[0\].pe__2203_/B
+ VGND VGND VPWR VPWR g_row\[1\].g_col\[0\].pe__2228_/A sky130_fd_sc_hd__and2b_2
Xg_row\[0\].g_col\[0\].pe__1591_ g_row\[0\].g_col\[0\].pe__1591_/A g_row\[0\].g_col\[0\].pe__1591_/B
+ VGND VGND VPWR VPWR g_row\[0\].g_col\[0\].pe__1830_/C sky130_fd_sc_hd__xnor2_2
Xg_row\[1\].g_col\[1\].pe__2150_ g_row\[1\].g_col\[1\].pe__2111_/A g_row\[1\].g_col\[1\].pe__2153_/C
+ g_row\[1\].g_col\[1\].pe__2150_/C VGND VGND VPWR VPWR g_row\[1\].g_col\[1\].pe__2150_/X
+ sky130_fd_sc_hd__and3b_2
Xg_row\[1\].g_col\[0\].pe__2134_ g_row\[1\].g_col\[0\].pe__2222_/A g_row\[1\].g_col\[0\].pe__2184_/B
+ g_row\[1\].g_col\[0\].pe__2184_/C VGND VGND VPWR VPWR g_row\[1\].g_col\[0\].pe__2135_/B
+ sky130_fd_sc_hd__nand3b_2
XFILLER_22_606 VGND VGND VPWR VPWR sky130_fd_sc_hd__decap_3
XFILLER_34_477 VGND VGND VPWR VPWR sky130_fd_sc_hd__decap_3
XFILLER_61_230 VGND VGND VPWR VPWR sky130_fd_sc_hd__fill_2
Xg_row\[1\].g_col\[1\].pe__2081_ g_row\[1\].g_col\[1\].pe__2126_/B2 g_row\[1\].g_col\[1\].pe__2081_/B
+ g_row\[1\].g_col\[1\].pe__2081_/C VGND VGND VPWR VPWR g_row\[1\].g_col\[1\].pe__2087_/A
+ sky130_fd_sc_hd__nand3b_2
Xg_row\[1\].g_col\[0\].pe__2065_ g_row\[1\].g_col\[0\].pe__2065_/A VGND VGND VPWR
+ VPWR g_row\[1\].g_col\[0\].pe__2445_/A sky130_fd_sc_hd__inv_2
XFILLER_14_190 VGND VGND VPWR VPWR sky130_fd_sc_hd__fill_2
Xg_row\[0\].g_col\[0\].pe__2212_ g_row\[0\].g_col\[0\].pe__2253_/A g_row\[0\].g_col\[0\].pe__2253_/B
+ VGND VGND VPWR VPWR g_row\[0\].g_col\[0\].pe__2221_/A sky130_fd_sc_hd__xnor2_2
XFILLER_30_661 VGND VGND VPWR VPWR sky130_fd_sc_hd__fill_2
XTAP_TAPCELL_ROW_32_689 VGND VPWR sky130_fd_sc_hd__tapvpwrvgnd_1
XFILLER_30_694 VGND VGND VPWR VPWR sky130_fd_sc_hd__fill_1
Xg_row\[0\].g_col\[0\].pe__2143_ g_row\[0\].g_col\[0\].pe__2143_/A g_row\[0\].g_col\[0\].pe__2143_/B
+ VGND VGND VPWR VPWR g_row\[0\].g_col\[0\].pe__2144_/B sky130_fd_sc_hd__xnor2_2
XTAP_TAPCELL_ROW_12_391 VGND VPWR sky130_fd_sc_hd__tapvpwrvgnd_1
Xg_row\[0\].g_col\[0\].pe__2074_ g_row\[0\].g_col\[0\].pe__2215_/B2 g_row\[0\].g_col\[0\].pe__2279_/A2
+ g_row\[0\].g_col\[0\].pe__2279_/B1 place1208/A VGND VGND VPWR VPWR g_row\[0\].g_col\[0\].pe__2075_/B
+ sky130_fd_sc_hd__a22o_2
Xg_row\[1\].g_col\[1\].pe__1934_ g_row\[1\].g_col\[1\].pe__1999_/A g_row\[1\].g_col\[1\].pe__1999_/B
+ VGND VGND VPWR VPWR g_row\[1\].g_col\[1\].pe__1935_/B sky130_fd_sc_hd__xor2_2
Xg_row\[0\].g_col\[1\].pe__2090_ g_row\[0\].g_col\[1\].pe__2209_/A g_row\[0\].g_col\[1\].pe__2090_/B
+ VGND VGND VPWR VPWR g_row\[0\].g_col\[1\].pe__2091_/C sky130_fd_sc_hd__xnor2_2
XTAP_TAPCELL_ROW_77_1363 VGND VPWR sky130_fd_sc_hd__tapvpwrvgnd_1
Xg_row\[1\].g_col\[0\].pe__1918_ g_row\[1\].g_col\[0\].pe__2726_/Q g_row\[1\].g_col\[0\].pe__2682_/A
+ VGND VGND VPWR VPWR g_row\[1\].g_col\[0\].pe__1919_/B sky130_fd_sc_hd__nand2_2
XFILLER_88_105 VGND VGND VPWR VPWR sky130_fd_sc_hd__decap_3
Xg_row\[1\].g_col\[1\].pe__1865_ g_row\[1\].g_col\[1\].pe__1899_/A g_row\[1\].g_col\[1\].pe__1899_/B
+ VGND VGND VPWR VPWR g_row\[1\].g_col\[1\].pe__1868_/A sky130_fd_sc_hd__xor2_2
Xg_row\[1\].g_col\[0\].pe__1849_ g_row\[1\].g_col\[0\].pe__1607_/A g_row\[1\].g_col\[0\].pe__1849_/B
+ VGND VGND VPWR VPWR g_row\[1\].g_col\[0\].pe__1850_/B sky130_fd_sc_hd__and2b_2
Xg_row\[1\].g_col\[1\].pe__1796_ g_row\[1\].g_col\[1\].pe__1796_/A g_row\[1\].g_col\[1\].pe__1796_/B
+ VGND VGND VPWR VPWR g_row\[1\].g_col\[1\].pe__1797_/B sky130_fd_sc_hd__or2_2
XFILLER_57_503 VGND VGND VPWR VPWR sky130_fd_sc_hd__fill_1
XFILLER_85_801 VGND VGND VPWR VPWR sky130_fd_sc_hd__fill_1
XTAP_TAPCELL_ROW_90_1563 VGND VPWR sky130_fd_sc_hd__tapvpwrvgnd_1
XFILLER_57_525 VGND VGND VPWR VPWR sky130_fd_sc_hd__decap_3
Xg_row\[0\].g_col\[0\].pe__1927_ g_row\[0\].g_col\[0\].pe__1980_/A g_row\[0\].g_col\[0\].pe__1927_/B
+ VGND VGND VPWR VPWR g_row\[0\].g_col\[0\].pe__1994_/A sky130_fd_sc_hd__xnor2_2
Xhold1502 hold3331/X VGND VGND VPWR VPWR hold3332/A sky130_fd_sc_hd__clkbuf_2
Xhold1513 hold3355/X VGND VGND VPWR VPWR hold3356/A sky130_fd_sc_hd__clkbuf_2
Xhold1524 hold2616/X VGND VGND VPWR VPWR hold2617/A sky130_fd_sc_hd__clkbuf_2
Xhold1535 hold3380/X VGND VGND VPWR VPWR hold3381/A sky130_fd_sc_hd__clkbuf_2
Xg_row\[0\].g_col\[1\].pe__1943_ g_row\[0\].g_col\[1\].pe__1951_/A g_row\[0\].g_col\[1\].pe__1951_/B
+ VGND VGND VPWR VPWR g_row\[0\].g_col\[1\].pe__2151_/A sky130_fd_sc_hd__xnor2_2
XFILLER_57_547 VGND VGND VPWR VPWR sky130_fd_sc_hd__decap_3
Xhold1546 hold3446/X VGND VGND VPWR VPWR hold3447/A sky130_fd_sc_hd__clkbuf_2
Xhold1557 hold2652/X VGND VGND VPWR VPWR hold2653/A sky130_fd_sc_hd__clkbuf_2
Xhold1568 hold3387/X VGND VGND VPWR VPWR hold3388/A sky130_fd_sc_hd__clkbuf_2
Xg_row\[0\].g_col\[0\].pe__1858_ g_row\[0\].g_col\[0\].pe__1908_/A g_row\[0\].g_col\[0\].pe__1858_/B
+ VGND VGND VPWR VPWR g_row\[0\].g_col\[0\].pe__1859_/B sky130_fd_sc_hd__and2_2
Xhold1579 hold3530/X VGND VGND VPWR VPWR hold3531/A sky130_fd_sc_hd__clkbuf_2
Xg_row\[1\].g_col\[1\].pe__2417_ g_row\[1\].g_col\[1\].pe__2754_/Q g_row\[1\].g_col\[1\].pe__2266_/Y
+ g_row\[1\].g_col\[1\].pe__2434_/B VGND VGND VPWR VPWR g_row\[1\].g_col\[1\].pe__2432_/B
+ sky130_fd_sc_hd__o21ai_2
Xg_row\[0\].g_col\[1\].pe__1874_ g_row\[0\].g_col\[1\].pe__1874_/A g_row\[0\].g_col\[1\].pe__1874_/B
+ VGND VGND VPWR VPWR g_row\[0\].g_col\[1\].pe__1932_/B sky130_fd_sc_hd__xor2_2
Xg_row\[0\].g_col\[0\].pe__1789_ g_row\[0\].g_col\[0\].pe__1789_/A g_row\[0\].g_col\[0\].pe__1789_/B
+ VGND VGND VPWR VPWR g_row\[0\].g_col\[0\].pe__1790_/B sky130_fd_sc_hd__or2_2
Xg_row\[1\].g_col\[1\].pe__2348_ g_row\[1\].g_col\[1\].pe__2348_/A g_row\[1\].g_col\[1\].pe__2348_/B
+ VGND VGND VPWR VPWR g_row\[1\].g_col\[1\].pe__2349_/B sky130_fd_sc_hd__nand2_2
Xg_row\[1\].g_col\[0\].pe_place929 g_row\[1\].g_col\[0\].pe__2626_/A1 VGND VGND VPWR
+ VPWR g_row\[1\].g_col\[0\].pe__2640_/A1 sky130_fd_sc_hd__buf_6
Xg_row\[1\].g_col\[0\].pe_place918 g_row\[1\].g_col\[0\].pe__1453_/Y VGND VGND VPWR
+ VPWR g_row\[1\].g_col\[0\].pe__2165_/A sky130_fd_sc_hd__buf_6
Xg_row\[1\].g_col\[0\].pe_place907 g_row\[1\].g_col\[0\].pe__2388_/B VGND VGND VPWR
+ VPWR g_row\[1\].g_col\[0\].pe__2177_/B1 sky130_fd_sc_hd__buf_6
XFILLER_13_617 VGND VGND VPWR VPWR sky130_fd_sc_hd__fill_1
XFILLER_52_230 VGND VGND VPWR VPWR sky130_fd_sc_hd__decap_3
XFILLER_80_594 VGND VGND VPWR VPWR sky130_fd_sc_hd__fill_2
Xg_row\[1\].g_col\[1\].pe__2279_ g_row\[1\].g_col\[1\].pe__2121_/A g_row\[1\].g_col\[1\].pe__2313_/A2
+ g_row\[1\].g_col\[1\].pe__2313_/B1 g_row\[1\].g_col\[1\].pe__2340_/B2 VGND VGND
+ VPWR VPWR g_row\[1\].g_col\[1\].pe__2280_/B sky130_fd_sc_hd__a22o_2
Xg_row\[1\].g_col\[0\].pe_place1062 g_row\[1\].g_col\[0\].pe_hold3079/X VGND VGND
+ VPWR VPWR g_row\[1\].g_col\[0\].pe__2250_/A sky130_fd_sc_hd__buf_6
XFILLER_12_138 VGND VGND VPWR VPWR sky130_fd_sc_hd__fill_2
Xg_row\[1\].g_col\[0\].pe_place1095 hold1950/A VGND VGND VPWR VPWR g_row\[1\].g_col\[0\].pe__2612_/B
+ sky130_fd_sc_hd__buf_6
Xg_row\[1\].g_col\[0\].pe_place1073 g_row\[1\].g_col\[0\].pe__2726_/Q VGND VGND VPWR
+ VPWR g_row\[1\].g_col\[0\].pe__1785_/A sky130_fd_sc_hd__buf_6
Xg_row\[0\].g_col\[1\].pe__2426_ g_row\[0\].g_col\[1\].pe__2752_/Q g_row\[0\].g_col\[1\].pe__2426_/B
+ VGND VGND VPWR VPWR g_row\[0\].g_col\[1\].pe__2427_/B sky130_fd_sc_hd__xor2_2
XFILLER_21_683 VGND VGND VPWR VPWR sky130_fd_sc_hd__decap_3
XTAP_TAPCELL_ROW_51_976 VGND VPWR sky130_fd_sc_hd__tapvpwrvgnd_1
Xg_row\[0\].g_col\[1\].pe__2357_ g_row\[0\].g_col\[1\].pe__2329_/A g_row\[0\].g_col\[1\].pe__2330_/X
+ g_row\[0\].g_col\[1\].pe__2329_/B VGND VGND VPWR VPWR g_row\[0\].g_col\[1\].pe__2358_/B
+ sky130_fd_sc_hd__a21o_2
Xg_row\[0\].g_col\[1\].pe__2288_ g_row\[0\].g_col\[1\].pe__2288_/A g_row\[0\].g_col\[1\].pe__2288_/B
+ VGND VGND VPWR VPWR g_row\[0\].g_col\[1\].pe__2288_/Y sky130_fd_sc_hd__nand2_2
Xhold3460 hold3460/A VGND VGND VPWR VPWR hold3460/X sky130_fd_sc_hd__clkbuf_2
XFILLER_48_536 VGND VGND VPWR VPWR sky130_fd_sc_hd__decap_3
XFILLER_57_53 VGND VGND VPWR VPWR sky130_fd_sc_hd__decap_3
Xhold3493 hold3493/A VGND VGND VPWR VPWR hold3493/X sky130_fd_sc_hd__clkbuf_2
Xhold3482 hold3482/A VGND VGND VPWR VPWR hold3482/X sky130_fd_sc_hd__clkbuf_2
Xhold3471 hold3471/A VGND VGND VPWR VPWR hold3471/X sky130_fd_sc_hd__clkbuf_2
Xhold2770 hold3545/X VGND VGND VPWR VPWR hold3546/A sky130_fd_sc_hd__clkbuf_2
Xhold2781 hold3561/X VGND VGND VPWR VPWR hold3562/A sky130_fd_sc_hd__clkbuf_2
Xhold2792 hold3577/X VGND VGND VPWR VPWR hold3578/A sky130_fd_sc_hd__clkbuf_2
XFILLER_63_528 VGND VGND VPWR VPWR sky130_fd_sc_hd__decap_3
XFILLER_44_720 VGND VGND VPWR VPWR sky130_fd_sc_hd__fill_2
XFILLER_71_561 VGND VGND VPWR VPWR sky130_fd_sc_hd__decap_3
XFILLER_16_477 VGND VGND VPWR VPWR sky130_fd_sc_hd__fill_2
XFILLER_31_447 VGND VGND VPWR VPWR sky130_fd_sc_hd__fill_1
XTAP_TAPCELL_ROW_61_1120 VGND VPWR sky130_fd_sc_hd__tapvpwrvgnd_1
XTAP_TAPCELL_ROW_61_1131 VGND VPWR sky130_fd_sc_hd__tapvpwrvgnd_1
XFILLER_12_683 VGND VGND VPWR VPWR sky130_fd_sc_hd__fill_1
XFILLER_8_665 VGND VGND VPWR VPWR sky130_fd_sc_hd__decap_3
XFILLER_8_698 VGND VGND VPWR VPWR sky130_fd_sc_hd__fill_2
Xg_row\[1\].g_col\[0\].pe__2752_ clkbuf_leaf_54_clk/X g_row\[1\].g_col\[0\].pe__2752_/D
+ VGND VGND VPWR VPWR g_row\[1\].g_col\[0\].pe__2752_/Q sky130_fd_sc_hd__dfxtp_2
XTAP_TAPCELL_ROW_59_1093 VGND VPWR sky130_fd_sc_hd__tapvpwrvgnd_1
Xg_row\[1\].g_col\[0\].pe__2683_ hold2045/X g_row\[1\].g_col\[0\].pe__2680_/B g_row\[1\].g_col\[0\].pe__2682_/X
+ g_row\[1\].g_col\[0\].pe__2687_/C1 VGND VGND VPWR VPWR g_row\[1\].g_col\[0\].pe__2683_/X
+ sky130_fd_sc_hd__o211a_2
Xg_row\[1\].g_col\[0\].pe__1703_ g_row\[1\].g_col\[0\].pe__1703_/A g_row\[1\].g_col\[0\].pe__1703_/B
+ VGND VGND VPWR VPWR g_row\[1\].g_col\[0\].pe__1824_/B sky130_fd_sc_hd__xnor2_2
Xg_row\[1\].g_col\[1\].pe__1650_ g_row\[1\].g_col\[1\].pe__1650_/A g_row\[1\].g_col\[1\].pe__1650_/B
+ VGND VGND VPWR VPWR g_row\[1\].g_col\[1\].pe__1660_/B sky130_fd_sc_hd__xnor2_2
Xg_row\[1\].g_col\[0\].pe__1634_ g_row\[1\].g_col\[0\].pe__1634_/A g_row\[1\].g_col\[0\].pe__1634_/B
+ VGND VGND VPWR VPWR g_row\[1\].g_col\[0\].pe__1634_/X sky130_fd_sc_hd__or2_2
Xg_row\[1\].g_col\[1\].pe__1581_ g_row\[1\].g_col\[1\].pe__1523_/A g_row\[1\].g_col\[1\].pe__1523_/B
+ g_row\[1\].g_col\[1\].pe__1580_/X VGND VGND VPWR VPWR g_row\[1\].g_col\[1\].pe__1582_/B
+ sky130_fd_sc_hd__a21oi_2
XFILLER_21_3 VGND VGND VPWR VPWR sky130_fd_sc_hd__decap_3
XFILLER_78_160 VGND VGND VPWR VPWR sky130_fd_sc_hd__fill_1
XTAP_TAPCELL_ROW_72_1293 VGND VPWR sky130_fd_sc_hd__tapvpwrvgnd_1
Xg_row\[1\].g_col\[0\].pe__1565_ g_row\[1\].g_col\[0\].pe__1910_/A g_row\[1\].g_col\[0\].pe__1565_/B
+ VGND VGND VPWR VPWR g_row\[1\].g_col\[0\].pe__1596_/A sky130_fd_sc_hd__xor2_2
Xg_row\[0\].g_col\[0\].pe__2761_ clkbuf_leaf_49_clk/X g_row\[0\].g_col\[0\].pe__2761_/D
+ VGND VGND VPWR VPWR g_row\[0\].g_col\[0\].pe__2761_/Q sky130_fd_sc_hd__dfxtp_2
Xg_row\[1\].g_col\[0\].pe_hold1744 g_row\[1\].g_col\[0\].pe__2769_/Q VGND VGND VPWR
+ VPWR g_row\[1\].g_col\[0\].pe__2587_/A1 sky130_fd_sc_hd__clkbuf_2
Xg_row\[1\].g_col\[0\].pe_hold1733 g_row\[1\].g_col\[0\].pe__2582_/X VGND VGND VPWR
+ VPWR g_row\[1\].g_col\[0\].pe__2768_/D sky130_fd_sc_hd__clkbuf_2
Xg_row\[1\].g_col\[0\].pe__1496_ g_row\[1\].g_col\[0\].pe__1536_/A g_row\[1\].g_col\[0\].pe__1536_/B
+ VGND VGND VPWR VPWR g_row\[1\].g_col\[0\].pe__1499_/A sky130_fd_sc_hd__xor2_2
XFILLER_54_517 VGND VGND VPWR VPWR sky130_fd_sc_hd__decap_3
Xg_row\[0\].g_col\[0\].pe__1712_ g_row\[0\].g_col\[0\].pe__1736_/A g_row\[0\].g_col\[0\].pe__1736_/B
+ VGND VGND VPWR VPWR g_row\[0\].g_col\[0\].pe__1714_/B sky130_fd_sc_hd__nand2_2
Xg_row\[0\].g_col\[0\].pe__2692_ clkbuf_leaf_14_clk/X g_row\[0\].g_col\[0\].pe__2692_/D
+ VGND VGND VPWR VPWR place1218/A sky130_fd_sc_hd__dfxtp_2
Xg_row\[1\].g_col\[0\].pe_hold1788 g_row\[1\].g_col\[0\].pe_hold2894/X VGND VGND VPWR
+ VPWR g_row\[1\].g_col\[0\].pe_hold2895/A sky130_fd_sc_hd__clkbuf_2
XFILLER_47_580 VGND VGND VPWR VPWR sky130_fd_sc_hd__decap_3
Xg_row\[0\].g_col\[0\].pe__1643_ place1209/X g_row\[0\].g_col\[0\].pe__1784_/A2 g_row\[0\].g_col\[0\].pe__1784_/A3
+ g_row\[0\].g_col\[0\].pe__1801_/B place1207/X VGND VGND VPWR VPWR g_row\[0\].g_col\[0\].pe__1644_/B
+ sky130_fd_sc_hd__a32o_2
Xg_row\[1\].g_col\[1\].pe__2202_ g_row\[1\].g_col\[1\].pe__2202_/A g_row\[1\].g_col\[1\].pe__2202_/B
+ VGND VGND VPWR VPWR g_row\[1\].g_col\[1\].pe__2238_/A sky130_fd_sc_hd__nor2_2
XFILLER_62_561 VGND VGND VPWR VPWR sky130_fd_sc_hd__decap_3
XTAP_TAPCELL_ROW_37_759 VGND VPWR sky130_fd_sc_hd__tapvpwrvgnd_1
Xg_row\[0\].g_col\[1\].pe__1590_ g_row\[0\].g_col\[1\].pe__1594_/A g_row\[0\].g_col\[1\].pe__1594_/B
+ VGND VGND VPWR VPWR g_row\[0\].g_col\[1\].pe__1591_/B sky130_fd_sc_hd__xor2_2
Xg_row\[1\].g_col\[1\].pe__2133_ g_row\[1\].g_col\[1\].pe__2184_/C g_row\[1\].g_col\[1\].pe__2184_/B
+ g_row\[1\].g_col\[1\].pe__2222_/A VGND VGND VPWR VPWR g_row\[1\].g_col\[1\].pe__2135_/A
+ sky130_fd_sc_hd__a21bo_2
XFILLER_22_425 VGND VGND VPWR VPWR sky130_fd_sc_hd__decap_3
XTAP_TAPCELL_ROW_17_461 VGND VPWR sky130_fd_sc_hd__tapvpwrvgnd_1
XTAP_TAPCELL_ROW_17_472 VGND VPWR sky130_fd_sc_hd__tapvpwrvgnd_1
Xg_row\[0\].g_col\[0\].pe__1574_ hold2229/A g_row\[0\].g_col\[0\].pe__1414_/X g_row\[0\].g_col\[0\].pe__1415_/Y
+ g_row\[0\].g_col\[0\].pe__1784_/B1 place1198/X VGND VGND VPWR VPWR g_row\[0\].g_col\[0\].pe__1575_/B
+ sky130_fd_sc_hd__a32o_2
Xg_row\[1\].g_col\[0\].pe__2117_ g_row\[1\].g_col\[0\].pe__2117_/A g_row\[1\].g_col\[0\].pe__2117_/B
+ VGND VGND VPWR VPWR g_row\[1\].g_col\[0\].pe__2161_/A sky130_fd_sc_hd__nor2_2
Xg_row\[1\].g_col\[1\].pe__2064_ hold1641/X g_row\[1\].g_col\[1\].pe__2064_/B VGND
+ VGND VPWR VPWR g_row\[1\].g_col\[1\].pe__2064_/Y sky130_fd_sc_hd__nor2_2
Xg_row\[1\].g_col\[0\].pe__2048_ g_row\[1\].g_col\[0\].pe__2048_/A g_row\[1\].g_col\[0\].pe__2048_/B
+ g_row\[1\].g_col\[0\].pe__2048_/C VGND VGND VPWR VPWR g_row\[1\].g_col\[0\].pe__2048_/Y
+ sky130_fd_sc_hd__nand3_2
Xg_row\[0\].g_col\[1\].pe__2211_ g_row\[0\].g_col\[1\].pe__2211_/A VGND VGND VPWR
+ VPWR g_row\[0\].g_col\[1\].pe__2253_/B sky130_fd_sc_hd__inv_2
Xg_row\[0\].g_col\[0\].pe__2126_ g_row\[0\].g_col\[0\].pe__2125_/A g_row\[0\].g_col\[0\].pe__1449_/A
+ g_row\[0\].g_col\[0\].pe__2125_/X g_row\[0\].g_col\[0\].pe__1460_/B VGND VGND VPWR
+ VPWR g_row\[0\].g_col\[0\].pe__2128_/A sky130_fd_sc_hd__a2bb2o_2
Xg_row\[0\].g_col\[1\].pe__2142_ g_row\[0\].g_col\[1\].pe__2142_/A g_row\[0\].g_col\[1\].pe__2187_/B
+ VGND VGND VPWR VPWR g_row\[0\].g_col\[1\].pe__2143_/B sky130_fd_sc_hd__xnor2_2
Xg_row\[0\].g_col\[1\].pe__2073_ g_row\[0\].g_col\[1\].pe__2138_/B2 g_row\[0\].g_col\[1\].pe__2177_/A2
+ g_row\[0\].g_col\[1\].pe__2215_/B1 g_row\[0\].g_col\[1\].pe__2073_/B2 VGND VGND
+ VPWR VPWR g_row\[0\].g_col\[1\].pe__2136_/A sky130_fd_sc_hd__a22o_2
Xg_row\[0\].g_col\[0\].pe__2057_ g_row\[0\].g_col\[0\].pe__2068_/A g_row\[0\].g_col\[0\].pe__2068_/B
+ VGND VGND VPWR VPWR g_row\[0\].g_col\[0\].pe__2058_/B sky130_fd_sc_hd__xnor2_2
Xg_row\[1\].g_col\[1\].pe__1917_ g_row\[1\].g_col\[1\].pe__2726_/Q g_row\[1\].g_col\[1\].pe__2682_/A
+ VGND VGND VPWR VPWR g_row\[1\].g_col\[1\].pe__2094_/B sky130_fd_sc_hd__or2_2
XFILLER_89_447 VGND VGND VPWR VPWR sky130_fd_sc_hd__fill_1
Xg_row\[1\].g_col\[1\].pe__1848_ g_row\[1\].g_col\[1\].pe__1606_/A g_row\[1\].g_col\[1\].pe__1848_/B
+ VGND VGND VPWR VPWR g_row\[1\].g_col\[1\].pe__1850_/A sky130_fd_sc_hd__and2b_2
Xg_row\[1\].g_col\[1\].pe__1779_ g_row\[1\].g_col\[1\].pe__1813_/A g_row\[1\].g_col\[1\].pe__1813_/B
+ VGND VGND VPWR VPWR g_row\[1\].g_col\[1\].pe__1779_/Y sky130_fd_sc_hd__nor2_2
XFILLER_85_642 VGND VGND VPWR VPWR sky130_fd_sc_hd__decap_3
Xhold2088 hold2088/A VGND VGND VPWR VPWR hold2088/X sky130_fd_sc_hd__clkbuf_2
XFILLER_85_664 VGND VGND VPWR VPWR sky130_fd_sc_hd__decap_3
Xhold2099 hold2099/A VGND VGND VPWR VPWR hold2099/X sky130_fd_sc_hd__clkbuf_2
Xg_row\[0\].g_col\[1\].pe__1926_ g_row\[0\].g_col\[1\].pe__1980_/B g_row\[0\].g_col\[1\].pe__1980_/C
+ VGND VGND VPWR VPWR g_row\[0\].g_col\[1\].pe__1927_/B sky130_fd_sc_hd__or2_4
Xg_row\[0\].g_col\[1\].pe__1857_ g_row\[0\].g_col\[1\].pe__1857_/A g_row\[0\].g_col\[1\].pe__1857_/B
+ VGND VGND VPWR VPWR g_row\[0\].g_col\[1\].pe__1858_/B sky130_fd_sc_hd__or2_2
XFILLER_41_701 VGND VGND VPWR VPWR sky130_fd_sc_hd__fill_1
XFILLER_53_561 VGND VGND VPWR VPWR sky130_fd_sc_hd__decap_3
Xg_row\[0\].g_col\[1\].pe__1788_ g_row\[0\].g_col\[1\].pe__1789_/A g_row\[0\].g_col\[1\].pe__1789_/B
+ VGND VGND VPWR VPWR g_row\[0\].g_col\[1\].pe__1795_/B sky130_fd_sc_hd__nand2_2
Xg_row\[0\].g_col\[1\].pe__2409_ g_row\[0\].g_col\[1\].pe__2775_/A g_row\[0\].g_col\[1\].pe__2410_/B
+ VGND VGND VPWR VPWR g_row\[0\].g_col\[1\].pe__2519_/A sky130_fd_sc_hd__nor2_2
Xinput1297 hold3511/X VGND VGND VPWR VPWR hold3512/A sky130_fd_sc_hd__buf_2
Xinput1286 hold3556/X VGND VGND VPWR VPWR hold3557/A sky130_fd_sc_hd__buf_2
XFILLER_5_668 VGND VGND VPWR VPWR sky130_fd_sc_hd__decap_3
XFILLER_5_679 VGND VGND VPWR VPWR sky130_fd_sc_hd__fill_2
XFILLER_1_841 VGND VGND VPWR VPWR sky130_fd_sc_hd__fill_1
Xhold3290 hold3290/A VGND VGND VPWR VPWR hold3290/X sky130_fd_sc_hd__clkbuf_2
Xg_row\[1\].g_col\[0\].pe__1350_ g_row\[1\].g_col\[0\].pe__2760_/Q g_row\[1\].g_col\[0\].pe__1348_/B
+ g_row\[1\].g_col\[0\].pe__2776_/A VGND VGND VPWR VPWR g_row\[1\].g_col\[0\].pe__1351_/B
+ sky130_fd_sc_hd__o21ai_2
XFILLER_76_675 VGND VGND VPWR VPWR sky130_fd_sc_hd__decap_3
XFILLER_29_580 VGND VGND VPWR VPWR sky130_fd_sc_hd__decap_3
XFILLER_91_634 VGND VGND VPWR VPWR sky130_fd_sc_hd__decap_3
XFILLER_90_155 VGND VGND VPWR VPWR sky130_fd_sc_hd__fill_1
XFILLER_32_701 VGND VGND VPWR VPWR sky130_fd_sc_hd__decap_3
XTAP_TAPCELL_ROW_34_718 VGND VPWR sky130_fd_sc_hd__tapvpwrvgnd_1
XTAP_TAPCELL_ROW_14_420 VGND VPWR sky130_fd_sc_hd__tapvpwrvgnd_1
XFILLER_32_789 VGND VGND VPWR VPWR sky130_fd_sc_hd__fill_1
XFILLER_69_3 VGND VGND VPWR VPWR sky130_fd_sc_hd__fill_1
XTAP_TAPCELL_ROW_74_1322 VGND VPWR sky130_fd_sc_hd__tapvpwrvgnd_1
Xg_row\[1\].g_col\[1\].pe__2751_ clkbuf_leaf_78_clk/X g_row\[1\].g_col\[1\].pe__2751_/D
+ VGND VGND VPWR VPWR g_row\[1\].g_col\[1\].pe__2751_/Q sky130_fd_sc_hd__dfxtp_2
Xg_row\[1\].g_col\[0\].pe__2735_ clkbuf_leaf_49_clk/X g_row\[1\].g_col\[0\].pe__2735_/D
+ VGND VGND VPWR VPWR g_row\[1\].g_col\[0\].pe__2735_/Q sky130_fd_sc_hd__dfxtp_2
Xg_row\[1\].g_col\[1\].pe__1702_ g_row\[1\].g_col\[1\].pe__1831_/A g_row\[1\].g_col\[1\].pe__1831_/B
+ g_row\[1\].g_col\[1\].pe__1827_/A g_row\[1\].g_col\[1\].pe__1827_/B VGND VGND VPWR
+ VPWR g_row\[1\].g_col\[1\].pe__1702_/X sky130_fd_sc_hd__o22a_2
Xg_row\[1\].g_col\[1\].pe__2682_ g_row\[1\].g_col\[1\].pe__2682_/A g_row\[1\].g_col\[1\].pe__2682_/B
+ VGND VGND VPWR VPWR g_row\[1\].g_col\[1\].pe__2682_/X sky130_fd_sc_hd__or2_2
Xg_row\[1\].g_col\[0\].pe__2666_ g_row\[1\].g_col\[0\].pe__2670_/A1 hold2069/X g_row\[1\].g_col\[0\].pe__2670_/B1
+ g_row\[1\].g_col\[0\].pe__2666_/C1 VGND VGND VPWR VPWR g_row\[1\].g_col\[0\].pe__2666_/X
+ sky130_fd_sc_hd__o211a_2
Xg_row\[1\].g_col\[1\].pe__1633_ g_row\[1\].g_col\[1\].pe__1633_/A g_row\[1\].g_col\[1\].pe__1633_/B
+ VGND VGND VPWR VPWR g_row\[1\].g_col\[1\].pe__1845_/B sky130_fd_sc_hd__xor2_2
Xg_row\[1\].g_col\[0\].pe_hold2231 g_row\[1\].g_col\[0\].pe__2751_/Q VGND VGND VPWR
+ VPWR g_row\[1\].g_col\[0\].pe__2336_/A sky130_fd_sc_hd__clkbuf_2
Xg_row\[1\].g_col\[0\].pe__1617_ g_row\[1\].g_col\[0\].pe__2163_/A VGND VGND VPWR
+ VPWR g_row\[1\].g_col\[0\].pe__2125_/A sky130_fd_sc_hd__inv_2
XFILLER_67_653 VGND VGND VPWR VPWR sky130_fd_sc_hd__decap_3
XFILLER_79_480 VGND VGND VPWR VPWR sky130_fd_sc_hd__fill_2
Xg_row\[1\].g_col\[1\].pe_place834 g_row\[1\].g_col\[1\].pe__2247_/B1 VGND VGND VPWR
+ VPWR g_row\[1\].g_col\[1\].pe__1613_/B1 sky130_fd_sc_hd__buf_6
Xg_row\[1\].g_col\[1\].pe__1564_ g_row\[1\].g_col\[1\].pe__2215_/B2 g_row\[1\].g_col\[1\].pe__2026_/B
+ g_row\[1\].g_col\[1\].pe__1738_/B1 g_row\[1\].g_col\[1\].pe__1704_/A2 VGND VGND
+ VPWR VPWR g_row\[1\].g_col\[1\].pe__1565_/B sky130_fd_sc_hd__a22o_2
Xg_row\[1\].g_col\[0\].pe_hold2242 g_row\[1\].g_col\[0\].pe__2306_/X VGND VGND VPWR
+ VPWR g_row\[1\].g_col\[0\].pe__2307_/B sky130_fd_sc_hd__clkbuf_2
Xg_row\[1\].g_col\[0\].pe__1548_ g_row\[1\].g_col\[0\].pe__1550_/A g_row\[1\].g_col\[0\].pe__1550_/B
+ VGND VGND VPWR VPWR g_row\[1\].g_col\[0\].pe__1830_/A sky130_fd_sc_hd__and2b_2
Xg_row\[0\].g_col\[0\].pe__2744_ _277_/CLK g_row\[0\].g_col\[0\].pe__2744_/D VGND
+ VGND VPWR VPWR g_row\[0\].g_col\[0\].pe__2744_/Q sky130_fd_sc_hd__dfxtp_2
Xg_row\[0\].g_col\[1\].pe__2760_ clkbuf_leaf_13_clk/X g_row\[0\].g_col\[1\].pe__2760_/D
+ VGND VGND VPWR VPWR g_row\[0\].g_col\[1\].pe__2760_/Q sky130_fd_sc_hd__dfxtp_2
XFILLER_81_111 VGND VGND VPWR VPWR sky130_fd_sc_hd__fill_1
XFILLER_82_623 VGND VGND VPWR VPWR sky130_fd_sc_hd__decap_3
Xg_row\[0\].g_col\[1\].pe__1711_ g_row\[0\].g_col\[1\].pe__1789_/A g_row\[0\].g_col\[1\].pe__1711_/B
+ VGND VGND VPWR VPWR g_row\[0\].g_col\[1\].pe__1736_/B sky130_fd_sc_hd__xor2_2
Xg_row\[1\].g_col\[1\].pe_place878 g_row\[1\].g_col\[1\].pe__2406_/Y VGND VGND VPWR
+ VPWR g_row\[1\].g_col\[1\].pe__2591_/A2 sky130_fd_sc_hd__buf_6
Xg_row\[1\].g_col\[1\].pe_place889 g_row\[1\].g_col\[1\].pe__2079_/B VGND VGND VPWR
+ VPWR g_row\[1\].g_col\[1\].pe__2026_/B sky130_fd_sc_hd__buf_6
Xg_row\[1\].g_col\[1\].pe__1495_ g_row\[1\].g_col\[1\].pe__1673_/A g_row\[1\].g_col\[1\].pe__1495_/B
+ VGND VGND VPWR VPWR g_row\[1\].g_col\[1\].pe__1536_/B sky130_fd_sc_hd__xnor2_2
Xg_row\[1\].g_col\[0\].pe__1479_ g_row\[1\].g_col\[0\].pe__1479_/A g_row\[1\].g_col\[0\].pe__1479_/B
+ VGND VGND VPWR VPWR g_row\[1\].g_col\[0\].pe__1479_/Y sky130_fd_sc_hd__nor2_2
Xg_row\[0\].g_col\[1\].pe__2691_ clkbuf_leaf_90_clk/X g_row\[0\].g_col\[1\].pe__2691_/D
+ VGND VGND VPWR VPWR g_row\[0\].g_col\[1\].pe__2691_/Q sky130_fd_sc_hd__dfxtp_2
XFILLER_81_155 VGND VGND VPWR VPWR sky130_fd_sc_hd__decap_3
Xg_row\[0\].g_col\[0\].pe__2675_ g_row\[0\].g_col\[0\].pe__2672_/X g_row\[0\].g_col\[0\].pe__2673_/X
+ g_row\[0\].g_col\[0\].pe__2674_/X g_row\[0\].g_col\[0\].pe__2675_/B1 VGND VGND VPWR
+ VPWR g_row\[0\].g_col\[0\].pe__2675_/Y sky130_fd_sc_hd__o31ai_2
Xg_row\[0\].g_col\[1\].pe__1642_ g_row\[0\].g_col\[1\].pe__1728_/A g_row\[0\].g_col\[1\].pe__1642_/B
+ VGND VGND VPWR VPWR g_row\[0\].g_col\[1\].pe__1648_/A sky130_fd_sc_hd__xnor2_2
XFILLER_22_200 VGND VGND VPWR VPWR sky130_fd_sc_hd__fill_2
XFILLER_35_583 VGND VGND VPWR VPWR sky130_fd_sc_hd__fill_1
XTAP_TAPCELL_ROW_85_1484 VGND VPWR sky130_fd_sc_hd__tapvpwrvgnd_1
Xg_row\[0\].g_col\[0\].pe__1626_ g_row\[0\].g_col\[0\].pe__1626_/A g_row\[0\].g_col\[0\].pe__1626_/B
+ VGND VGND VPWR VPWR g_row\[0\].g_col\[0\].pe__1626_/X sky130_fd_sc_hd__and2_2
Xg_row\[0\].g_col\[0\].pe__1557_ g_row\[0\].g_col\[0\].pe__1602_/A g_row\[0\].g_col\[0\].pe__1557_/B
+ VGND VGND VPWR VPWR g_row\[0\].g_col\[0\].pe__1558_/C sky130_fd_sc_hd__xnor2_2
Xg_row\[0\].g_col\[1\].pe__1573_ g_row\[0\].g_col\[1\].pe__1808_/A g_row\[0\].g_col\[1\].pe__1573_/B
+ VGND VGND VPWR VPWR g_row\[0\].g_col\[1\].pe__1626_/A sky130_fd_sc_hd__xnor2_2
Xg_row\[1\].g_col\[1\].pe__2116_ g_row\[1\].g_col\[1\].pe__2116_/A VGND VGND VPWR
+ VPWR g_row\[1\].g_col\[1\].pe__2116_/Y sky130_fd_sc_hd__inv_2
XFILLER_10_417 VGND VGND VPWR VPWR sky130_fd_sc_hd__decap_3
Xg_row\[1\].g_col\[1\].pe__2047_ g_row\[1\].g_col\[1\].pe__2047_/A g_row\[1\].g_col\[1\].pe__2047_/B
+ VGND VGND VPWR VPWR g_row\[1\].g_col\[1\].pe__2048_/C sky130_fd_sc_hd__xor2_2
Xg_row\[0\].g_col\[0\].pe__1488_ place1205/X g_row\[0\].g_col\[0\].pe__1732_/A2 g_row\[0\].g_col\[0\].pe__1732_/B1
+ place1207/X VGND VGND VPWR VPWR g_row\[0\].g_col\[0\].pe__1489_/B sky130_fd_sc_hd__a22o_2
XFILLER_2_605 VGND VGND VPWR VPWR sky130_fd_sc_hd__decap_3
Xg_row\[0\].g_col\[0\].pe__2109_ g_row\[0\].g_col\[0\].pe__2110_/A g_row\[0\].g_col\[0\].pe__2110_/B
+ VGND VGND VPWR VPWR g_row\[0\].g_col\[0\].pe__2111_/A sky130_fd_sc_hd__and2_4
Xg_row\[0\].g_col\[1\].pe__2125_ g_row\[0\].g_col\[1\].pe__2125_/A g_row\[0\].g_col\[1\].pe__2729_/Q
+ g_row\[0\].g_col\[1\].pe__2125_/C VGND VGND VPWR VPWR g_row\[0\].g_col\[1\].pe__2125_/X
+ sky130_fd_sc_hd__or3_2
XFILLER_2_627 VGND VGND VPWR VPWR sky130_fd_sc_hd__decap_3
Xg_row\[0\].g_col\[1\].pe__2056_ g_row\[0\].g_col\[1\].pe__1997_/A g_row\[0\].g_col\[1\].pe__1997_/B
+ g_row\[0\].g_col\[1\].pe__2055_/Y VGND VGND VPWR VPWR g_row\[0\].g_col\[1\].pe__2068_/B
+ sky130_fd_sc_hd__a21oi_2
XFILLER_1_126 VGND VGND VPWR VPWR sky130_fd_sc_hd__decap_3
XFILLER_18_528 VGND VGND VPWR VPWR sky130_fd_sc_hd__decap_3
XFILLER_38_99 VGND VGND VPWR VPWR sky130_fd_sc_hd__fill_1
Xg_row\[0\].g_col\[1\].pe__1909_ g_row\[0\].g_col\[1\].pe__2030_/A g_row\[0\].g_col\[1\].pe__2026_/B
+ g_row\[0\].g_col\[1\].pe__1449_/Y g_row\[0\].g_col\[1\].pe__1970_/A VGND VGND VPWR
+ VPWR g_row\[0\].g_col\[1\].pe__1910_/B sky130_fd_sc_hd__a22o_2
XFILLER_14_723 VGND VGND VPWR VPWR sky130_fd_sc_hd__fill_2
XFILLER_60_328 VGND VGND VPWR VPWR sky130_fd_sc_hd__fill_1
Xg_row\[0\].g_col\[0\].pe_hold2307 g_row\[0\].g_col\[0\].pe_hold2891/X VGND VGND VPWR
+ VPWR g_row\[0\].g_col\[0\].pe__2697_/D sky130_fd_sc_hd__clkbuf_2
XTAP_TAPCELL_ROW_0_192 VGND VPWR sky130_fd_sc_hd__tapvpwrvgnd_1
Xg_row\[0\].g_col\[0\].pe_hold2318 g_row\[0\].g_col\[0\].pe_hold2912/X VGND VGND VPWR
+ VPWR g_row\[0\].g_col\[0\].pe__2693_/D sky130_fd_sc_hd__clkbuf_2
XFILLER_13_255 VGND VGND VPWR VPWR sky130_fd_sc_hd__fill_1
Xg_row\[1\].g_col\[1\].pe_hold3062 g_row\[1\].g_col\[1\].pe__2702_/Q VGND VGND VPWR
+ VPWR g_row\[1\].g_col\[1\].pe__2627_/B sky130_fd_sc_hd__clkbuf_2
Xoutput1409 output1409/A VGND VGND VPWR VPWR results_flat[59] sky130_fd_sc_hd__buf_2
XTAP_TAPCELL_ROW_56_1052 VGND VPWR sky130_fd_sc_hd__tapvpwrvgnd_1
Xg_row\[1\].g_col\[0\].pe__2520_ g_row\[1\].g_col\[0\].pe__2499_/B g_row\[1\].g_col\[0\].pe__2519_/Y
+ g_row\[1\].g_col\[0\].pe__2559_/A VGND VGND VPWR VPWR g_row\[1\].g_col\[0\].pe__2520_/X
+ sky130_fd_sc_hd__a21o_2
Xg_row\[1\].g_col\[1\].pe_hold1682 g_row\[1\].g_col\[1\].pe__2401_/X VGND VGND VPWR
+ VPWR g_row\[1\].g_col\[1\].pe__2402_/B sky130_fd_sc_hd__clkbuf_2
Xg_row\[1\].g_col\[1\].pe_hold1671 g_row\[1\].g_col\[1\].pe__2380_/X VGND VGND VPWR
+ VPWR g_row\[1\].g_col\[1\].pe__2381_/B sky130_fd_sc_hd__clkbuf_2
Xg_row\[1\].g_col\[0\].pe__2451_ g_row\[1\].g_col\[0\].pe__2451_/A g_row\[1\].g_col\[0\].pe__2451_/B
+ VGND VGND VPWR VPWR g_row\[1\].g_col\[0\].pe__2452_/B sky130_fd_sc_hd__xnor2_2
Xg_row\[1\].g_col\[0\].pe__1402_ hold2082/X g_row\[1\].g_col\[0\].pe__1402_/B VGND
+ VGND VPWR VPWR g_row\[1\].g_col\[0\].pe__1402_/X sky130_fd_sc_hd__or2_2
XFILLER_48_141 VGND VGND VPWR VPWR sky130_fd_sc_hd__fill_1
XFILLER_36_303 VGND VGND VPWR VPWR sky130_fd_sc_hd__decap_3
XFILLER_37_837 VGND VGND VPWR VPWR sky130_fd_sc_hd__decap_3
XTAP_TAPCELL_ROW_19_501 VGND VPWR sky130_fd_sc_hd__tapvpwrvgnd_1
Xg_row\[1\].g_col\[1\].pe_place1006 g_row\[1\].g_col\[1\].pe__2167_/A VGND VGND VPWR
+ VPWR g_row\[1\].g_col\[1\].pe__1739_/A sky130_fd_sc_hd__buf_6
Xg_row\[1\].g_col\[1\].pe_place1017 g_row\[1\].g_col\[1\].pe__2724_/Q VGND VGND VPWR
+ VPWR g_row\[1\].g_col\[1\].pe__2682_/A sky130_fd_sc_hd__buf_6
Xg_row\[1\].g_col\[1\].pe_place1028 g_row\[1\].g_col\[1\].pe__2700_/Q VGND VGND VPWR
+ VPWR g_row\[1\].g_col\[1\].pe__1970_/A sky130_fd_sc_hd__buf_6
XFILLER_63_133 VGND VGND VPWR VPWR sky130_fd_sc_hd__fill_2
Xg_row\[1\].g_col\[1\].pe_place1039 g_row\[1\].g_col\[1\].pe__2694_/Q VGND VGND VPWR
+ VPWR g_row\[1\].g_col\[1\].pe__1761_/A2 sky130_fd_sc_hd__buf_6
XFILLER_17_550 VGND VGND VPWR VPWR sky130_fd_sc_hd__fill_1
XFILLER_17_561 VGND VGND VPWR VPWR sky130_fd_sc_hd__decap_3
XFILLER_64_689 VGND VGND VPWR VPWR sky130_fd_sc_hd__fill_2
Xg_row\[0\].g_col\[0\].pe__2460_ g_row\[0\].g_col\[0\].pe__2740_/Q g_row\[0\].g_col\[0\].pe__2460_/B
+ VGND VGND VPWR VPWR g_row\[0\].g_col\[0\].pe__2462_/B sky130_fd_sc_hd__xnor2_2
Xg_row\[0\].g_col\[0\].pe__1411_ g_row\[0\].g_col\[0\].pe__2724_/Q VGND VGND VPWR
+ VPWR g_row\[0\].g_col\[0\].pe__1808_/A sky130_fd_sc_hd__inv_4
Xg_row\[0\].g_col\[0\].pe__2391_ g_row\[0\].g_col\[0\].pe__2391_/A g_row\[0\].g_col\[0\].pe__2391_/B
+ VGND VGND VPWR VPWR g_row\[0\].g_col\[0\].pe__2392_/B sky130_fd_sc_hd__xor2_2
XFILLER_32_564 VGND VGND VPWR VPWR sky130_fd_sc_hd__decap_3
Xg_row\[0\].g_col\[0\].pe__1342_ g_row\[0\].g_col\[0\].pe__2757_/Q g_row\[0\].g_col\[0\].pe__1342_/B
+ VGND VGND VPWR VPWR output1366/A sky130_fd_sc_hd__xnor2_2
XFILLER_87_704 VGND VGND VPWR VPWR sky130_fd_sc_hd__decap_3
Xg_row\[1\].g_col\[1\].pe__2734_ clkbuf_leaf_84_clk/X g_row\[1\].g_col\[1\].pe__2734_/D
+ VGND VGND VPWR VPWR g_row\[1\].g_col\[1\].pe__2734_/Q sky130_fd_sc_hd__dfxtp_2
Xg_row\[1\].g_col\[0\].pe__2718_ clkbuf_leaf_49_clk/X g_row\[1\].g_col\[0\].pe__2718_/D
+ VGND VGND VPWR VPWR g_row\[1\].g_col\[0\].pe__2718_/Q sky130_fd_sc_hd__dfxtp_2
XFILLER_59_417 VGND VGND VPWR VPWR sky130_fd_sc_hd__fill_2
XFILLER_87_726 VGND VGND VPWR VPWR sky130_fd_sc_hd__fill_2
Xg_row\[1\].g_col\[1\].pe__2665_ g_row\[1\].g_col\[1\].pe__2669_/A g_row\[1\].g_col\[1\].pe__2665_/B
+ VGND VGND VPWR VPWR g_row\[1\].g_col\[1\].pe__2665_/X sky130_fd_sc_hd__or2_2
Xg_row\[1\].g_col\[0\].pe__2649_ g_row\[1\].g_col\[0\].pe__2676_/A g_row\[1\].g_col\[0\].pe__2649_/B
+ VGND VGND VPWR VPWR g_row\[1\].g_col\[0\].pe__2649_/X sky130_fd_sc_hd__or2_2
XFILLER_87_748 VGND VGND VPWR VPWR sky130_fd_sc_hd__decap_3
Xg_row\[1\].g_col\[1\].pe__1616_ g_row\[1\].g_col\[1\].pe__2704_/Q g_row\[1\].g_col\[1\].pe__1804_/B
+ g_row\[1\].g_col\[1\].pe__1928_/A VGND VGND VPWR VPWR g_row\[1\].g_col\[1\].pe__1875_/A
+ sky130_fd_sc_hd__a21o_2
Xg_row\[1\].g_col\[0\].pe_hold2072 g_row\[1\].g_col\[0\].pe_hold2929/X VGND VGND VPWR
+ VPWR g_row\[1\].g_col\[0\].pe__2703_/D sky130_fd_sc_hd__clkbuf_2
Xg_row\[1\].g_col\[0\].pe_hold2061 g_row\[1\].g_col\[0\].pe_hold2930/X VGND VGND VPWR
+ VPWR g_row\[1\].g_col\[0\].pe_hold2931/A sky130_fd_sc_hd__clkbuf_2
Xg_row\[1\].g_col\[0\].pe_hold2050 g_row\[1\].g_col\[0\].pe__2723_/Q VGND VGND VPWR
+ VPWR g_row\[1\].g_col\[0\].pe__1340_/A sky130_fd_sc_hd__clkbuf_2
XFILLER_39_174 VGND VGND VPWR VPWR sky130_fd_sc_hd__fill_2
XFILLER_55_623 VGND VGND VPWR VPWR sky130_fd_sc_hd__decap_3
XTAP_TAPCELL_ROW_87_1513 VGND VPWR sky130_fd_sc_hd__tapvpwrvgnd_1
Xg_row\[1\].g_col\[1\].pe__1547_ g_row\[1\].g_col\[1\].pe__1547_/A g_row\[1\].g_col\[1\].pe__1547_/B
+ VGND VGND VPWR VPWR g_row\[1\].g_col\[1\].pe__1550_/B sky130_fd_sc_hd__xor2_2
Xg_row\[1\].g_col\[0\].pe_hold2083 g_row\[1\].g_col\[0\].pe_hold2860/X VGND VGND VPWR
+ VPWR g_row\[1\].g_col\[0\].pe_hold2861/A sky130_fd_sc_hd__clkbuf_2
Xg_row\[0\].g_col\[1\].pe_hold2404 g_row\[0\].g_col\[1\].pe__1893_/Y VGND VGND VPWR
+ VPWR g_row\[0\].g_col\[1\].pe__2740_/D sky130_fd_sc_hd__clkbuf_2
Xg_row\[0\].g_col\[1\].pe__2743_ clkbuf_leaf_7_clk/X g_row\[0\].g_col\[1\].pe__2743_/D
+ VGND VGND VPWR VPWR g_row\[0\].g_col\[1\].pe__2743_/Q sky130_fd_sc_hd__dfxtp_2
XFILLER_55_667 VGND VGND VPWR VPWR sky130_fd_sc_hd__decap_3
Xg_row\[0\].g_col\[0\].pe__2727_ clkbuf_leaf_22_clk/X g_row\[0\].g_col\[0\].pe__2727_/D
+ VGND VGND VPWR VPWR g_row\[0\].g_col\[0\].pe__2727_/Q sky130_fd_sc_hd__dfxtp_2
Xg_row\[1\].g_col\[1\].pe__1478_ g_row\[1\].g_col\[1\].pe__1478_/A g_row\[1\].g_col\[1\].pe__1478_/B
+ VGND VGND VPWR VPWR g_row\[1\].g_col\[1\].pe__1662_/B sky130_fd_sc_hd__xor2_2
XFILLER_54_177 VGND VGND VPWR VPWR sky130_fd_sc_hd__fill_2
Xg_row\[0\].g_col\[0\].pe__2658_ g_row\[0\].g_col\[0\].pe__2670_/A1 g_row\[0\].g_col\[0\].pe__2658_/A2
+ g_row\[0\].g_col\[0\].pe__2677_/B1 g_row\[0\].g_col\[0\].pe__2657_/X VGND VGND VPWR
+ VPWR g_row\[0\].g_col\[0\].pe__2658_/X sky130_fd_sc_hd__o211a_2
Xg_row\[0\].g_col\[1\].pe__2674_ g_row\[0\].g_col\[1\].pe__2674_/A g_row\[0\].g_col\[1\].pe__2674_/B
+ _332_/Q g_row\[0\].g_col\[1\].pe__2674_/D VGND VGND VPWR VPWR g_row\[0\].g_col\[1\].pe__2674_/X
+ sky130_fd_sc_hd__or4_2
XFILLER_35_391 VGND VGND VPWR VPWR sky130_fd_sc_hd__fill_1
Xg_row\[0\].g_col\[0\].pe__1609_ g_row\[0\].g_col\[0\].pe__1910_/A g_row\[0\].g_col\[0\].pe__1609_/B
+ VGND VGND VPWR VPWR g_row\[0\].g_col\[0\].pe__1851_/A sky130_fd_sc_hd__xor2_2
Xg_row\[0\].g_col\[1\].pe__1625_ g_row\[0\].g_col\[1\].pe__1625_/A g_row\[0\].g_col\[1\].pe__1625_/B
+ VGND VGND VPWR VPWR g_row\[0\].g_col\[1\].pe__1879_/A sky130_fd_sc_hd__xnor2_2
XFILLER_50_361 VGND VGND VPWR VPWR sky130_fd_sc_hd__decap_3
Xg_row\[0\].g_col\[1\].pe__1556_ g_row\[0\].g_col\[1\].pe__2605_/B g_row\[0\].g_col\[1\].pe__2313_/A2
+ g_row\[0\].g_col\[1\].pe__1541_/X g_row\[0\].g_col\[1\].pe__2603_/B VGND VGND VPWR
+ VPWR g_row\[0\].g_col\[1\].pe__1557_/B sky130_fd_sc_hd__a22o_2
XFILLER_10_214 VGND VGND VPWR VPWR sky130_fd_sc_hd__fill_1
XFILLER_11_726 VGND VGND VPWR VPWR sky130_fd_sc_hd__fill_2
XFILLER_24_79 VGND VGND VPWR VPWR sky130_fd_sc_hd__fill_1
Xg_row\[0\].g_col\[1\].pe__1487_ g_row\[0\].g_col\[1\].pe__1514_/A g_row\[0\].g_col\[1\].pe__1514_/B
+ VGND VGND VPWR VPWR g_row\[0\].g_col\[1\].pe__1490_/A sky130_fd_sc_hd__xor2_2
XFILLER_6_229 VGND VGND VPWR VPWR sky130_fd_sc_hd__fill_1
Xg_row\[0\].g_col\[1\].pe__2108_ g_row\[0\].g_col\[1\].pe__2117_/A g_row\[0\].g_col\[1\].pe__2117_/B
+ VGND VGND VPWR VPWR g_row\[0\].g_col\[1\].pe__2110_/B sky130_fd_sc_hd__xor2_2
Xg_row\[0\].g_col\[1\].pe__2039_ g_row\[0\].g_col\[1\].pe__2038_/A g_row\[0\].g_col\[1\].pe__2038_/B
+ g_row\[0\].g_col\[1\].pe__2038_/C VGND VGND VPWR VPWR g_row\[0\].g_col\[1\].pe__2048_/B
+ sky130_fd_sc_hd__a21o_2
XFILLER_93_729 VGND VGND VPWR VPWR sky130_fd_sc_hd__decap_3
XFILLER_45_111 VGND VGND VPWR VPWR sky130_fd_sc_hd__fill_1
XFILLER_46_612 VGND VGND VPWR VPWR sky130_fd_sc_hd__fill_2
XFILLER_58_472 VGND VGND VPWR VPWR sky130_fd_sc_hd__decap_3
XTAP_TAPCELL_ROW_5_284 VGND VPWR sky130_fd_sc_hd__tapvpwrvgnd_1
XANTENNA_110 hold3229/A VGND VGND VPWR VPWR sky130_fd_sc_hd__diode_2
XANTENNA_121 hold3340/X VGND VGND VPWR VPWR sky130_fd_sc_hd__diode_2
XANTENNA_132 a_inputs_flat[23] VGND VGND VPWR VPWR sky130_fd_sc_hd__diode_2
XANTENNA_143 a_inputs_flat[30] VGND VGND VPWR VPWR sky130_fd_sc_hd__diode_2
XFILLER_45_166 VGND VGND VPWR VPWR sky130_fd_sc_hd__fill_2
XFILLER_61_626 VGND VGND VPWR VPWR sky130_fd_sc_hd__fill_2
XFILLER_61_637 VGND VGND VPWR VPWR sky130_fd_sc_hd__decap_3
Xg_row\[0\].g_col\[1\].pe_hold2971 g_row\[0\].g_col\[1\].pe__2674_/D VGND VGND VPWR
+ VPWR g_row\[0\].g_col\[1\].pe__2654_/A2 sky130_fd_sc_hd__clkbuf_2
XANTENNA_154 hold1929/X VGND VGND VPWR VPWR sky130_fd_sc_hd__diode_2
XANTENNA_165 _310_/D VGND VGND VPWR VPWR sky130_fd_sc_hd__diode_2
XANTENNA_176 hold3325/X VGND VGND VPWR VPWR sky130_fd_sc_hd__diode_2
Xg_row\[0\].g_col\[0\].pe_hold2104 g_row\[0\].g_col\[0\].pe__2769_/Q VGND VGND VPWR
+ VPWR g_row\[0\].g_col\[0\].pe__2587_/A1 sky130_fd_sc_hd__clkbuf_2
Xg_row\[0\].g_col\[1\].pe_hold2993 _339_/Q VGND VGND VPWR VPWR g_row\[0\].g_col\[1\].pe_hold2993/X
+ sky130_fd_sc_hd__clkbuf_2
XFILLER_14_553 VGND VGND VPWR VPWR sky130_fd_sc_hd__fill_1
XTAP_TAPCELL_ROW_44_868 VGND VPWR sky130_fd_sc_hd__tapvpwrvgnd_1
Xg_row\[0\].g_col\[0\].pe_hold2137 g_row\[0\].g_col\[0\].pe__2762_/Q VGND VGND VPWR
+ VPWR g_row\[0\].g_col\[0\].pe__2554_/A1 sky130_fd_sc_hd__clkbuf_2
Xg_row\[0\].g_col\[0\].pe_hold2159 _318_/Q VGND VGND VPWR VPWR g_row\[0\].g_col\[0\].pe_hold2159/X
+ sky130_fd_sc_hd__clkbuf_2
XFILLER_14_597 VGND VGND VPWR VPWR sky130_fd_sc_hd__decap_3
XTAP_TAPCELL_ROW_24_570 VGND VPWR sky130_fd_sc_hd__tapvpwrvgnd_1
Xg_row\[1\].g_col\[0\].pe__1951_ g_row\[1\].g_col\[0\].pe__1951_/A g_row\[1\].g_col\[0\].pe__1951_/B
+ VGND VGND VPWR VPWR g_row\[1\].g_col\[0\].pe__2009_/C sky130_fd_sc_hd__and2_2
X_287_ _287_/CLK _287_/D VGND VGND VPWR VPWR _287_/Q sky130_fd_sc_hd__dfxtp_2
Xg_row\[1\].g_col\[0\].pe__1882_ g_row\[1\].g_col\[0\].pe__1882_/A g_row\[1\].g_col\[0\].pe__1882_/B
+ VGND VGND VPWR VPWR g_row\[1\].g_col\[0\].pe__1885_/A sky130_fd_sc_hd__xor2_2
XFILLER_6_785 VGND VGND VPWR VPWR sky130_fd_sc_hd__fill_1
Xg_row\[0\].g_col\[0\].pe__1960_ g_row\[0\].g_col\[0\].pe__1961_/A g_row\[0\].g_col\[0\].pe__1961_/B
+ VGND VGND VPWR VPWR g_row\[0\].g_col\[0\].pe__2024_/A sky130_fd_sc_hd__nand2_2
Xg_row\[1\].g_col\[1\].pe_hold2180 g_row\[1\].g_col\[1\].pe__2708_/Q VGND VGND VPWR
+ VPWR g_row\[1\].g_col\[1\].pe__2645_/B sky130_fd_sc_hd__clkbuf_2
Xg_row\[1\].g_col\[0\].pe__2503_ g_row\[1\].g_col\[0\].pe__2579_/A g_row\[1\].g_col\[0\].pe__2503_/B
+ g_row\[1\].g_col\[0\].pe__2585_/B g_row\[1\].g_col\[0\].pe__2502_/X VGND VGND VPWR
+ VPWR g_row\[1\].g_col\[0\].pe__2506_/C sky130_fd_sc_hd__or4b_2
Xg_row\[1\].g_col\[1\].pe__2450_ g_row\[1\].g_col\[1\].pe__2450_/A1 g_row\[1\].g_col\[1\].pe__2742_/Q
+ g_row\[1\].g_col\[1\].pe__2453_/B VGND VGND VPWR VPWR g_row\[1\].g_col\[1\].pe__2451_/B
+ sky130_fd_sc_hd__a21o_2
XFILLER_84_707 VGND VGND VPWR VPWR sky130_fd_sc_hd__fill_2
XFILLER_84_718 VGND VGND VPWR VPWR sky130_fd_sc_hd__fill_2
Xg_row\[0\].g_col\[0\].pe__1891_ g_row\[0\].g_col\[0\].pe__1891_/A g_row\[0\].g_col\[0\].pe__1891_/B
+ VGND VGND VPWR VPWR g_row\[0\].g_col\[0\].pe__1891_/Y sky130_fd_sc_hd__xnor2_2
Xg_row\[1\].g_col\[1\].pe__1401_ g_row\[1\].g_col\[1\].pe__1401_/A1 g_row\[1\].g_col\[1\].pe__1403_/A2
+ g_row\[1\].g_col\[1\].pe__1401_/B1 g_row\[1\].g_col\[1\].pe__2640_/C1 VGND VGND
+ VPWR VPWR g_row\[1\].g_col\[1\].pe__1401_/X sky130_fd_sc_hd__o211a_2
Xg_row\[1\].g_col\[0\].pe__2434_ g_row\[1\].g_col\[0\].pe__2748_/Q g_row\[1\].g_col\[0\].pe__2434_/B
+ VGND VGND VPWR VPWR g_row\[1\].g_col\[0\].pe__2472_/B sky130_fd_sc_hd__xnor2_2
XFILLER_37_623 VGND VGND VPWR VPWR sky130_fd_sc_hd__fill_1
XFILLER_49_461 VGND VGND VPWR VPWR sky130_fd_sc_hd__fill_1
Xg_row\[1\].g_col\[1\].pe__2381_ g_row\[1\].g_col\[1\].pe__2595_/A g_row\[1\].g_col\[1\].pe__2381_/B
+ VGND VGND VPWR VPWR g_row\[1\].g_col\[1\].pe__2381_/X sky130_fd_sc_hd__and2_4
Xg_row\[1\].g_col\[0\].pe__2365_ g_row\[1\].g_col\[0\].pe__2365_/A g_row\[1\].g_col\[0\].pe__2365_/B
+ VGND VGND VPWR VPWR g_row\[1\].g_col\[0\].pe__2365_/X sky130_fd_sc_hd__and2_2
XTAP_TAPCELL_ROW_69_1243 VGND VPWR sky130_fd_sc_hd__tapvpwrvgnd_1
XFILLER_52_626 VGND VGND VPWR VPWR sky130_fd_sc_hd__decap_3
XFILLER_91_272 VGND VGND VPWR VPWR sky130_fd_sc_hd__fill_1
Xg_row\[0\].g_col\[0\].pe__2512_ g_row\[0\].g_col\[0\].pe__2519_/A g_row\[0\].g_col\[0\].pe__2499_/A
+ g_row\[0\].g_col\[0\].pe__2559_/A g_row\[0\].g_col\[0\].pe__2157_/A g_row\[0\].g_col\[0\].pe__2403_/A
+ VGND VGND VPWR VPWR g_row\[0\].g_col\[0\].pe__2512_/X sky130_fd_sc_hd__o311a_2
Xg_row\[1\].g_col\[0\].pe__2296_ g_row\[1\].g_col\[0\].pe__2329_/A g_row\[1\].g_col\[0\].pe__2296_/B
+ VGND VGND VPWR VPWR g_row\[1\].g_col\[0\].pe__2330_/C sky130_fd_sc_hd__nand2_2
Xg_row\[0\].g_col\[0\].pe__2443_ g_row\[0\].g_col\[0\].pe__2762_/Q g_row\[0\].g_col\[0\].pe__2443_/B
+ VGND VGND VPWR VPWR g_row\[0\].g_col\[0\].pe__2444_/B sky130_fd_sc_hd__and2b_2
XTAP_TAPCELL_ROW_82_1443 VGND VPWR sky130_fd_sc_hd__tapvpwrvgnd_1
XFILLER_32_372 VGND VGND VPWR VPWR sky130_fd_sc_hd__fill_2
Xg_row\[0\].g_col\[0\].pe__2374_ g_row\[0\].g_col\[0\].pe__2385_/A g_row\[0\].g_col\[0\].pe__2385_/B
+ VGND VGND VPWR VPWR g_row\[0\].g_col\[0\].pe__2375_/B sky130_fd_sc_hd__xor2_2
Xg_row\[0\].g_col\[1\].pe__2390_ g_row\[0\].g_col\[1\].pe__2390_/A g_row\[0\].g_col\[1\].pe__2390_/B
+ VGND VGND VPWR VPWR g_row\[0\].g_col\[1\].pe__2391_/B sky130_fd_sc_hd__xnor2_2
XFILLER_20_567 VGND VGND VPWR VPWR sky130_fd_sc_hd__fill_1
Xg_row\[0\].g_col\[1\].pe__1341_ g_row\[0\].g_col\[1\].pe__1348_/A g_row\[0\].g_col\[1\].pe__2775_/A
+ VGND VGND VPWR VPWR g_row\[0\].g_col\[1\].pe__1342_/B sky130_fd_sc_hd__nand2_2
XFILLER_20_589 VGND VGND VPWR VPWR sky130_fd_sc_hd__decap_3
Xg_row\[0\].g_col\[0\].pe_hold1992 g_row\[0\].g_col\[0\].pe__2759_/Q VGND VGND VPWR
+ VPWR g_row\[0\].g_col\[0\].pe__2535_/A1 sky130_fd_sc_hd__clkbuf_2
Xg_row\[1\].g_col\[1\].pe__2717_ clkbuf_leaf_80_clk/X g_row\[1\].g_col\[1\].pe__2717_/D
+ VGND VGND VPWR VPWR g_row\[1\].g_col\[1\].pe__2717_/Q sky130_fd_sc_hd__dfxtp_2
XFILLER_59_247 VGND VGND VPWR VPWR sky130_fd_sc_hd__fill_2
XFILLER_75_729 VGND VGND VPWR VPWR sky130_fd_sc_hd__fill_1
Xg_row\[1\].g_col\[1\].pe__2648_ g_row\[1\].g_col\[1\].pe__2656_/A1 g_row\[1\].g_col\[1\].pe__2648_/A2
+ g_row\[1\].g_col\[1\].pe__2683_/C1 g_row\[1\].g_col\[1\].pe__2648_/C1 VGND VGND
+ VPWR VPWR g_row\[1\].g_col\[1\].pe__2648_/X sky130_fd_sc_hd__o211a_2
XFILLER_19_57 VGND VGND VPWR VPWR sky130_fd_sc_hd__fill_2
Xg_row\[1\].g_col\[1\].pe__2579_ g_row\[1\].g_col\[1\].pe__2579_/A g_row\[1\].g_col\[1\].pe__2579_/B
+ g_row\[1\].g_col\[1\].pe__2579_/C VGND VGND VPWR VPWR g_row\[1\].g_col\[1\].pe__2579_/Y
+ sky130_fd_sc_hd__nand3_2
XTAP_TAPCELL_ROW_2_243 VGND VPWR sky130_fd_sc_hd__tapvpwrvgnd_1
XFILLER_43_615 VGND VGND VPWR VPWR sky130_fd_sc_hd__fill_1
XFILLER_55_464 VGND VGND VPWR VPWR sky130_fd_sc_hd__decap_3
Xg_row\[0\].g_col\[1\].pe_hold2245 g_row\[0\].g_col\[1\].pe__1393_/X VGND VGND VPWR
+ VPWR g_row\[0\].g_col\[1\].pe__2732_/D sky130_fd_sc_hd__clkbuf_2
Xg_row\[0\].g_col\[1\].pe__2726_ _332_/CLK g_row\[0\].g_col\[1\].pe__2726_/D VGND
+ VGND VPWR VPWR g_row\[0\].g_col\[1\].pe__2726_/Q sky130_fd_sc_hd__dfxtp_2
XFILLER_43_659 VGND VGND VPWR VPWR sky130_fd_sc_hd__decap_3
Xg_row\[0\].g_col\[1\].pe__2657_ g_row\[0\].g_col\[1\].pe__2669_/A hold2097/X VGND
+ VGND VPWR VPWR g_row\[0\].g_col\[1\].pe__2657_/X sky130_fd_sc_hd__or2_2
XFILLER_23_350 VGND VGND VPWR VPWR sky130_fd_sc_hd__fill_1
Xg_row\[0\].g_col\[1\].pe__1608_ g_row\[0\].g_col\[1\].pe__2699_/Q g_row\[0\].g_col\[1\].pe__2026_/B
+ g_row\[0\].g_col\[1\].pe__1449_/Y g_row\[0\].g_col\[1\].pe__2177_/A1 VGND VGND VPWR
+ VPWR g_row\[0\].g_col\[1\].pe__1609_/B sky130_fd_sc_hd__a22o_2
XTAP_TAPCELL_ROW_41_827 VGND VPWR sky130_fd_sc_hd__tapvpwrvgnd_1
Xg_row\[0\].g_col\[1\].pe__2588_ g_row\[0\].g_col\[1\].pe__2595_/A g_row\[0\].g_col\[1\].pe__2588_/B
+ VGND VGND VPWR VPWR g_row\[0\].g_col\[1\].pe__2769_/D sky130_fd_sc_hd__and2_2
X_141_ _271_/A _141_/B_N VGND VGND VPWR VPWR _141_/Y sky130_fd_sc_hd__nor2b_4
XFILLER_3_700 VGND VGND VPWR VPWR sky130_fd_sc_hd__decap_3
Xg_row\[0\].g_col\[0\].pe_place974 g_row\[0\].g_col\[0\].pe__2406_/Y VGND VGND VPWR
+ VPWR g_row\[0\].g_col\[0\].pe__2554_/A2 sky130_fd_sc_hd__buf_6
Xg_row\[0\].g_col\[0\].pe_place985 g_row\[0\].g_col\[0\].pe__2079_/B VGND VGND VPWR
+ VPWR g_row\[0\].g_col\[0\].pe__2026_/B sky130_fd_sc_hd__buf_6
Xg_row\[0\].g_col\[0\].pe_place996 g_row\[0\].g_col\[0\].pe__1838_/A VGND VGND VPWR
+ VPWR g_row\[0\].g_col\[0\].pe__2670_/A1 sky130_fd_sc_hd__buf_6
XFILLER_3_788 VGND VGND VPWR VPWR sky130_fd_sc_hd__decap_3
XTAP_TAPCELL_ROW_53_1000 VGND VPWR sky130_fd_sc_hd__tapvpwrvgnd_1
XTAP_TAPCELL_ROW_53_1011 VGND VPWR sky130_fd_sc_hd__tapvpwrvgnd_1
XFILLER_78_545 VGND VGND VPWR VPWR sky130_fd_sc_hd__decap_3
Xg_row\[1\].g_col\[0\].pe_hold2819 g_row\[1\].g_col\[0\].pe__2709_/Q VGND VGND VPWR
+ VPWR g_row\[1\].g_col\[0\].pe__2647_/B sky130_fd_sc_hd__clkbuf_2
XFILLER_66_707 VGND VGND VPWR VPWR sky130_fd_sc_hd__fill_1
XFILLER_78_567 VGND VGND VPWR VPWR sky130_fd_sc_hd__fill_1
XFILLER_19_612 VGND VGND VPWR VPWR sky130_fd_sc_hd__decap_3
XTAP_TAPCELL_ROW_49_938 VGND VPWR sky130_fd_sc_hd__tapvpwrvgnd_1
XTAP_TAPCELL_ROW_49_949 VGND VPWR sky130_fd_sc_hd__tapvpwrvgnd_1
XFILLER_19_634 VGND VGND VPWR VPWR sky130_fd_sc_hd__decap_3
XFILLER_19_667 VGND VGND VPWR VPWR sky130_fd_sc_hd__decap_3
XFILLER_74_740 VGND VGND VPWR VPWR sky130_fd_sc_hd__decap_3
XFILLER_74_751 VGND VGND VPWR VPWR sky130_fd_sc_hd__decap_3
Xg_row\[1\].g_col\[0\].pe__2150_ g_row\[1\].g_col\[0\].pe__2111_/A g_row\[1\].g_col\[0\].pe__2153_/C
+ g_row\[1\].g_col\[0\].pe__2150_/C VGND VGND VPWR VPWR g_row\[1\].g_col\[0\].pe__2150_/X
+ sky130_fd_sc_hd__and3b_2
XFILLER_18_144 VGND VGND VPWR VPWR sky130_fd_sc_hd__decap_3
XFILLER_18_166 VGND VGND VPWR VPWR sky130_fd_sc_hd__decap_3
XFILLER_46_475 VGND VGND VPWR VPWR sky130_fd_sc_hd__fill_1
XFILLER_46_486 VGND VGND VPWR VPWR sky130_fd_sc_hd__decap_3
XFILLER_74_784 VGND VGND VPWR VPWR sky130_fd_sc_hd__fill_1
XTAP_TAPCELL_ROW_29_640 VGND VPWR sky130_fd_sc_hd__tapvpwrvgnd_1
XTAP_TAPCELL_ROW_29_651 VGND VPWR sky130_fd_sc_hd__tapvpwrvgnd_1
XFILLER_61_412 VGND VGND VPWR VPWR sky130_fd_sc_hd__fill_2
Xg_row\[1\].g_col\[0\].pe__2081_ g_row\[1\].g_col\[0\].pe__1460_/B g_row\[1\].g_col\[0\].pe__2081_/B
+ g_row\[1\].g_col\[0\].pe__2081_/C VGND VGND VPWR VPWR g_row\[1\].g_col\[0\].pe__2087_/A
+ sky130_fd_sc_hd__nand3b_2
XFILLER_33_169 VGND VGND VPWR VPWR sky130_fd_sc_hd__fill_2
XTAP_TAPCELL_ROW_64_1173 VGND VPWR sky130_fd_sc_hd__tapvpwrvgnd_1
X_339_ _339_/CLK _339_/D VGND VGND VPWR VPWR _339_/Q sky130_fd_sc_hd__dfxtp_2
Xg_row\[0\].g_col\[0\].pe__2090_ g_row\[0\].g_col\[0\].pe__2171_/A g_row\[0\].g_col\[0\].pe__2090_/B
+ VGND VGND VPWR VPWR g_row\[0\].g_col\[0\].pe__2091_/C sky130_fd_sc_hd__xnor2_2
Xg_row\[1\].g_col\[1\].pe__1950_ g_row\[1\].g_col\[1\].pe__1950_/A g_row\[1\].g_col\[1\].pe__1950_/B
+ VGND VGND VPWR VPWR g_row\[1\].g_col\[1\].pe__1950_/Y sky130_fd_sc_hd__nand2_2
Xg_row\[1\].g_col\[0\].pe__1934_ g_row\[1\].g_col\[0\].pe__1999_/A g_row\[1\].g_col\[0\].pe__1999_/B
+ VGND VGND VPWR VPWR g_row\[1\].g_col\[0\].pe__1935_/B sky130_fd_sc_hd__xor2_2
Xg_row\[1\].g_col\[1\].pe__1881_ g_row\[1\].g_col\[1\].pe__1936_/A g_row\[1\].g_col\[1\].pe__1936_/B
+ VGND VGND VPWR VPWR g_row\[1\].g_col\[1\].pe__1882_/B sky130_fd_sc_hd__xnor2_2
Xg_row\[1\].g_col\[0\].pe__1865_ g_row\[1\].g_col\[0\].pe__1899_/A g_row\[1\].g_col\[0\].pe__1899_/B
+ VGND VGND VPWR VPWR g_row\[1\].g_col\[0\].pe__1868_/A sky130_fd_sc_hd__xor2_2
XFILLER_51_3 VGND VGND VPWR VPWR sky130_fd_sc_hd__decap_3
XFILLER_69_501 VGND VGND VPWR VPWR sky130_fd_sc_hd__decap_3
Xg_row\[1\].g_col\[0\].pe__1796_ g_row\[1\].g_col\[0\].pe__1796_/A g_row\[1\].g_col\[0\].pe__1796_/B
+ VGND VGND VPWR VPWR g_row\[1\].g_col\[0\].pe__1797_/B sky130_fd_sc_hd__or2_2
Xhold2418 _137_/Y VGND VGND VPWR VPWR hold2418/X sky130_fd_sc_hd__clkbuf_2
Xg_row\[1\].g_col\[1\].pe__2502_ g_row\[1\].g_col\[1\].pe__2551_/A g_row\[1\].g_col\[1\].pe__2558_/B
+ g_row\[1\].g_col\[1\].pe__2546_/B g_row\[1\].g_col\[1\].pe__2502_/D VGND VGND VPWR
+ VPWR g_row\[1\].g_col\[1\].pe__2502_/X sky130_fd_sc_hd__and4_2
XFILLER_69_578 VGND VGND VPWR VPWR sky130_fd_sc_hd__decap_3
Xg_row\[0\].g_col\[0\].pe__1943_ g_row\[0\].g_col\[0\].pe__1951_/A g_row\[0\].g_col\[0\].pe__1951_/B
+ VGND VGND VPWR VPWR g_row\[0\].g_col\[0\].pe__2151_/A sky130_fd_sc_hd__xnor2_2
Xhold2429 hold3178/X VGND VGND VPWR VPWR _205_/B_N sky130_fd_sc_hd__clkbuf_2
XFILLER_57_729 VGND VGND VPWR VPWR sky130_fd_sc_hd__fill_1
Xg_row\[0\].g_col\[0\].pe__1874_ g_row\[0\].g_col\[0\].pe__1874_/A g_row\[0\].g_col\[0\].pe__1874_/B
+ VGND VGND VPWR VPWR g_row\[0\].g_col\[0\].pe__1932_/B sky130_fd_sc_hd__xor2_2
Xg_row\[1\].g_col\[1\].pe__2433_ g_row\[1\].g_col\[1\].pe__2474_/B g_row\[1\].g_col\[1\].pe__2766_/Q
+ VGND VGND VPWR VPWR g_row\[1\].g_col\[1\].pe__2487_/B sky130_fd_sc_hd__and2b_2
Xg_row\[1\].g_col\[0\].pe__2417_ g_row\[1\].g_col\[0\].pe__2754_/Q g_row\[1\].g_col\[0\].pe__2266_/Y
+ g_row\[1\].g_col\[0\].pe__2434_/B VGND VGND VPWR VPWR g_row\[1\].g_col\[0\].pe__2432_/B
+ sky130_fd_sc_hd__o21ai_2
Xg_row\[0\].g_col\[1\].pe__1890_ g_row\[0\].g_col\[1\].pe__1894_/A g_row\[0\].g_col\[1\].pe__1894_/B
+ VGND VGND VPWR VPWR g_row\[0\].g_col\[1\].pe__1891_/B sky130_fd_sc_hd__xor2_2
XFILLER_37_420 VGND VGND VPWR VPWR sky130_fd_sc_hd__decap_3
Xg_row\[1\].g_col\[1\].pe__2364_ g_row\[1\].g_col\[1\].pe__2364_/A g_row\[1\].g_col\[1\].pe__2364_/B
+ VGND VGND VPWR VPWR g_row\[1\].g_col\[1\].pe__2365_/B sky130_fd_sc_hd__xnor2_2
XFILLER_25_615 VGND VGND VPWR VPWR sky130_fd_sc_hd__fill_1
Xg_row\[1\].g_col\[0\].pe__2348_ g_row\[1\].g_col\[0\].pe__2348_/A g_row\[1\].g_col\[0\].pe__2348_/B
+ VGND VGND VPWR VPWR g_row\[1\].g_col\[0\].pe__2349_/B sky130_fd_sc_hd__nand2_2
Xg_row\[1\].g_col\[1\].pe__2295_ g_row\[1\].g_col\[1\].pe__2295_/A g_row\[1\].g_col\[1\].pe__2295_/B
+ g_row\[1\].g_col\[1\].pe__2292_/X VGND VGND VPWR VPWR g_row\[1\].g_col\[1\].pe__2296_/B
+ sky130_fd_sc_hd__or3b_2
Xg_row\[1\].g_col\[0\].pe__2279_ g_row\[1\].g_col\[0\].pe__2121_/A g_row\[1\].g_col\[0\].pe__2313_/A2
+ g_row\[1\].g_col\[0\].pe__1541_/X g_row\[1\].g_col\[0\].pe__1965_/A VGND VGND VPWR
+ VPWR g_row\[1\].g_col\[0\].pe__2280_/B sky130_fd_sc_hd__a22o_2
XFILLER_52_489 VGND VGND VPWR VPWR sky130_fd_sc_hd__decap_3
Xg_row\[0\].g_col\[0\].pe__2426_ g_row\[0\].g_col\[0\].pe__2752_/Q g_row\[0\].g_col\[0\].pe__2426_/B
+ VGND VGND VPWR VPWR g_row\[0\].g_col\[0\].pe__2427_/B sky130_fd_sc_hd__xor2_2
Xg_row\[0\].g_col\[1\].pe__2442_ g_row\[0\].g_col\[1\].pe__2443_/B g_row\[0\].g_col\[1\].pe__2762_/Q
+ VGND VGND VPWR VPWR g_row\[0\].g_col\[1\].pe__2444_/A sky130_fd_sc_hd__and2b_2
XANTENNA_10 a_inputs_flat[25] VGND VGND VPWR VPWR sky130_fd_sc_hd__diode_2
XANTENNA_21 b_inputs_flat[22] VGND VGND VPWR VPWR sky130_fd_sc_hd__diode_2
XANTENNA_32 _209_/Y VGND VGND VPWR VPWR sky130_fd_sc_hd__diode_2
Xg_row\[0\].g_col\[0\].pe__2357_ g_row\[0\].g_col\[0\].pe__2329_/A g_row\[0\].g_col\[0\].pe__2330_/X
+ g_row\[0\].g_col\[0\].pe__2329_/B VGND VGND VPWR VPWR g_row\[0\].g_col\[0\].pe__2358_/B
+ sky130_fd_sc_hd__a21o_2
Xg_row\[0\].g_col\[1\].pe__2373_ g_row\[0\].g_col\[1\].pe__2337_/B g_row\[0\].g_col\[1\].pe__2368_/B
+ g_row\[0\].g_col\[1\].pe__2350_/B g_row\[0\].g_col\[1\].pe__2350_/A VGND VGND VPWR
+ VPWR g_row\[0\].g_col\[1\].pe__2385_/B sky130_fd_sc_hd__a22o_2
XANTENNA_43 ANTENNA_43/DIODE VGND VGND VPWR VPWR sky130_fd_sc_hd__diode_2
XANTENNA_54 hold3370/A VGND VGND VPWR VPWR sky130_fd_sc_hd__diode_2
XANTENNA_65 _324_/D VGND VGND VPWR VPWR sky130_fd_sc_hd__diode_2
XANTENNA_76 hold3209/X VGND VGND VPWR VPWR sky130_fd_sc_hd__diode_2
XANTENNA_87 hold3275/X VGND VGND VPWR VPWR sky130_fd_sc_hd__diode_2
XANTENNA_98 hold3553/X VGND VGND VPWR VPWR sky130_fd_sc_hd__diode_2
Xg_row\[0\].g_col\[0\].pe__2288_ g_row\[0\].g_col\[0\].pe__2288_/A g_row\[0\].g_col\[0\].pe__2288_/B
+ VGND VGND VPWR VPWR g_row\[0\].g_col\[0\].pe__2288_/Y sky130_fd_sc_hd__nand2_2
XFILLER_88_810 VGND VGND VPWR VPWR sky130_fd_sc_hd__fill_2
XTAP_TAPCELL_ROW_7_313 VGND VPWR sky130_fd_sc_hd__tapvpwrvgnd_1
Xg_row\[0\].g_col\[1\].pe_hold2031 g_row\[0\].g_col\[1\].pe__2769_/Q VGND VGND VPWR
+ VPWR g_row\[0\].g_col\[1\].pe__2587_/A1 sky130_fd_sc_hd__clkbuf_2
Xg_row\[0\].g_col\[1\].pe__2709_ clkbuf_leaf_95_clk/X g_row\[0\].g_col\[1\].pe__2709_/D
+ VGND VGND VPWR VPWR hold3057/A sky130_fd_sc_hd__dfxtp_2
XFILLER_15_147 VGND VGND VPWR VPWR sky130_fd_sc_hd__fill_2
XFILLER_15_169 VGND VGND VPWR VPWR sky130_fd_sc_hd__fill_2
XFILLER_70_253 VGND VGND VPWR VPWR sky130_fd_sc_hd__fill_1
XFILLER_71_754 VGND VGND VPWR VPWR sky130_fd_sc_hd__decap_3
Xg_row\[1\].g_col\[0\].pe__1650_ g_row\[1\].g_col\[0\].pe__1650_/A g_row\[1\].g_col\[0\].pe__1650_/B
+ VGND VGND VPWR VPWR g_row\[1\].g_col\[0\].pe__1660_/B sky130_fd_sc_hd__xnor2_2
XFILLER_3_574 VGND VGND VPWR VPWR sky130_fd_sc_hd__fill_2
XFILLER_3_596 VGND VGND VPWR VPWR sky130_fd_sc_hd__decap_3
Xclkbuf_4_9_0_clk clkbuf_0_clk/X VGND VGND VPWR VPWR clkload4/A sky130_fd_sc_hd__clkbuf_16
Xg_row\[1\].g_col\[0\].pe__1581_ g_row\[1\].g_col\[0\].pe__1523_/A g_row\[1\].g_col\[0\].pe__1523_/B
+ g_row\[1\].g_col\[0\].pe__1580_/X VGND VGND VPWR VPWR g_row\[1\].g_col\[0\].pe__1582_/B
+ sky130_fd_sc_hd__a21oi_2
XFILLER_39_729 VGND VGND VPWR VPWR sky130_fd_sc_hd__fill_1
XFILLER_66_504 VGND VGND VPWR VPWR sky130_fd_sc_hd__fill_1
XFILLER_66_526 VGND VGND VPWR VPWR sky130_fd_sc_hd__decap_3
Xg_row\[1\].g_col\[0\].pe_hold1937 g_row\[1\].g_col\[0\].pe__2455_/A VGND VGND VPWR
+ VPWR g_row\[1\].g_col\[0\].pe__1947_/B1 sky130_fd_sc_hd__clkbuf_2
Xg_row\[1\].g_col\[0\].pe_hold1926 g_row\[1\].g_col\[0\].pe__1893_/Y VGND VGND VPWR
+ VPWR g_row\[1\].g_col\[0\].pe__2740_/D sky130_fd_sc_hd__clkbuf_2
Xg_row\[1\].g_col\[0\].pe_hold1915 g_row\[1\].g_col\[0\].pe__2745_/Q VGND VGND VPWR
+ VPWR g_row\[1\].g_col\[0\].pe__2116_/A sky130_fd_sc_hd__clkbuf_2
Xg_row\[1\].g_col\[0\].pe_hold1904 g_row\[1\].g_col\[0\].pe_hold2818/X VGND VGND VPWR
+ VPWR g_row\[1\].g_col\[0\].pe__2708_/D sky130_fd_sc_hd__clkbuf_2
Xg_row\[1\].g_col\[0\].pe__2202_ g_row\[1\].g_col\[0\].pe__2202_/A g_row\[1\].g_col\[0\].pe__2202_/B
+ VGND VGND VPWR VPWR g_row\[1\].g_col\[0\].pe__2238_/A sky130_fd_sc_hd__nor2_2
XFILLER_93_389 VGND VGND VPWR VPWR sky130_fd_sc_hd__decap_3
XTAP_TAPCELL_ROW_66_1202 VGND VPWR sky130_fd_sc_hd__tapvpwrvgnd_1
XFILLER_46_283 VGND VGND VPWR VPWR sky130_fd_sc_hd__decap_3
Xg_row\[0\].g_col\[0\].pe__1590_ g_row\[0\].g_col\[0\].pe__1594_/A g_row\[0\].g_col\[0\].pe__1594_/B
+ VGND VGND VPWR VPWR g_row\[0\].g_col\[0\].pe__1591_/B sky130_fd_sc_hd__xor2_2
Xg_row\[1\].g_col\[0\].pe__2133_ g_row\[1\].g_col\[0\].pe__2184_/C g_row\[1\].g_col\[0\].pe__2184_/B
+ g_row\[1\].g_col\[0\].pe__2222_/A VGND VGND VPWR VPWR g_row\[1\].g_col\[0\].pe__2135_/A
+ sky130_fd_sc_hd__a21bo_2
XFILLER_34_445 VGND VGND VPWR VPWR sky130_fd_sc_hd__decap_3
XFILLER_62_754 VGND VGND VPWR VPWR sky130_fd_sc_hd__fill_2
Xg_row\[1\].g_col\[1\].pe__2080_ g_row\[1\].g_col\[1\].pe__1449_/A g_row\[1\].g_col\[1\].pe__1449_/B
+ g_row\[1\].g_col\[1\].pe__1983_/Y VGND VGND VPWR VPWR g_row\[1\].g_col\[1\].pe__2081_/C
+ sky130_fd_sc_hd__a21o_2
Xg_row\[1\].g_col\[0\].pe__2688__1426 VGND VGND VPWR VPWR g_row\[1\].g_col\[0\].pe__2688__1426/HI
+ g_row\[1\].g_col\[0\].pe__2688_/CIN sky130_fd_sc_hd__conb_1
Xg_row\[1\].g_col\[0\].pe__2064_ g_row\[1\].g_col\[0\].pe__2514_/A g_row\[1\].g_col\[0\].pe__2064_/B
+ VGND VGND VPWR VPWR g_row\[1\].g_col\[0\].pe__2064_/Y sky130_fd_sc_hd__nor2_2
XFILLER_15_670 VGND VGND VPWR VPWR sky130_fd_sc_hd__fill_2
XFILLER_30_640 VGND VGND VPWR VPWR sky130_fd_sc_hd__decap_3
Xg_row\[0\].g_col\[0\].pe__2211_ g_row\[0\].g_col\[0\].pe__2211_/A VGND VGND VPWR
+ VPWR g_row\[0\].g_col\[0\].pe__2253_/B sky130_fd_sc_hd__inv_2
Xg_row\[0\].g_col\[0\].pe__2142_ g_row\[0\].g_col\[0\].pe__2142_/A g_row\[0\].g_col\[0\].pe__2187_/B
+ VGND VGND VPWR VPWR g_row\[0\].g_col\[0\].pe__2143_/B sky130_fd_sc_hd__xnor2_2
XTAP_TAPCELL_ROW_12_392 VGND VPWR sky130_fd_sc_hd__tapvpwrvgnd_1
Xg_row\[0\].g_col\[0\].pe__2073_ place1210/A g_row\[0\].g_col\[0\].pe__2278_/A2 g_row\[0\].g_col\[0\].pe__2278_/B1
+ place1212/A VGND VGND VPWR VPWR g_row\[0\].g_col\[0\].pe__2136_/A sky130_fd_sc_hd__a22o_2
Xg_row\[1\].g_col\[1\].pe__1933_ g_row\[1\].g_col\[1\].pe__1878_/A g_row\[1\].g_col\[1\].pe__1878_/B
+ g_row\[1\].g_col\[1\].pe__1932_/X VGND VGND VPWR VPWR g_row\[1\].g_col\[1\].pe__1999_/B
+ sky130_fd_sc_hd__a21oi_2
XTAP_TAPCELL_ROW_77_1364 VGND VPWR sky130_fd_sc_hd__tapvpwrvgnd_1
Xg_row\[1\].g_col\[0\].pe__1917_ g_row\[1\].g_col\[0\].pe__2726_/Q g_row\[1\].g_col\[0\].pe__2682_/A
+ VGND VGND VPWR VPWR g_row\[1\].g_col\[0\].pe__2094_/B sky130_fd_sc_hd__or2_2
Xg_row\[1\].g_col\[1\].pe__1864_ g_row\[1\].g_col\[1\].pe__2165_/A g_row\[1\].g_col\[1\].pe__1864_/B
+ VGND VGND VPWR VPWR g_row\[1\].g_col\[1\].pe__1899_/B sky130_fd_sc_hd__xnor2_2
Xg_row\[1\].g_col\[0\].pe__1848_ g_row\[1\].g_col\[0\].pe__1606_/A g_row\[1\].g_col\[0\].pe__1848_/B
+ VGND VGND VPWR VPWR g_row\[1\].g_col\[0\].pe__1850_/A sky130_fd_sc_hd__and2b_2
Xg_row\[1\].g_col\[1\].pe__1795_ g_row\[1\].g_col\[1\].pe__1795_/A g_row\[1\].g_col\[1\].pe__1795_/B
+ g_row\[1\].g_col\[1\].pe__1795_/C VGND VGND VPWR VPWR g_row\[1\].g_col\[1\].pe__1811_/B
+ sky130_fd_sc_hd__and3_2
Xg_row\[1\].g_col\[0\].pe__1779_ g_row\[1\].g_col\[0\].pe__1813_/A g_row\[1\].g_col\[0\].pe__1813_/B
+ VGND VGND VPWR VPWR g_row\[1\].g_col\[0\].pe__1779_/Y sky130_fd_sc_hd__nor2_2
XTAP_TAPCELL_ROW_90_1553 VGND VPWR sky130_fd_sc_hd__tapvpwrvgnd_1
XTAP_TAPCELL_ROW_90_1564 VGND VPWR sky130_fd_sc_hd__tapvpwrvgnd_1
XFILLER_29_217 VGND VGND VPWR VPWR sky130_fd_sc_hd__decap_3
Xg_row\[0\].g_col\[0\].pe__1926_ g_row\[0\].g_col\[0\].pe__1980_/B g_row\[0\].g_col\[0\].pe__1980_/C
+ VGND VGND VPWR VPWR g_row\[0\].g_col\[0\].pe__1927_/B sky130_fd_sc_hd__or2_4
Xhold1503 hold2562/X VGND VGND VPWR VPWR hold2563/A sky130_fd_sc_hd__clkbuf_2
Xhold1514 hold3359/X VGND VGND VPWR VPWR hold3360/A sky130_fd_sc_hd__clkbuf_2
Xhold1525 hold3341/X VGND VGND VPWR VPWR hold3342/A sky130_fd_sc_hd__clkbuf_2
Xg_row\[0\].g_col\[1\].pe__1942_ g_row\[0\].g_col\[1\].pe__2005_/A g_row\[0\].g_col\[1\].pe__1942_/B
+ VGND VGND VPWR VPWR g_row\[0\].g_col\[1\].pe__1951_/B sky130_fd_sc_hd__nor2_2
XFILLER_84_345 VGND VGND VPWR VPWR sky130_fd_sc_hd__fill_1
Xhold1536 hold2604/X VGND VGND VPWR VPWR hold2605/A sky130_fd_sc_hd__clkbuf_2
Xhold1547 hold3450/X VGND VGND VPWR VPWR hold3451/A sky130_fd_sc_hd__clkbuf_2
Xhold1558 hold3488/X VGND VGND VPWR VPWR hold3489/A sky130_fd_sc_hd__clkbuf_2
Xg_row\[1\].g_col\[1\].pe__2416_ g_row\[1\].g_col\[1\].pe__2450_/A1 g_row\[1\].g_col\[1\].pe__2747_/Q
+ g_row\[1\].g_col\[1\].pe__2436_/B VGND VGND VPWR VPWR g_row\[1\].g_col\[1\].pe__2434_/B
+ sky130_fd_sc_hd__a21oi_2
Xg_row\[0\].g_col\[1\].pe__1873_ g_row\[0\].g_col\[1\].pe__2094_/A g_row\[0\].g_col\[1\].pe__1873_/B
+ VGND VGND VPWR VPWR g_row\[0\].g_col\[1\].pe__1874_/B sky130_fd_sc_hd__xor2_2
XFILLER_38_773 VGND VGND VPWR VPWR sky130_fd_sc_hd__fill_1
Xg_row\[0\].g_col\[0\].pe__1857_ g_row\[0\].g_col\[0\].pe__1857_/A g_row\[0\].g_col\[0\].pe__1857_/B
+ VGND VGND VPWR VPWR g_row\[0\].g_col\[0\].pe__1858_/B sky130_fd_sc_hd__or2_2
Xhold1569 hold2658/X VGND VGND VPWR VPWR hold2659/A sky130_fd_sc_hd__clkbuf_2
Xg_row\[0\].g_col\[0\].pe__1788_ g_row\[0\].g_col\[0\].pe__1789_/A g_row\[0\].g_col\[0\].pe__1789_/B
+ VGND VGND VPWR VPWR g_row\[0\].g_col\[0\].pe__1795_/B sky130_fd_sc_hd__nand2_2
Xg_row\[1\].g_col\[1\].pe__2347_ g_row\[1\].g_col\[1\].pe__2347_/A g_row\[1\].g_col\[1\].pe__2347_/B
+ VGND VGND VPWR VPWR g_row\[1\].g_col\[1\].pe__2368_/B sky130_fd_sc_hd__xor2_2
Xg_row\[1\].g_col\[0\].pe_place919 g_row\[1\].g_col\[0\].pe__2026_/B VGND VGND VPWR
+ VPWR g_row\[1\].g_col\[0\].pe__1748_/B sky130_fd_sc_hd__buf_6
Xg_row\[1\].g_col\[0\].pe_place908 g_row\[1\].g_col\[0\].pe__2591_/A2 VGND VGND VPWR
+ VPWR g_row\[1\].g_col\[0\].pe__2560_/A2 sky130_fd_sc_hd__buf_6
XFILLER_25_456 VGND VGND VPWR VPWR sky130_fd_sc_hd__decap_3
XFILLER_52_253 VGND VGND VPWR VPWR sky130_fd_sc_hd__decap_3
Xg_row\[1\].g_col\[1\].pe__2278_ g_row\[1\].g_col\[1\].pe__2030_/A g_row\[1\].g_col\[1\].pe__2363_/A2
+ g_row\[1\].g_col\[1\].pe__2388_/B g_row\[1\].g_col\[1\].pe__2278_/B2 VGND VGND VPWR
+ VPWR g_row\[1\].g_col\[1\].pe__2311_/A sky130_fd_sc_hd__a22o_2
XFILLER_80_584 VGND VGND VPWR VPWR sky130_fd_sc_hd__decap_3
Xg_row\[1\].g_col\[0\].pe_place1063 g_row\[1\].g_col\[0\].pe_hold3070/X VGND VGND
+ VPWR VPWR g_row\[1\].g_col\[0\].pe__2167_/A sky130_fd_sc_hd__buf_6
XFILLER_12_128 VGND VGND VPWR VPWR sky130_fd_sc_hd__fill_2
XFILLER_40_448 VGND VGND VPWR VPWR sky130_fd_sc_hd__fill_1
Xg_row\[1\].g_col\[0\].pe_place1074 g_row\[1\].g_col\[0\].pe__2724_/Q VGND VGND VPWR
+ VPWR g_row\[1\].g_col\[0\].pe__2682_/A sky130_fd_sc_hd__buf_6
Xg_row\[0\].g_col\[1\].pe__2425_ g_row\[0\].g_col\[1\].pe__2425_/A g_row\[0\].g_col\[1\].pe__2425_/B
+ VGND VGND VPWR VPWR g_row\[0\].g_col\[1\].pe__2508_/A sky130_fd_sc_hd__nor2_2
XFILLER_21_673 VGND VGND VPWR VPWR sky130_fd_sc_hd__decap_3
XTAP_TAPCELL_ROW_51_977 VGND VPWR sky130_fd_sc_hd__tapvpwrvgnd_1
Xg_row\[0\].g_col\[0\].pe__2409_ g_row\[0\].g_col\[0\].pe__2775_/A g_row\[0\].g_col\[0\].pe__2410_/B
+ VGND VGND VPWR VPWR g_row\[0\].g_col\[0\].pe__2519_/A sky130_fd_sc_hd__nor2_2
XFILLER_5_806 VGND VGND VPWR VPWR sky130_fd_sc_hd__decap_3
Xg_row\[0\].g_col\[1\].pe__2356_ g_row\[0\].g_col\[1\].pe__2356_/A g_row\[0\].g_col\[1\].pe__2356_/B
+ VGND VGND VPWR VPWR g_row\[0\].g_col\[1\].pe__2377_/A sky130_fd_sc_hd__nor2_2
XFILLER_20_194 VGND VGND VPWR VPWR sky130_fd_sc_hd__fill_2
XFILLER_5_839 VGND VGND VPWR VPWR sky130_fd_sc_hd__fill_1
Xg_row\[0\].g_col\[1\].pe__2287_ g_row\[0\].g_col\[1\].pe__2287_/A g_row\[0\].g_col\[1\].pe__2309_/B
+ VGND VGND VPWR VPWR g_row\[0\].g_col\[1\].pe__2291_/A sky130_fd_sc_hd__xnor2_2
Xhold3461 hold3461/A VGND VGND VPWR VPWR hold3461/X sky130_fd_sc_hd__clkbuf_2
Xhold3450 hold3450/A VGND VGND VPWR VPWR hold3450/X sky130_fd_sc_hd__clkbuf_2
XFILLER_75_301 VGND VGND VPWR VPWR sky130_fd_sc_hd__fill_1
XFILLER_76_824 VGND VGND VPWR VPWR sky130_fd_sc_hd__decap_3
Xhold3494 b_inputs_flat[5] VGND VGND VPWR VPWR hold3494/X sky130_fd_sc_hd__clkbuf_2
Xhold3483 hold3483/A VGND VGND VPWR VPWR hold3483/X sky130_fd_sc_hd__clkbuf_2
Xhold3472 hold3472/A VGND VGND VPWR VPWR hold3472/X sky130_fd_sc_hd__clkbuf_2
Xhold2760 _195_/Y VGND VGND VPWR VPWR hold2760/X sky130_fd_sc_hd__clkbuf_2
Xhold2771 hold2771/A VGND VGND VPWR VPWR _191_/B_N sky130_fd_sc_hd__clkbuf_2
Xhold2782 hold3563/X VGND VGND VPWR VPWR hold3564/A sky130_fd_sc_hd__clkbuf_2
Xhold2793 hold3579/X VGND VGND VPWR VPWR hold3580/A sky130_fd_sc_hd__clkbuf_2
XFILLER_56_592 VGND VGND VPWR VPWR sky130_fd_sc_hd__decap_3
XFILLER_75_389 VGND VGND VPWR VPWR sky130_fd_sc_hd__decap_3
XFILLER_43_242 VGND VGND VPWR VPWR sky130_fd_sc_hd__fill_2
XFILLER_73_53 VGND VGND VPWR VPWR sky130_fd_sc_hd__decap_3
XFILLER_90_359 VGND VGND VPWR VPWR sky130_fd_sc_hd__fill_1
XTAP_TAPCELL_ROW_39_790 VGND VPWR sky130_fd_sc_hd__tapvpwrvgnd_1
XFILLER_71_573 VGND VGND VPWR VPWR sky130_fd_sc_hd__decap_3
XTAP_TAPCELL_ROW_61_1121 VGND VPWR sky130_fd_sc_hd__tapvpwrvgnd_1
XTAP_TAPCELL_ROW_61_1132 VGND VPWR sky130_fd_sc_hd__tapvpwrvgnd_1
Xg_row\[1\].g_col\[0\].pe__2751_ clkbuf_leaf_54_clk/X g_row\[1\].g_col\[0\].pe__2751_/D
+ VGND VGND VPWR VPWR g_row\[1\].g_col\[0\].pe__2751_/Q sky130_fd_sc_hd__dfxtp_2
Xg_row\[1\].g_col\[0\].pe__2682_ g_row\[1\].g_col\[0\].pe__2682_/A g_row\[1\].g_col\[0\].pe__2686_/B
+ VGND VGND VPWR VPWR g_row\[1\].g_col\[0\].pe__2682_/X sky130_fd_sc_hd__or2_2
Xg_row\[1\].g_col\[0\].pe__1702_ g_row\[1\].g_col\[0\].pe__1831_/A g_row\[1\].g_col\[0\].pe__1831_/B
+ g_row\[1\].g_col\[0\].pe__1827_/A g_row\[1\].g_col\[0\].pe__1827_/B VGND VGND VPWR
+ VPWR g_row\[1\].g_col\[0\].pe__1702_/X sky130_fd_sc_hd__o22a_2
XTAP_TAPCELL_ROW_59_1094 VGND VPWR sky130_fd_sc_hd__tapvpwrvgnd_1
Xg_row\[1\].g_col\[0\].pe__1633_ g_row\[1\].g_col\[0\].pe__1633_/A g_row\[1\].g_col\[0\].pe__1633_/B
+ VGND VGND VPWR VPWR g_row\[1\].g_col\[0\].pe__1845_/B sky130_fd_sc_hd__xor2_2
Xg_row\[1\].g_col\[1\].pe__1580_ g_row\[1\].g_col\[1\].pe__1580_/A g_row\[1\].g_col\[1\].pe__1580_/B
+ VGND VGND VPWR VPWR g_row\[1\].g_col\[1\].pe__1580_/X sky130_fd_sc_hd__and2_2
XFILLER_79_662 VGND VGND VPWR VPWR sky130_fd_sc_hd__decap_3
XFILLER_79_673 VGND VGND VPWR VPWR sky130_fd_sc_hd__decap_3
XTAP_TAPCELL_ROW_72_1283 VGND VPWR sky130_fd_sc_hd__tapvpwrvgnd_1
XTAP_TAPCELL_ROW_72_1294 VGND VPWR sky130_fd_sc_hd__tapvpwrvgnd_1
Xg_row\[1\].g_col\[0\].pe__1564_ place1090/X g_row\[1\].g_col\[0\].pe__2026_/B g_row\[1\].g_col\[0\].pe__1738_/B1
+ place1092/A VGND VGND VPWR VPWR g_row\[1\].g_col\[0\].pe__1565_/B sky130_fd_sc_hd__a22o_2
XFILLER_14_3 VGND VGND VPWR VPWR sky130_fd_sc_hd__fill_1
Xg_row\[0\].g_col\[0\].pe__2760_ clkbuf_leaf_35_clk/X g_row\[0\].g_col\[0\].pe__2760_/D
+ VGND VGND VPWR VPWR g_row\[0\].g_col\[0\].pe__2760_/Q sky130_fd_sc_hd__dfxtp_2
Xg_row\[1\].g_col\[0\].pe_hold1745 g_row\[1\].g_col\[0\].pe__2587_/X VGND VGND VPWR
+ VPWR g_row\[1\].g_col\[0\].pe__2588_/B sky130_fd_sc_hd__clkbuf_2
Xg_row\[1\].g_col\[0\].pe_hold1734 g_row\[1\].g_col\[0\].pe__2767_/Q VGND VGND VPWR
+ VPWR g_row\[1\].g_col\[0\].pe__2576_/A1 sky130_fd_sc_hd__clkbuf_2
Xg_row\[1\].g_col\[0\].pe__1495_ g_row\[1\].g_col\[0\].pe__1864_/A g_row\[1\].g_col\[0\].pe__1495_/B
+ VGND VGND VPWR VPWR g_row\[1\].g_col\[0\].pe__1536_/B sky130_fd_sc_hd__xnor2_2
Xg_row\[0\].g_col\[0\].pe__1711_ g_row\[0\].g_col\[0\].pe__1733_/A g_row\[0\].g_col\[0\].pe__1711_/B
+ VGND VGND VPWR VPWR g_row\[0\].g_col\[0\].pe__1736_/B sky130_fd_sc_hd__xor2_2
Xg_row\[0\].g_col\[0\].pe__2691_ clkbuf_leaf_14_clk/X g_row\[0\].g_col\[0\].pe__2691_/D
+ VGND VGND VPWR VPWR hold2363/A sky130_fd_sc_hd__dfxtp_2
Xg_row\[1\].g_col\[0\].pe_hold1756 g_row\[1\].g_col\[0\].pe__2764_/Q VGND VGND VPWR
+ VPWR g_row\[1\].g_col\[0\].pe__2564_/A1 sky130_fd_sc_hd__clkbuf_2
XFILLER_35_710 VGND VGND VPWR VPWR sky130_fd_sc_hd__fill_1
XFILLER_54_529 VGND VGND VPWR VPWR sky130_fd_sc_hd__decap_3
XFILLER_93_197 VGND VGND VPWR VPWR sky130_fd_sc_hd__fill_2
Xg_row\[0\].g_col\[0\].pe__1642_ g_row\[0\].g_col\[0\].pe__1705_/A g_row\[0\].g_col\[0\].pe__1642_/B
+ VGND VGND VPWR VPWR g_row\[0\].g_col\[0\].pe__1648_/A sky130_fd_sc_hd__xnor2_2
Xg_row\[1\].g_col\[1\].pe__2201_ g_row\[1\].g_col\[1\].pe__2155_/B g_row\[1\].g_col\[1\].pe__2300_/A
+ g_row\[1\].g_col\[1\].pe__2299_/A VGND VGND VPWR VPWR g_row\[1\].g_col\[1\].pe__2233_/A
+ sky130_fd_sc_hd__a21o_2
Xg_row\[1\].g_col\[0\].pe_hold1789 g_row\[1\].g_col\[0\].pe_hold2896/X VGND VGND VPWR
+ VPWR g_row\[1\].g_col\[0\].pe__2699_/D sky130_fd_sc_hd__clkbuf_2
XFILLER_81_348 VGND VGND VPWR VPWR sky130_fd_sc_hd__fill_1
Xg_row\[0\].g_col\[0\].pe__1573_ g_row\[0\].g_col\[0\].pe__1705_/A g_row\[0\].g_col\[0\].pe__1573_/B
+ VGND VGND VPWR VPWR g_row\[0\].g_col\[0\].pe__1626_/A sky130_fd_sc_hd__xnor2_2
Xg_row\[1\].g_col\[1\].pe__2132_ g_row\[1\].g_col\[1\].pe__2132_/A g_row\[1\].g_col\[1\].pe__2132_/B
+ VGND VGND VPWR VPWR g_row\[1\].g_col\[1\].pe__2222_/A sky130_fd_sc_hd__xnor2_2
Xg_row\[1\].g_col\[0\].pe__2116_ g_row\[1\].g_col\[0\].pe__2116_/A VGND VGND VPWR
+ VPWR g_row\[1\].g_col\[0\].pe__2116_/Y sky130_fd_sc_hd__inv_2
XFILLER_34_253 VGND VGND VPWR VPWR sky130_fd_sc_hd__decap_3
XFILLER_62_584 VGND VGND VPWR VPWR sky130_fd_sc_hd__decap_3
XTAP_TAPCELL_ROW_17_462 VGND VPWR sky130_fd_sc_hd__tapvpwrvgnd_1
XFILLER_34_286 VGND VGND VPWR VPWR sky130_fd_sc_hd__fill_1
XFILLER_50_757 VGND VGND VPWR VPWR sky130_fd_sc_hd__fill_1
Xg_row\[1\].g_col\[1\].pe__2063_ g_row\[1\].g_col\[1\].pe__2157_/A g_row\[1\].g_col\[1\].pe__2061_/Y
+ g_row\[1\].g_col\[1\].pe__2062_/X g_row\[1\].g_col\[1\].pe__2063_/B1 g_row\[1\].g_col\[1\].pe__1950_/A
+ VGND VGND VPWR VPWR g_row\[1\].g_col\[1\].pe__2063_/Y sky130_fd_sc_hd__a32oi_2
Xg_row\[1\].g_col\[0\].pe__2047_ g_row\[1\].g_col\[0\].pe__2047_/A g_row\[1\].g_col\[0\].pe__2047_/B
+ VGND VGND VPWR VPWR g_row\[1\].g_col\[0\].pe__2048_/C sky130_fd_sc_hd__xor2_2
Xg_row\[0\].g_col\[1\].pe__2210_ g_row\[0\].g_col\[1\].pe__2210_/A g_row\[0\].g_col\[1\].pe__2210_/B
+ VGND VGND VPWR VPWR g_row\[0\].g_col\[1\].pe__2211_/A sky130_fd_sc_hd__xor2_2
XFILLER_30_492 VGND VGND VPWR VPWR sky130_fd_sc_hd__decap_3
Xg_row\[0\].g_col\[0\].pe__2125_ g_row\[0\].g_col\[0\].pe__2125_/A g_row\[0\].g_col\[0\].pe__2729_/Q
+ g_row\[0\].g_col\[0\].pe__2728_/Q VGND VGND VPWR VPWR g_row\[0\].g_col\[0\].pe__2125_/X
+ sky130_fd_sc_hd__or3_2
Xg_row\[0\].g_col\[1\].pe__2141_ g_row\[0\].g_col\[1\].pe__2174_/A g_row\[0\].g_col\[1\].pe__2174_/B
+ VGND VGND VPWR VPWR g_row\[0\].g_col\[1\].pe__2187_/B sky130_fd_sc_hd__xor2_2
Xg_row\[0\].g_col\[1\].pe__2072_ g_row\[0\].g_col\[1\].pe__2038_/B g_row\[0\].g_col\[1\].pe__2038_/C
+ g_row\[0\].g_col\[1\].pe__2038_/A VGND VGND VPWR VPWR g_row\[0\].g_col\[1\].pe__2077_/A
+ sky130_fd_sc_hd__a21boi_2
XFILLER_2_809 VGND VGND VPWR VPWR sky130_fd_sc_hd__decap_3
Xg_row\[0\].g_col\[0\].pe__2056_ g_row\[0\].g_col\[0\].pe__1997_/A g_row\[0\].g_col\[0\].pe__1997_/B
+ g_row\[0\].g_col\[0\].pe__2055_/Y VGND VGND VPWR VPWR g_row\[0\].g_col\[0\].pe__2068_/B
+ sky130_fd_sc_hd__a21oi_2
Xg_row\[1\].g_col\[1\].pe__1916_ g_row\[1\].g_col\[1\].pe__1916_/A g_row\[1\].g_col\[1\].pe__1916_/B
+ VGND VGND VPWR VPWR g_row\[1\].g_col\[1\].pe__1931_/A sky130_fd_sc_hd__xor2_2
Xg_row\[1\].g_col\[1\].pe__1847_ g_row\[1\].g_col\[1\].pe__1847_/A g_row\[1\].g_col\[1\].pe__1847_/B
+ VGND VGND VPWR VPWR g_row\[1\].g_col\[1\].pe__1888_/B sky130_fd_sc_hd__nor2_2
Xhold2045 hold3060/X VGND VGND VPWR VPWR hold2045/X sky130_fd_sc_hd__clkbuf_2
Xg_row\[1\].g_col\[1\].pe__1778_ g_row\[1\].g_col\[1\].pe__1778_/A g_row\[1\].g_col\[1\].pe__1816_/C
+ VGND VGND VPWR VPWR g_row\[1\].g_col\[1\].pe__1813_/B sky130_fd_sc_hd__xnor2_2
XFILLER_85_621 VGND VGND VPWR VPWR sky130_fd_sc_hd__fill_1
Xg_row\[0\].g_col\[1\].pe__1925_ g_row\[0\].g_col\[1\].pe__1924_/B g_row\[0\].g_col\[1\].pe__1924_/C
+ g_row\[0\].g_col\[1\].pe__2094_/A VGND VGND VPWR VPWR g_row\[0\].g_col\[1\].pe__1980_/C
+ sky130_fd_sc_hd__o21a_2
XFILLER_73_805 VGND VGND VPWR VPWR sky130_fd_sc_hd__fill_2
XFILLER_84_164 VGND VGND VPWR VPWR sky130_fd_sc_hd__fill_2
Xg_row\[0\].g_col\[0\].pe__1909_ place1199/X g_row\[0\].g_col\[0\].pe__2026_/B g_row\[0\].g_col\[0\].pe__1449_/Y
+ place1201/A VGND VGND VPWR VPWR g_row\[0\].g_col\[0\].pe__1910_/B sky130_fd_sc_hd__a22o_2
XFILLER_38_581 VGND VGND VPWR VPWR sky130_fd_sc_hd__decap_3
XFILLER_72_337 VGND VGND VPWR VPWR sky130_fd_sc_hd__fill_2
XFILLER_84_197 VGND VGND VPWR VPWR sky130_fd_sc_hd__fill_2
Xg_row\[0\].g_col\[1\].pe__1856_ g_row\[0\].g_col\[1\].pe__1857_/A g_row\[0\].g_col\[1\].pe__1857_/B
+ VGND VGND VPWR VPWR g_row\[0\].g_col\[1\].pe__1908_/A sky130_fd_sc_hd__nand2_2
Xg_row\[0\].g_col\[1\].pe__1787_ g_row\[0\].g_col\[1\].pe__1791_/A g_row\[0\].g_col\[1\].pe__1797_/A
+ VGND VGND VPWR VPWR g_row\[0\].g_col\[1\].pe__1789_/B sky130_fd_sc_hd__xor2_2
XFILLER_25_253 VGND VGND VPWR VPWR sky130_fd_sc_hd__decap_3
XFILLER_25_275 VGND VGND VPWR VPWR sky130_fd_sc_hd__fill_1
XFILLER_13_437 VGND VGND VPWR VPWR sky130_fd_sc_hd__decap_3
XFILLER_40_267 VGND VGND VPWR VPWR sky130_fd_sc_hd__fill_2
XFILLER_40_278 VGND VGND VPWR VPWR sky130_fd_sc_hd__decap_3
XFILLER_43_89 VGND VGND VPWR VPWR sky130_fd_sc_hd__fill_2
XFILLER_21_481 VGND VGND VPWR VPWR sky130_fd_sc_hd__fill_1
Xg_row\[0\].g_col\[1\].pe__2408_ g_row\[0\].g_col\[1\].pe__2739_/Q VGND VGND VPWR
+ VPWR g_row\[0\].g_col\[1\].pe__2410_/B sky130_fd_sc_hd__inv_2
Xg_row\[0\].g_col\[1\].pe__2339_ g_row\[0\].g_col\[1\].pe__2311_/A g_row\[0\].g_col\[1\].pe__2311_/B
+ g_row\[0\].g_col\[1\].pe__2319_/B g_row\[0\].g_col\[1\].pe__2318_/B g_row\[0\].g_col\[1\].pe__2318_/A
+ VGND VGND VPWR VPWR g_row\[0\].g_col\[1\].pe__2350_/A sky130_fd_sc_hd__a32o_2
XFILLER_5_647 VGND VGND VPWR VPWR sky130_fd_sc_hd__decap_3
Xinput1287 hold3308/X VGND VGND VPWR VPWR hold3309/A sky130_fd_sc_hd__buf_2
Xinput1298 hold3518/X VGND VGND VPWR VPWR hold3519/A sky130_fd_sc_hd__buf_2
XFILLER_48_312 VGND VGND VPWR VPWR sky130_fd_sc_hd__decap_3
XFILLER_76_621 VGND VGND VPWR VPWR sky130_fd_sc_hd__decap_3
XFILLER_88_481 VGND VGND VPWR VPWR sky130_fd_sc_hd__decap_3
Xhold3280 hold3280/A VGND VGND VPWR VPWR hold3280/X sky130_fd_sc_hd__clkbuf_2
Xhold3291 b_inputs_flat[30] VGND VGND VPWR VPWR hold3291/X sky130_fd_sc_hd__clkbuf_2
XFILLER_76_687 VGND VGND VPWR VPWR sky130_fd_sc_hd__decap_3
Xhold2590 hold3344/X VGND VGND VPWR VPWR hold3345/A sky130_fd_sc_hd__clkbuf_2
XFILLER_36_529 VGND VGND VPWR VPWR sky130_fd_sc_hd__decap_3
XFILLER_29_592 VGND VGND VPWR VPWR sky130_fd_sc_hd__decap_3
XFILLER_84_85 VGND VGND VPWR VPWR sky130_fd_sc_hd__fill_2
XFILLER_84_96 VGND VGND VPWR VPWR sky130_fd_sc_hd__fill_2
XFILLER_17_776 VGND VGND VPWR VPWR sky130_fd_sc_hd__decap_3
XTAP_TAPCELL_ROW_34_719 VGND VPWR sky130_fd_sc_hd__tapvpwrvgnd_1
XFILLER_31_223 VGND VGND VPWR VPWR sky130_fd_sc_hd__fill_1
XFILLER_44_595 VGND VGND VPWR VPWR sky130_fd_sc_hd__decap_3
XTAP_TAPCELL_ROW_14_421 VGND VPWR sky130_fd_sc_hd__tapvpwrvgnd_1
Xg_row\[1\].g_col\[1\].pe__2750_ clkbuf_leaf_78_clk/X g_row\[1\].g_col\[1\].pe__2750_/D
+ VGND VGND VPWR VPWR g_row\[1\].g_col\[1\].pe__2750_/Q sky130_fd_sc_hd__dfxtp_2
Xg_row\[1\].g_col\[0\].pe__2734_ clkbuf_leaf_46_clk/X g_row\[1\].g_col\[0\].pe__2734_/D
+ VGND VGND VPWR VPWR g_row\[1\].g_col\[0\].pe__2734_/Q sky130_fd_sc_hd__dfxtp_2
XTAP_TAPCELL_ROW_74_1323 VGND VPWR sky130_fd_sc_hd__tapvpwrvgnd_1
Xg_row\[1\].g_col\[1\].pe__2681_ hold2186/X g_row\[1\].g_col\[1\].pe__2680_/B g_row\[1\].g_col\[1\].pe__2680_/Y
+ g_row\[1\].g_col\[1\].pe__2683_/C1 VGND VGND VPWR VPWR g_row\[1\].g_col\[1\].pe__2681_/X
+ sky130_fd_sc_hd__o211a_2
Xg_row\[1\].g_col\[1\].pe__1701_ g_row\[1\].g_col\[1\].pe__1701_/A g_row\[1\].g_col\[1\].pe__1701_/B
+ VGND VGND VPWR VPWR g_row\[1\].g_col\[1\].pe__1827_/B sky130_fd_sc_hd__xnor2_2
Xg_row\[1\].g_col\[1\].pe__1632_ g_row\[1\].g_col\[1\].pe__1883_/A g_row\[1\].g_col\[1\].pe__1883_/B
+ VGND VGND VPWR VPWR g_row\[1\].g_col\[1\].pe__1633_/B sky130_fd_sc_hd__xnor2_2
Xg_row\[1\].g_col\[0\].pe__2665_ g_row\[1\].g_col\[0\].pe__2669_/A g_row\[1\].g_col\[0\].pe__2665_/B
+ VGND VGND VPWR VPWR g_row\[1\].g_col\[0\].pe__2665_/X sky130_fd_sc_hd__or2_2
XFILLER_86_418 VGND VGND VPWR VPWR sky130_fd_sc_hd__fill_2
Xg_row\[1\].g_col\[0\].pe__1616_ hold1989/A g_row\[1\].g_col\[0\].pe__1641_/B2 g_row\[1\].g_col\[0\].pe__2682_/A
+ VGND VGND VPWR VPWR g_row\[1\].g_col\[0\].pe__1875_/A sky130_fd_sc_hd__a21o_2
Xg_row\[1\].g_col\[1\].pe__1563_ g_row\[1\].g_col\[1\].pe__1846_/A g_row\[1\].g_col\[1\].pe__1563_/B
+ VGND VGND VPWR VPWR g_row\[1\].g_col\[1\].pe__1587_/A sky130_fd_sc_hd__or2_2
Xg_row\[1\].g_col\[0\].pe_hold2232 g_row\[1\].g_col\[0\].pe__2336_/Y VGND VGND VPWR
+ VPWR g_row\[1\].g_col\[0\].pe__2360_/A2 sky130_fd_sc_hd__clkbuf_2
Xg_row\[1\].g_col\[0\].pe__1547_ g_row\[1\].g_col\[0\].pe__1547_/A g_row\[1\].g_col\[0\].pe__1547_/B
+ VGND VGND VPWR VPWR g_row\[1\].g_col\[0\].pe__1550_/B sky130_fd_sc_hd__xor2_2
XFILLER_67_665 VGND VGND VPWR VPWR sky130_fd_sc_hd__decap_3
XFILLER_67_676 VGND VGND VPWR VPWR sky130_fd_sc_hd__decap_3
Xg_row\[0\].g_col\[0\].pe__2743_ clkbuf_leaf_25_clk/X g_row\[0\].g_col\[0\].pe__2743_/D
+ VGND VGND VPWR VPWR g_row\[0\].g_col\[0\].pe__2743_/Q sky130_fd_sc_hd__dfxtp_2
Xg_row\[1\].g_col\[1\].pe_place835 g_row\[1\].g_col\[1\].pe__1474_/Y VGND VGND VPWR
+ VPWR g_row\[1\].g_col\[1\].pe__2247_/B1 sky130_fd_sc_hd__buf_6
Xg_row\[1\].g_col\[1\].pe__1494_ g_row\[1\].g_col\[1\].pe__2019_/B2 g_row\[1\].g_col\[1\].pe__1715_/B
+ g_row\[1\].g_col\[1\].pe__1863_/B1 g_row\[1\].g_col\[1\].pe__1957_/B2 VGND VGND
+ VPWR VPWR g_row\[1\].g_col\[1\].pe__1495_/B sky130_fd_sc_hd__a22o_2
XFILLER_66_186 VGND VGND VPWR VPWR sky130_fd_sc_hd__fill_1
Xg_row\[0\].g_col\[1\].pe__1710_ g_row\[0\].g_col\[1\].pe__1782_/A2 g_row\[0\].g_col\[1\].pe__1732_/A2
+ g_row\[0\].g_col\[1\].pe__1732_/B1 g_row\[0\].g_col\[1\].pe__1799_/A2 VGND VGND
+ VPWR VPWR g_row\[0\].g_col\[1\].pe__1711_/B sky130_fd_sc_hd__a22o_2
Xg_row\[1\].g_col\[1\].pe_place879 g_row\[1\].g_col\[1\].pe__2399_/Y VGND VGND VPWR
+ VPWR g_row\[1\].g_col\[1\].pe__2450_/A1 sky130_fd_sc_hd__buf_6
Xg_row\[1\].g_col\[0\].pe__1478_ g_row\[1\].g_col\[0\].pe__1478_/A g_row\[1\].g_col\[0\].pe__1478_/B
+ VGND VGND VPWR VPWR g_row\[1\].g_col\[0\].pe__1662_/B sky130_fd_sc_hd__xor2_2
Xg_row\[0\].g_col\[1\].pe__2690_ clkbuf_leaf_91_clk/X g_row\[0\].g_col\[1\].pe__2690_/D
+ VGND VGND VPWR VPWR g_row\[0\].g_col\[1\].pe__2690_/Q sky130_fd_sc_hd__dfxtp_2
Xg_row\[0\].g_col\[0\].pe__2674_ _314_/Q _313_/Q _316_/Q g_row\[0\].g_col\[0\].pe__2674_/D
+ VGND VGND VPWR VPWR g_row\[0\].g_col\[0\].pe__2674_/X sky130_fd_sc_hd__or4_2
Xg_row\[0\].g_col\[1\].pe__1641_ g_row\[0\].g_col\[1\].pe__1704_/A1 g_row\[0\].g_col\[1\].pe__1911_/A1
+ g_row\[0\].g_col\[1\].pe__2036_/B2 g_row\[0\].g_col\[1\].pe__1704_/B2 VGND VGND
+ VPWR VPWR g_row\[0\].g_col\[1\].pe__1642_/B sky130_fd_sc_hd__a22o_2
XTAP_TAPCELL_ROW_85_1485 VGND VPWR sky130_fd_sc_hd__tapvpwrvgnd_1
Xg_row\[0\].g_col\[0\].pe__1625_ g_row\[0\].g_col\[0\].pe__1625_/A g_row\[0\].g_col\[0\].pe__1625_/B
+ VGND VGND VPWR VPWR g_row\[0\].g_col\[0\].pe__1879_/A sky130_fd_sc_hd__xnor2_2
Xg_row\[0\].g_col\[0\].pe__1556_ place1218/A g_row\[0\].g_col\[0\].pe__1549_/B g_row\[0\].g_col\[0\].pe__1541_/X
+ g_row\[0\].g_col\[0\].pe__1672_/A1 VGND VGND VPWR VPWR g_row\[0\].g_col\[0\].pe__1557_/B
+ sky130_fd_sc_hd__a22o_2
Xg_row\[0\].g_col\[1\].pe__1572_ g_row\[0\].g_col\[1\].pe__1704_/A1 g_row\[0\].g_col\[1\].pe__2163_/A
+ g_row\[0\].g_col\[1\].pe__2703_/Q g_row\[0\].g_col\[1\].pe__1704_/B2 VGND VGND VPWR
+ VPWR g_row\[0\].g_col\[1\].pe__1573_/B sky130_fd_sc_hd__a22o_2
Xg_row\[1\].g_col\[1\].pe__2115_ hold1641/X g_row\[1\].g_col\[1\].pe__2115_/B VGND
+ VGND VPWR VPWR g_row\[1\].g_col\[1\].pe__2115_/Y sky130_fd_sc_hd__nor2_2
Xg_row\[0\].g_col\[0\].pe__1487_ g_row\[0\].g_col\[0\].pe__1514_/A g_row\[0\].g_col\[0\].pe__1514_/B
+ VGND VGND VPWR VPWR g_row\[0\].g_col\[0\].pe__1490_/A sky130_fd_sc_hd__xor2_2
Xg_row\[1\].g_col\[1\].pe__2046_ g_row\[1\].g_col\[1\].pe__2094_/B g_row\[1\].g_col\[1\].pe__1988_/B
+ g_row\[1\].g_col\[1\].pe__1988_/C g_row\[1\].g_col\[1\].pe__2045_/X VGND VGND VPWR
+ VPWR g_row\[1\].g_col\[1\].pe__2047_/B sky130_fd_sc_hd__a31o_2
Xg_row\[0\].g_col\[1\].pe__2124_ g_row\[0\].g_col\[1\].pe__2123_/B g_row\[0\].g_col\[1\].pe__2123_/C
+ g_row\[0\].g_col\[1\].pe__2123_/A VGND VGND VPWR VPWR g_row\[0\].g_col\[1\].pe__2128_/C
+ sky130_fd_sc_hd__a21o_2
Xg_row\[0\].g_col\[0\].pe__2108_ g_row\[0\].g_col\[0\].pe__2117_/A g_row\[0\].g_col\[0\].pe__2117_/B
+ VGND VGND VPWR VPWR g_row\[0\].g_col\[0\].pe__2110_/B sky130_fd_sc_hd__xor2_2
Xg_row\[0\].g_col\[0\].pe__2039_ g_row\[0\].g_col\[0\].pe__2038_/A g_row\[0\].g_col\[0\].pe__2038_/B
+ g_row\[0\].g_col\[0\].pe__2038_/C VGND VGND VPWR VPWR g_row\[0\].g_col\[0\].pe__2048_/B
+ sky130_fd_sc_hd__a21o_2
Xg_row\[0\].g_col\[1\].pe__2055_ g_row\[0\].g_col\[1\].pe__2055_/A g_row\[0\].g_col\[1\].pe__2055_/B
+ VGND VGND VPWR VPWR g_row\[0\].g_col\[1\].pe__2055_/Y sky130_fd_sc_hd__nor2_2
XFILLER_89_223 VGND VGND VPWR VPWR sky130_fd_sc_hd__fill_1
Xplace1195 hold2340/X VGND VGND VPWR VPWR place1195/X sky130_fd_sc_hd__buf_6
XFILLER_58_643 VGND VGND VPWR VPWR sky130_fd_sc_hd__fill_1
XFILLER_45_304 VGND VGND VPWR VPWR sky130_fd_sc_hd__decap_3
Xg_row\[0\].g_col\[1\].pe__1908_ g_row\[0\].g_col\[1\].pe__1908_/A g_row\[0\].g_col\[1\].pe__1908_/B
+ VGND VGND VPWR VPWR g_row\[0\].g_col\[1\].pe__1935_/A sky130_fd_sc_hd__xor2_2
XFILLER_73_679 VGND VGND VPWR VPWR sky130_fd_sc_hd__decap_3
Xg_row\[0\].g_col\[0\].pe_hold2308 g_row\[0\].g_col\[0\].pe_hold2920/X VGND VGND VPWR
+ VPWR g_row\[0\].g_col\[0\].pe_hold2921/A sky130_fd_sc_hd__clkbuf_2
XFILLER_53_381 VGND VGND VPWR VPWR sky130_fd_sc_hd__decap_3
XTAP_TAPCELL_ROW_0_193 VGND VPWR sky130_fd_sc_hd__tapvpwrvgnd_1
Xg_row\[0\].g_col\[0\].pe_hold2319 g_row\[0\].g_col\[0\].pe_hold2949/X VGND VGND VPWR
+ VPWR g_row\[0\].g_col\[0\].pe_hold2950/A sky130_fd_sc_hd__clkbuf_2
XFILLER_14_779 VGND VGND VPWR VPWR sky130_fd_sc_hd__decap_3
Xg_row\[1\].g_col\[1\].pe_hold3063 g_row\[1\].g_col\[1\].pe__2628_/X VGND VGND VPWR
+ VPWR g_row\[1\].g_col\[1\].pe_hold3063/X sky130_fd_sc_hd__clkbuf_2
Xg_row\[1\].g_col\[1\].pe_hold3074 g_row\[1\].g_col\[1\].pe__2736_/Q VGND VGND VPWR
+ VPWR g_row\[1\].g_col\[1\].pe__1401_/A1 sky130_fd_sc_hd__clkbuf_2
XTAP_TAPCELL_ROW_56_1053 VGND VPWR sky130_fd_sc_hd__tapvpwrvgnd_1
Xg_row\[1\].g_col\[1\].pe_hold3096 g_row\[1\].g_col\[1\].pe__2704_/Q VGND VGND VPWR
+ VPWR g_row\[1\].g_col\[1\].pe__2632_/B sky130_fd_sc_hd__clkbuf_2
Xg_row\[1\].g_col\[1\].pe_hold1672 g_row\[1\].g_col\[1\].pe__2381_/X VGND VGND VPWR
+ VPWR g_row\[1\].g_col\[1\].pe__2752_/D sky130_fd_sc_hd__clkbuf_2
Xg_row\[1\].g_col\[1\].pe_hold1650 g_row\[1\].g_col\[1\].pe_hold3093/X VGND VGND VPWR
+ VPWR g_row\[1\].g_col\[1\].pe__2063_/B1 sky130_fd_sc_hd__clkbuf_2
Xg_row\[1\].g_col\[0\].pe__2450_ g_row\[1\].g_col\[0\].pe__2399_/Y g_row\[1\].g_col\[0\].pe__2742_/Q
+ g_row\[1\].g_col\[0\].pe__2453_/B VGND VGND VPWR VPWR g_row\[1\].g_col\[0\].pe__2451_/B
+ sky130_fd_sc_hd__a21o_2
Xg_row\[1\].g_col\[1\].pe_hold1683 g_row\[1\].g_col\[1\].pe__2402_/Y VGND VGND VPWR
+ VPWR g_row\[1\].g_col\[1\].pe__2754_/D sky130_fd_sc_hd__clkbuf_2
Xg_row\[1\].g_col\[0\].pe__2381_ g_row\[1\].g_col\[0\].pe__2592_/A g_row\[1\].g_col\[0\].pe__2381_/B
+ VGND VGND VPWR VPWR g_row\[1\].g_col\[0\].pe__2381_/X sky130_fd_sc_hd__and2_4
Xg_row\[1\].g_col\[0\].pe__1401_ g_row\[1\].g_col\[0\].pe__1401_/A1 g_row\[1\].g_col\[0\].pe__2679_/A2
+ g_row\[1\].g_col\[0\].pe__1401_/B1 g_row\[1\].g_col\[0\].pe__1403_/C1 VGND VGND
+ VPWR VPWR g_row\[1\].g_col\[0\].pe__1401_/X sky130_fd_sc_hd__o211a_2
XTAP_TAPCELL_ROW_19_502 VGND VPWR sky130_fd_sc_hd__tapvpwrvgnd_1
Xg_row\[1\].g_col\[1\].pe_place1007 g_row\[1\].g_col\[1\].pe__2126_/B2 VGND VGND VPWR
+ VPWR g_row\[1\].g_col\[1\].pe__2167_/A sky130_fd_sc_hd__buf_6
Xg_row\[1\].g_col\[1\].pe_place1018 g_row\[1\].g_col\[1\].pe__1804_/A VGND VGND VPWR
+ VPWR g_row\[1\].g_col\[1\].pe__1727_/A1 sky130_fd_sc_hd__buf_6
Xg_row\[1\].g_col\[1\].pe_place1029 g_row\[1\].g_col\[1\].pe__1608_/A1 VGND VGND VPWR
+ VPWR g_row\[1\].g_col\[1\].pe__2241_/B2 sky130_fd_sc_hd__buf_6
XFILLER_17_573 VGND VGND VPWR VPWR sky130_fd_sc_hd__decap_3
XFILLER_51_307 VGND VGND VPWR VPWR sky130_fd_sc_hd__decap_3
XFILLER_63_167 VGND VGND VPWR VPWR sky130_fd_sc_hd__fill_1
XFILLER_60_841 VGND VGND VPWR VPWR sky130_fd_sc_hd__fill_1
Xg_row\[0\].g_col\[0\].pe__2390_ g_row\[0\].g_col\[0\].pe__2390_/A g_row\[0\].g_col\[0\].pe__2390_/B
+ VGND VGND VPWR VPWR g_row\[0\].g_col\[0\].pe__2391_/B sky130_fd_sc_hd__xnor2_2
Xg_row\[0\].g_col\[0\].pe__1341_ g_row\[0\].g_col\[0\].pe__1348_/A g_row\[0\].g_col\[0\].pe__2775_/A
+ VGND VGND VPWR VPWR g_row\[0\].g_col\[0\].pe__1342_/B sky130_fd_sc_hd__nand2_2
Xg_row\[0\].g_col\[0\].pe_hold2875 _278_/Q VGND VGND VPWR VPWR g_row\[0\].g_col\[0\].pe_hold2875/X
+ sky130_fd_sc_hd__clkbuf_2
Xg_row\[0\].g_col\[0\].pe_hold2886 _282_/Q VGND VGND VPWR VPWR g_row\[0\].g_col\[0\].pe_hold2886/X
+ sky130_fd_sc_hd__clkbuf_2
Xg_row\[0\].g_col\[0\].pe_hold2897 _281_/Q VGND VGND VPWR VPWR g_row\[0\].g_col\[0\].pe_hold2897/X
+ sky130_fd_sc_hd__clkbuf_2
XFILLER_9_750 VGND VGND VPWR VPWR sky130_fd_sc_hd__fill_1
XFILLER_9_783 VGND VGND VPWR VPWR sky130_fd_sc_hd__fill_1
Xg_row\[1\].g_col\[1\].pe__2733_ clkbuf_leaf_84_clk/X g_row\[1\].g_col\[1\].pe__2733_/D
+ VGND VGND VPWR VPWR g_row\[1\].g_col\[1\].pe__2733_/Q sky130_fd_sc_hd__dfxtp_2
Xg_row\[1\].g_col\[0\].pe__2717_ clkbuf_leaf_50_clk/X g_row\[1\].g_col\[0\].pe__2717_/D
+ VGND VGND VPWR VPWR g_row\[1\].g_col\[0\].pe__2717_/Q sky130_fd_sc_hd__dfxtp_2
Xg_row\[1\].g_col\[1\].pe__2664_ g_row\[1\].g_col\[1\].pe__2670_/A1 hold2084/X g_row\[1\].g_col\[1\].pe__2670_/B1
+ g_row\[1\].g_col\[1\].pe__2664_/C1 VGND VGND VPWR VPWR g_row\[1\].g_col\[1\].pe__2664_/X
+ sky130_fd_sc_hd__o211a_2
Xg_row\[1\].g_col\[0\].pe__2648_ g_row\[1\].g_col\[0\].pe__2652_/A1 hold2043/X g_row\[1\].g_col\[0\].pe__2677_/B1
+ g_row\[1\].g_col\[0\].pe__2648_/C1 VGND VGND VPWR VPWR g_row\[1\].g_col\[0\].pe__2648_/X
+ sky130_fd_sc_hd__o211a_2
Xg_row\[1\].g_col\[1\].pe__2595_ g_row\[1\].g_col\[1\].pe__2595_/A g_row\[1\].g_col\[1\].pe__2595_/B
+ VGND VGND VPWR VPWR g_row\[1\].g_col\[1\].pe__2771_/D sky130_fd_sc_hd__and2_2
Xg_row\[1\].g_col\[1\].pe__1615_ g_row\[1\].g_col\[1\].pe__1615_/A g_row\[1\].g_col\[1\].pe__1615_/B
+ VGND VGND VPWR VPWR g_row\[1\].g_col\[1\].pe__1629_/A sky130_fd_sc_hd__xor2_2
Xg_row\[1\].g_col\[1\].pe__1546_ g_row\[1\].g_col\[1\].pe__1546_/A g_row\[1\].g_col\[1\].pe__1546_/B
+ VGND VGND VPWR VPWR g_row\[1\].g_col\[1\].pe__1547_/B sky130_fd_sc_hd__xnor2_2
Xg_row\[1\].g_col\[0\].pe_hold2073 g_row\[1\].g_col\[0\].pe__2717_/Q VGND VGND VPWR
+ VPWR g_row\[1\].g_col\[0\].pe__2663_/B sky130_fd_sc_hd__clkbuf_2
Xg_row\[1\].g_col\[0\].pe_hold2062 g_row\[1\].g_col\[0\].pe__2633_/X VGND VGND VPWR
+ VPWR g_row\[1\].g_col\[0\].pe__2704_/D sky130_fd_sc_hd__clkbuf_2
Xg_row\[1\].g_col\[0\].pe_hold2051 g_row\[1\].g_col\[0\].pe__2689_/A VGND VGND VPWR
+ VPWR g_row\[1\].g_col\[0\].pe__2680_/A sky130_fd_sc_hd__clkbuf_2
Xg_row\[1\].g_col\[0\].pe__2579_ g_row\[1\].g_col\[0\].pe__2579_/A g_row\[1\].g_col\[0\].pe__2579_/B
+ g_row\[1\].g_col\[0\].pe__2579_/C VGND VGND VPWR VPWR g_row\[1\].g_col\[0\].pe__2579_/Y
+ sky130_fd_sc_hd__nand3_2
XTAP_TAPCELL_ROW_87_1514 VGND VPWR sky130_fd_sc_hd__tapvpwrvgnd_1
Xg_row\[0\].g_col\[1\].pe_hold2405 g_row\[0\].g_col\[1\].pe_hold3083/X VGND VGND VPWR
+ VPWR g_row\[0\].g_col\[1\].pe__2063_/B1 sky130_fd_sc_hd__clkbuf_2
Xg_row\[0\].g_col\[1\].pe__2742_ _276_/CLK g_row\[0\].g_col\[1\].pe__2742_/D VGND
+ VGND VPWR VPWR g_row\[0\].g_col\[1\].pe__2742_/Q sky130_fd_sc_hd__dfxtp_2
XFILLER_54_112 VGND VGND VPWR VPWR sky130_fd_sc_hd__fill_2
Xg_row\[0\].g_col\[0\].pe__2726_ clkbuf_leaf_40_clk/X g_row\[0\].g_col\[0\].pe__2726_/D
+ VGND VGND VPWR VPWR g_row\[0\].g_col\[0\].pe__2726_/Q sky130_fd_sc_hd__dfxtp_2
Xg_row\[1\].g_col\[1\].pe__1477_ g_row\[1\].g_col\[1\].pe__1676_/A g_row\[1\].g_col\[1\].pe__1477_/B
+ VGND VGND VPWR VPWR g_row\[1\].g_col\[1\].pe__1478_/B sky130_fd_sc_hd__xnor2_2
XFILLER_70_605 VGND VGND VPWR VPWR sky130_fd_sc_hd__decap_3
Xg_row\[0\].g_col\[0\].pe__2657_ g_row\[0\].g_col\[0\].pe__2669_/A hold1876/X VGND
+ VGND VPWR VPWR g_row\[0\].g_col\[0\].pe__2657_/X sky130_fd_sc_hd__or2_2
Xg_row\[0\].g_col\[1\].pe__2673_ _326_/Q _325_/Q g_row\[0\].g_col\[1\].pe__2673_/C
+ g_row\[0\].g_col\[1\].pe__2673_/D VGND VGND VPWR VPWR g_row\[0\].g_col\[1\].pe__2673_/X
+ sky130_fd_sc_hd__or4_2
XFILLER_42_329 VGND VGND VPWR VPWR sky130_fd_sc_hd__decap_3
XFILLER_51_841 VGND VGND VPWR VPWR sky130_fd_sc_hd__fill_1
XPHY_EDGE_ROW_59_Left_153 VGND VGND VPWR VPWR sky130_fd_sc_hd__decap_3
Xg_row\[0\].g_col\[0\].pe__1608_ hold2339/A g_row\[0\].g_col\[0\].pe__2026_/B g_row\[0\].g_col\[0\].pe__1449_/Y
+ place1205/A VGND VGND VPWR VPWR g_row\[0\].g_col\[0\].pe__1609_/B sky130_fd_sc_hd__a22o_2
Xg_row\[0\].g_col\[1\].pe__1624_ g_row\[0\].g_col\[1\].pe__1624_/A g_row\[0\].g_col\[1\].pe__1624_/B
+ VGND VGND VPWR VPWR g_row\[0\].g_col\[1\].pe__1625_/B sky130_fd_sc_hd__xor2_2
XFILLER_23_554 VGND VGND VPWR VPWR sky130_fd_sc_hd__fill_1
Xg_row\[0\].g_col\[0\].pe__2588_ g_row\[0\].g_col\[0\].pe__2592_/A g_row\[0\].g_col\[0\].pe__2588_/B
+ VGND VGND VPWR VPWR g_row\[0\].g_col\[0\].pe__2769_/D sky130_fd_sc_hd__and2_2
Xg_row\[0\].g_col\[1\].pe__1555_ g_row\[0\].g_col\[1\].pe__1555_/A g_row\[0\].g_col\[1\].pe__1555_/B
+ VGND VGND VPWR VPWR g_row\[0\].g_col\[1\].pe__1562_/B sky130_fd_sc_hd__and2_2
Xg_row\[0\].g_col\[1\].pe__1486_ g_row\[0\].g_col\[1\].pe__1707_/A g_row\[0\].g_col\[1\].pe__1486_/B
+ VGND VGND VPWR VPWR g_row\[0\].g_col\[1\].pe__1514_/B sky130_fd_sc_hd__xor2_2
Xg_row\[1\].g_col\[1\].pe__2029_ g_row\[1\].g_col\[1\].pe__2028_/B g_row\[1\].g_col\[1\].pe__2028_/C
+ g_row\[1\].g_col\[1\].pe__2126_/B2 VGND VGND VPWR VPWR g_row\[1\].g_col\[1\].pe__2034_/B
+ sky130_fd_sc_hd__a21bo_2
Xg_row\[0\].g_col\[1\].pe__2107_ g_row\[0\].g_col\[1\].pe__2107_/A g_row\[0\].g_col\[1\].pe__2107_/B
+ VGND VGND VPWR VPWR g_row\[0\].g_col\[1\].pe__2117_/B sky130_fd_sc_hd__xnor2_2
XPHY_EDGE_ROW_68_Left_162 VGND VGND VPWR VPWR sky130_fd_sc_hd__decap_3
Xg_row\[0\].g_col\[1\].pe__2038_ g_row\[0\].g_col\[1\].pe__2038_/A g_row\[0\].g_col\[1\].pe__2038_/B
+ g_row\[0\].g_col\[1\].pe__2038_/C VGND VGND VPWR VPWR g_row\[0\].g_col\[1\].pe__2048_/A
+ sky130_fd_sc_hd__nand3_2
XFILLER_77_248 VGND VGND VPWR VPWR sky130_fd_sc_hd__decap_3
XTAP_TAPCELL_ROW_5_285 VGND VPWR sky130_fd_sc_hd__tapvpwrvgnd_1
XANTENNA_100 b_inputs_flat[0] VGND VGND VPWR VPWR sky130_fd_sc_hd__diode_2
XFILLER_65_54 VGND VGND VPWR VPWR sky130_fd_sc_hd__fill_2
XANTENNA_111 hold3240/A VGND VGND VPWR VPWR sky130_fd_sc_hd__diode_2
XANTENNA_122 hold3405/X VGND VGND VPWR VPWR sky130_fd_sc_hd__diode_2
XANTENNA_133 a_inputs_flat[8] VGND VGND VPWR VPWR sky130_fd_sc_hd__diode_2
XPHY_EDGE_ROW_77_Left_171 VGND VGND VPWR VPWR sky130_fd_sc_hd__decap_3
Xg_row\[0\].g_col\[1\].pe_hold2972 g_row\[0\].g_col\[1\].pe__2654_/X VGND VGND VPWR
+ VPWR g_row\[0\].g_col\[1\].pe_hold2972/X sky130_fd_sc_hd__clkbuf_2
XANTENNA_144 ANTENNA_144/DIODE VGND VGND VPWR VPWR sky130_fd_sc_hd__diode_2
XANTENNA_155 hold3182/A VGND VGND VPWR VPWR sky130_fd_sc_hd__diode_2
XANTENNA_166 _217_/B_N VGND VGND VPWR VPWR sky130_fd_sc_hd__diode_2
XFILLER_33_329 VGND VGND VPWR VPWR sky130_fd_sc_hd__fill_2
Xg_row\[0\].g_col\[0\].pe_hold2105 g_row\[0\].g_col\[0\].pe__2587_/X VGND VGND VPWR
+ VPWR g_row\[0\].g_col\[0\].pe__2588_/B sky130_fd_sc_hd__clkbuf_2
Xg_row\[0\].g_col\[1\].pe_hold2994 g_row\[0\].g_col\[1\].pe__2672_/C VGND VGND VPWR
+ VPWR g_row\[0\].g_col\[1\].pe__2670_/A2 sky130_fd_sc_hd__clkbuf_2
XANTENNA_177 hold3336/X VGND VGND VPWR VPWR sky130_fd_sc_hd__diode_2
XFILLER_14_565 VGND VGND VPWR VPWR sky130_fd_sc_hd__decap_3
XTAP_TAPCELL_ROW_44_869 VGND VPWR sky130_fd_sc_hd__tapvpwrvgnd_1
Xg_row\[0\].g_col\[0\].pe_hold2138 g_row\[0\].g_col\[0\].pe__2554_/X VGND VGND VPWR
+ VPWR g_row\[0\].g_col\[0\].pe__2555_/B sky130_fd_sc_hd__clkbuf_2
XTAP_TAPCELL_ROW_24_571 VGND VPWR sky130_fd_sc_hd__tapvpwrvgnd_1
X_286_ _289_/CLK _286_/D VGND VGND VPWR VPWR _286_/Q sky130_fd_sc_hd__dfxtp_2
Xg_row\[1\].g_col\[0\].pe__1950_ g_row\[1\].g_col\[0\].pe__1950_/A g_row\[1\].g_col\[0\].pe__1950_/B
+ VGND VGND VPWR VPWR g_row\[1\].g_col\[0\].pe__1950_/Y sky130_fd_sc_hd__nand2_2
XFILLER_10_760 VGND VGND VPWR VPWR sky130_fd_sc_hd__fill_2
XFILLER_6_731 VGND VGND VPWR VPWR sky130_fd_sc_hd__fill_2
XFILLER_6_753 VGND VGND VPWR VPWR sky130_fd_sc_hd__decap_3
XPHY_EDGE_ROW_86_Left_180 VGND VGND VPWR VPWR sky130_fd_sc_hd__decap_3
Xg_row\[1\].g_col\[0\].pe__1881_ g_row\[1\].g_col\[0\].pe__1936_/A g_row\[1\].g_col\[0\].pe__1936_/B
+ VGND VGND VPWR VPWR g_row\[1\].g_col\[0\].pe__1882_/B sky130_fd_sc_hd__xnor2_2
XFILLER_5_285 VGND VGND VPWR VPWR sky130_fd_sc_hd__decap_3
Xg_row\[1\].g_col\[1\].pe_hold2181 g_row\[1\].g_col\[1\].pe__2645_/X VGND VGND VPWR
+ VPWR g_row\[1\].g_col\[1\].pe__2646_/C1 sky130_fd_sc_hd__clkbuf_2
Xg_row\[1\].g_col\[0\].pe__2502_ g_row\[1\].g_col\[0\].pe__2551_/A g_row\[1\].g_col\[0\].pe__2558_/B
+ g_row\[1\].g_col\[0\].pe__2546_/B g_row\[1\].g_col\[0\].pe__2502_/D VGND VGND VPWR
+ VPWR g_row\[1\].g_col\[0\].pe__2502_/X sky130_fd_sc_hd__and4_2
Xg_row\[0\].g_col\[0\].pe__1890_ g_row\[0\].g_col\[0\].pe__1894_/A g_row\[0\].g_col\[0\].pe__1894_/B
+ VGND VGND VPWR VPWR g_row\[0\].g_col\[0\].pe__1891_/B sky130_fd_sc_hd__xor2_2
Xg_row\[1\].g_col\[1\].pe__1400_ hold1781/X g_row\[1\].g_col\[1\].pe__2680_/B VGND
+ VGND VPWR VPWR g_row\[1\].g_col\[1\].pe__1400_/X sky130_fd_sc_hd__or2_2
Xg_row\[1\].g_col\[0\].pe__2433_ g_row\[1\].g_col\[0\].pe__2474_/B g_row\[1\].g_col\[0\].pe__2766_/Q
+ VGND VGND VPWR VPWR g_row\[1\].g_col\[0\].pe__2487_/B sky130_fd_sc_hd__and2b_2
Xg_row\[1\].g_col\[1\].pe__2380_ g_row\[1\].g_col\[1\].pe__2376_/X g_row\[1\].g_col\[1\].pe__2378_/X
+ g_row\[1\].g_col\[1\].pe__2379_/Y g_row\[1\].g_col\[1\].pe__2380_/B1 g_row\[1\].g_col\[1\].pe__1950_/A
+ VGND VGND VPWR VPWR g_row\[1\].g_col\[1\].pe__2380_/X sky130_fd_sc_hd__a32o_2
Xg_row\[1\].g_col\[0\].pe__2364_ g_row\[1\].g_col\[0\].pe__2364_/A g_row\[1\].g_col\[0\].pe__2364_/B
+ VGND VGND VPWR VPWR g_row\[1\].g_col\[0\].pe__2365_/B sky130_fd_sc_hd__xnor2_2
XTAP_TAPCELL_ROW_69_1244 VGND VPWR sky130_fd_sc_hd__tapvpwrvgnd_1
Xg_row\[1\].g_col\[0\].pe__2295_ g_row\[1\].g_col\[0\].pe__2295_/A g_row\[1\].g_col\[0\].pe__2295_/B
+ g_row\[1\].g_col\[0\].pe__2292_/X VGND VGND VPWR VPWR g_row\[1\].g_col\[0\].pe__2296_/B
+ sky130_fd_sc_hd__or3b_2
XFILLER_36_178 VGND VGND VPWR VPWR sky130_fd_sc_hd__fill_1
XFILLER_33_841 VGND VGND VPWR VPWR sky130_fd_sc_hd__fill_1
Xg_row\[0\].g_col\[0\].pe__2442_ g_row\[0\].g_col\[0\].pe__2443_/B g_row\[0\].g_col\[0\].pe__2762_/Q
+ VGND VGND VPWR VPWR g_row\[0\].g_col\[0\].pe__2444_/A sky130_fd_sc_hd__and2b_2
XTAP_TAPCELL_ROW_82_1433 VGND VPWR sky130_fd_sc_hd__tapvpwrvgnd_1
XTAP_TAPCELL_ROW_82_1444 VGND VPWR sky130_fd_sc_hd__tapvpwrvgnd_1
XFILLER_20_502 VGND VGND VPWR VPWR sky130_fd_sc_hd__decap_3
XFILLER_60_682 VGND VGND VPWR VPWR sky130_fd_sc_hd__fill_2
Xg_row\[0\].g_col\[0\].pe__2373_ g_row\[0\].g_col\[0\].pe__2337_/B g_row\[0\].g_col\[0\].pe__2368_/B
+ g_row\[0\].g_col\[0\].pe__2350_/B g_row\[0\].g_col\[0\].pe__2350_/A VGND VGND VPWR
+ VPWR g_row\[0\].g_col\[0\].pe__2385_/B sky130_fd_sc_hd__a22o_2
Xg_row\[0\].g_col\[1\].pe__1340_ g_row\[0\].g_col\[1\].pe__1340_/A VGND VGND VPWR
+ VPWR g_row\[0\].g_col\[1\].pe__2689_/A sky130_fd_sc_hd__inv_2
Xg_row\[0\].g_col\[0\].pe_hold1993 g_row\[0\].g_col\[0\].pe__2535_/X VGND VGND VPWR
+ VPWR g_row\[0\].g_col\[0\].pe__2536_/B sky130_fd_sc_hd__clkbuf_2
Xg_row\[1\].g_col\[1\].pe__2716_ clkbuf_leaf_81_clk/X g_row\[1\].g_col\[1\].pe__2716_/D
+ VGND VGND VPWR VPWR g_row\[1\].g_col\[1\].pe__2716_/Q sky130_fd_sc_hd__dfxtp_2
Xg_row\[1\].g_col\[1\].pe__2647_ g_row\[1\].g_col\[1\].pe__2676_/A g_row\[1\].g_col\[1\].pe__2647_/B
+ VGND VGND VPWR VPWR g_row\[1\].g_col\[1\].pe__2647_/X sky130_fd_sc_hd__or2_2
XFILLER_75_708 VGND VGND VPWR VPWR sky130_fd_sc_hd__decap_3
XFILLER_87_557 VGND VGND VPWR VPWR sky130_fd_sc_hd__decap_3
XFILLER_28_602 VGND VGND VPWR VPWR sky130_fd_sc_hd__decap_3
Xg_row\[0\].g_col\[1\].pe_hold2202 g_row\[0\].g_col\[1\].pe__2698_/Q VGND VGND VPWR
+ VPWR g_row\[0\].g_col\[1\].pe__2618_/B sky130_fd_sc_hd__clkbuf_2
XFILLER_67_281 VGND VGND VPWR VPWR sky130_fd_sc_hd__fill_2
XTAP_TAPCELL_ROW_2_233 VGND VPWR sky130_fd_sc_hd__tapvpwrvgnd_1
XTAP_TAPCELL_ROW_2_244 VGND VPWR sky130_fd_sc_hd__tapvpwrvgnd_1
Xg_row\[1\].g_col\[1\].pe__1529_ g_row\[1\].g_col\[1\].pe__1554_/A g_row\[1\].g_col\[1\].pe__1554_/B
+ VGND VGND VPWR VPWR g_row\[1\].g_col\[1\].pe__1555_/A sky130_fd_sc_hd__xor2_2
Xg_row\[0\].g_col\[1\].pe_hold2213 g_row\[0\].g_col\[1\].pe__2694_/Q VGND VGND VPWR
+ VPWR g_row\[0\].g_col\[1\].pe__2610_/B sky130_fd_sc_hd__clkbuf_2
Xg_row\[0\].g_col\[0\].pe__2709_ clkbuf_leaf_41_clk/X g_row\[0\].g_col\[0\].pe__2709_/D
+ VGND VGND VPWR VPWR hold2042/A sky130_fd_sc_hd__dfxtp_2
Xg_row\[0\].g_col\[1\].pe__2725_ clkbuf_leaf_95_clk/X g_row\[0\].g_col\[1\].pe__2725_/D
+ VGND VGND VPWR VPWR g_row\[0\].g_col\[1\].pe__2725_/Q sky130_fd_sc_hd__dfxtp_2
Xg_row\[0\].g_col\[1\].pe__2656_ g_row\[0\].g_col\[1\].pe__2668_/A1 g_row\[0\].g_col\[1\].pe__1387_/A
+ g_row\[0\].g_col\[1\].pe__2656_/B1 g_row\[0\].g_col\[1\].pe__2655_/X VGND VGND VPWR
+ VPWR g_row\[0\].g_col\[1\].pe__2656_/X sky130_fd_sc_hd__o211a_2
Xg_row\[0\].g_col\[1\].pe__1607_ g_row\[0\].g_col\[1\].pe__1607_/A g_row\[0\].g_col\[1\].pe__1849_/B
+ VGND VGND VPWR VPWR g_row\[0\].g_col\[1\].pe__1633_/A sky130_fd_sc_hd__xor2_2
XFILLER_11_502 VGND VGND VPWR VPWR sky130_fd_sc_hd__fill_2
XTAP_TAPCELL_ROW_41_828 VGND VPWR sky130_fd_sc_hd__tapvpwrvgnd_1
Xg_row\[0\].g_col\[1\].pe__2587_ g_row\[0\].g_col\[1\].pe__2587_/A1 g_row\[0\].g_col\[1\].pe__2587_/A2
+ g_row\[0\].g_col\[1\].pe__2517_/Y g_row\[0\].g_col\[1\].pe__2586_/X VGND VGND VPWR
+ VPWR g_row\[0\].g_col\[1\].pe__2587_/X sky130_fd_sc_hd__a22o_2
XPHY_EDGE_ROW_14_Right_14 VGND VGND VPWR VPWR sky130_fd_sc_hd__decap_3
XTAP_TAPCELL_ROW_21_530 VGND VPWR sky130_fd_sc_hd__tapvpwrvgnd_1
Xg_row\[0\].g_col\[1\].pe__1538_ g_row\[0\].g_col\[1\].pe__2736_/Q VGND VGND VPWR
+ VPWR g_row\[0\].g_col\[1\].pe__1557_/A sky130_fd_sc_hd__inv_2
Xg_row\[0\].g_col\[1\].pe__1469_ g_row\[0\].g_col\[1\].pe__2733_/Q g_row\[0\].g_col\[1\].pe__2250_/A
+ VGND VGND VPWR VPWR g_row\[0\].g_col\[1\].pe__1471_/A sky130_fd_sc_hd__nand2_2
Xg_row\[0\].g_col\[0\].pe_place975 g_row\[0\].g_col\[0\].pe__2399_/Y VGND VGND VPWR
+ VPWR g_row\[0\].g_col\[0\].pe__2450_/A1 sky130_fd_sc_hd__buf_6
Xg_row\[0\].g_col\[0\].pe_place986 g_row\[0\].g_col\[0\].pe__1982_/B VGND VGND VPWR
+ VPWR g_row\[0\].g_col\[0\].pe__1732_/A2 sky130_fd_sc_hd__buf_6
Xg_row\[0\].g_col\[0\].pe_place997 g_row\[0\].g_col\[0\].pe__1385_/B VGND VGND VPWR
+ VPWR g_row\[0\].g_col\[0\].pe__2680_/B sky130_fd_sc_hd__buf_6
XTAP_TAPCELL_ROW_53_1001 VGND VPWR sky130_fd_sc_hd__tapvpwrvgnd_1
XTAP_TAPCELL_ROW_53_1012 VGND VPWR sky130_fd_sc_hd__tapvpwrvgnd_1
XPHY_EDGE_ROW_23_Right_23 VGND VGND VPWR VPWR sky130_fd_sc_hd__decap_3
XFILLER_78_557 VGND VGND VPWR VPWR sky130_fd_sc_hd__fill_2
XTAP_TAPCELL_ROW_49_939 VGND VPWR sky130_fd_sc_hd__tapvpwrvgnd_1
XFILLER_18_134 VGND VGND VPWR VPWR sky130_fd_sc_hd__fill_1
XFILLER_19_657 VGND VGND VPWR VPWR sky130_fd_sc_hd__decap_3
XFILLER_46_421 VGND VGND VPWR VPWR sky130_fd_sc_hd__fill_1
XFILLER_46_454 VGND VGND VPWR VPWR sky130_fd_sc_hd__decap_3
XTAP_TAPCELL_ROW_29_641 VGND VPWR sky130_fd_sc_hd__tapvpwrvgnd_1
XTAP_TAPCELL_ROW_29_652 VGND VPWR sky130_fd_sc_hd__tapvpwrvgnd_1
XFILLER_34_638 VGND VGND VPWR VPWR sky130_fd_sc_hd__decap_3
Xg_row\[1\].g_col\[0\].pe__2080_ g_row\[1\].g_col\[0\].pe__1449_/A g_row\[1\].g_col\[0\].pe__1449_/B
+ g_row\[1\].g_col\[0\].pe__1983_/Y VGND VGND VPWR VPWR g_row\[1\].g_col\[0\].pe__2081_/C
+ sky130_fd_sc_hd__a21o_2
XFILLER_15_841 VGND VGND VPWR VPWR sky130_fd_sc_hd__fill_1
XFILLER_92_74 VGND VGND VPWR VPWR sky130_fd_sc_hd__decap_3
XFILLER_92_85 VGND VGND VPWR VPWR sky130_fd_sc_hd__fill_1
XPHY_EDGE_ROW_32_Right_32 VGND VGND VPWR VPWR sky130_fd_sc_hd__decap_3
XFILLER_30_811 VGND VGND VPWR VPWR sky130_fd_sc_hd__fill_1
XTAP_TAPCELL_ROW_64_1163 VGND VPWR sky130_fd_sc_hd__tapvpwrvgnd_1
XTAP_TAPCELL_ROW_64_1174 VGND VPWR sky130_fd_sc_hd__tapvpwrvgnd_1
X_338_ _338_/CLK _338_/D VGND VGND VPWR VPWR _338_/Q sky130_fd_sc_hd__dfxtp_2
X_269_ _269_/A _269_/B_N VGND VGND VPWR VPWR _269_/Y sky130_fd_sc_hd__nor2b_4
Xg_row\[1\].g_col\[0\].pe__1933_ g_row\[1\].g_col\[0\].pe__1878_/A g_row\[1\].g_col\[0\].pe__1878_/B
+ g_row\[1\].g_col\[0\].pe__1932_/X VGND VGND VPWR VPWR g_row\[1\].g_col\[0\].pe__1999_/B
+ sky130_fd_sc_hd__a21oi_2
Xg_row\[1\].g_col\[1\].pe__1880_ g_row\[1\].g_col\[1\].pe__1629_/A g_row\[1\].g_col\[1\].pe__1629_/B
+ g_row\[1\].g_col\[1\].pe__1879_/Y VGND VGND VPWR VPWR g_row\[1\].g_col\[1\].pe__1936_/B
+ sky130_fd_sc_hd__a21oi_2
Xg_row\[1\].g_col\[0\].pe__1864_ g_row\[1\].g_col\[0\].pe__1864_/A g_row\[1\].g_col\[0\].pe__1864_/B
+ VGND VGND VPWR VPWR g_row\[1\].g_col\[0\].pe__1899_/B sky130_fd_sc_hd__xnor2_2
XPHY_EDGE_ROW_41_Right_41 VGND VGND VPWR VPWR sky130_fd_sc_hd__decap_3
Xg_row\[1\].g_col\[0\].pe__1795_ g_row\[1\].g_col\[0\].pe__1795_/A g_row\[1\].g_col\[0\].pe__1795_/B
+ g_row\[1\].g_col\[0\].pe__1795_/C VGND VGND VPWR VPWR g_row\[1\].g_col\[0\].pe__1811_/B
+ sky130_fd_sc_hd__and3_2
Xhold2408 hold3130/X VGND VGND VPWR VPWR hold3131/A sky130_fd_sc_hd__clkbuf_2
Xhold2419 hold2419/A VGND VGND VPWR VPWR _274_/D sky130_fd_sc_hd__clkbuf_2
Xg_row\[1\].g_col\[1\].pe__2501_ g_row\[1\].g_col\[1\].pe__2538_/A g_row\[1\].g_col\[1\].pe__2526_/A
+ g_row\[1\].g_col\[1\].pe__2501_/C g_row\[1\].g_col\[1\].pe__2533_/B VGND VGND VPWR
+ VPWR g_row\[1\].g_col\[1\].pe__2502_/D sky130_fd_sc_hd__and4_2
Xg_row\[0\].g_col\[0\].pe__1942_ g_row\[0\].g_col\[0\].pe__2005_/A g_row\[0\].g_col\[0\].pe__1942_/B
+ VGND VGND VPWR VPWR g_row\[0\].g_col\[0\].pe__1951_/B sky130_fd_sc_hd__nor2_2
XFILLER_56_229 VGND VGND VPWR VPWR sky130_fd_sc_hd__decap_3
Xg_row\[0\].g_col\[0\].pe__1873_ g_row\[0\].g_col\[0\].pe__2728_/Q g_row\[0\].g_col\[0\].pe__1873_/B
+ VGND VGND VPWR VPWR g_row\[0\].g_col\[0\].pe__1874_/B sky130_fd_sc_hd__xor2_2
Xg_row\[1\].g_col\[1\].pe__2432_ g_row\[1\].g_col\[1\].pe__2432_/A g_row\[1\].g_col\[1\].pe__2432_/B
+ VGND VGND VPWR VPWR g_row\[1\].g_col\[1\].pe__2474_/B sky130_fd_sc_hd__xnor2_2
Xg_row\[1\].g_col\[0\].pe__2416_ g_row\[1\].g_col\[0\].pe__2421_/A1 g_row\[1\].g_col\[0\].pe__2747_/Q
+ g_row\[1\].g_col\[0\].pe__2436_/B VGND VGND VPWR VPWR g_row\[1\].g_col\[0\].pe__2434_/B
+ sky130_fd_sc_hd__a21oi_2
XFILLER_49_281 VGND VGND VPWR VPWR sky130_fd_sc_hd__decap_3
XFILLER_65_741 VGND VGND VPWR VPWR sky130_fd_sc_hd__fill_1
Xg_row\[1\].g_col\[1\].pe__2363_ g_row\[1\].g_col\[1\].pe__2388_/A g_row\[1\].g_col\[1\].pe__2363_/A2
+ g_row\[1\].g_col\[1\].pe__2388_/B g_row\[1\].g_col\[1\].pe__2121_/A VGND VGND VPWR
+ VPWR g_row\[1\].g_col\[1\].pe__2364_/B sky130_fd_sc_hd__a22o_2
XFILLER_37_454 VGND VGND VPWR VPWR sky130_fd_sc_hd__fill_2
XFILLER_65_785 VGND VGND VPWR VPWR sky130_fd_sc_hd__decap_3
Xg_row\[1\].g_col\[0\].pe__2347_ g_row\[1\].g_col\[0\].pe__2347_/A g_row\[1\].g_col\[0\].pe__2347_/B
+ VGND VGND VPWR VPWR g_row\[1\].g_col\[0\].pe__2368_/B sky130_fd_sc_hd__xor2_2
XPHY_EDGE_ROW_50_Right_50 VGND VGND VPWR VPWR sky130_fd_sc_hd__decap_3
Xg_row\[1\].g_col\[1\].pe__2294_ g_row\[1\].g_col\[1\].pe__2294_/A VGND VGND VPWR
+ VPWR g_row\[1\].g_col\[1\].pe__2329_/A sky130_fd_sc_hd__inv_2
Xg_row\[1\].g_col\[0\].pe__2278_ g_row\[1\].g_col\[0\].pe__2030_/A g_row\[1\].g_col\[0\].pe__2363_/A2
+ g_row\[1\].g_col\[0\].pe__2388_/B place1086/X VGND VGND VPWR VPWR g_row\[1\].g_col\[0\].pe__2311_/A
+ sky130_fd_sc_hd__a22o_2
Xg_row\[0\].g_col\[1\].pe__2510_ g_row\[0\].g_col\[1\].pe__2516_/B g_row\[0\].g_col\[1\].pe__2507_/Y
+ g_row\[0\].g_col\[1\].pe__2508_/Y g_row\[0\].g_col\[1\].pe__2509_/X VGND VGND VPWR
+ VPWR g_row\[0\].g_col\[1\].pe__2590_/A sky130_fd_sc_hd__a31o_2
XFILLER_80_766 VGND VGND VPWR VPWR sky130_fd_sc_hd__decap_3
Xg_row\[1\].g_col\[0\].pe_place1245 place1246/X VGND VGND VPWR VPWR g_row\[1\].g_col\[0\].pe__2639_/A
+ sky130_fd_sc_hd__buf_6
Xg_row\[0\].g_col\[1\].pe__2441_ g_row\[0\].g_col\[1\].pe__2745_/Q g_row\[0\].g_col\[1\].pe__2441_/B
+ VGND VGND VPWR VPWR g_row\[0\].g_col\[1\].pe__2443_/B sky130_fd_sc_hd__xnor2_2
Xg_row\[0\].g_col\[0\].pe__2425_ g_row\[0\].g_col\[0\].pe__2425_/A g_row\[0\].g_col\[0\].pe__2425_/B
+ VGND VGND VPWR VPWR g_row\[0\].g_col\[0\].pe__2508_/A sky130_fd_sc_hd__nor2_2
XANTENNA_11 a_inputs_flat[20] VGND VGND VPWR VPWR sky130_fd_sc_hd__diode_2
XANTENNA_22 b_inputs_flat[24] VGND VGND VPWR VPWR sky130_fd_sc_hd__diode_2
Xg_row\[0\].g_col\[0\].pe__2356_ g_row\[0\].g_col\[0\].pe__2356_/A g_row\[0\].g_col\[0\].pe__2356_/B
+ VGND VGND VPWR VPWR g_row\[0\].g_col\[0\].pe__2377_/A sky130_fd_sc_hd__nor2_2
Xg_row\[0\].g_col\[1\].pe__2372_ g_row\[0\].g_col\[1\].pe__2372_/A g_row\[0\].g_col\[1\].pe__2386_/A
+ VGND VGND VPWR VPWR g_row\[0\].g_col\[1\].pe__2385_/A sky130_fd_sc_hd__xnor2_2
XANTENNA_33 _221_/Y VGND VGND VPWR VPWR sky130_fd_sc_hd__diode_2
XANTENNA_44 a_inputs_flat[6] VGND VGND VPWR VPWR sky130_fd_sc_hd__diode_2
XANTENNA_55 hold3579/A VGND VGND VPWR VPWR sky130_fd_sc_hd__diode_2
XANTENNA_66 hold3331/A VGND VGND VPWR VPWR sky130_fd_sc_hd__diode_2
XANTENNA_77 hold3210/X VGND VGND VPWR VPWR sky130_fd_sc_hd__diode_2
XANTENNA_88 hold3280/X VGND VGND VPWR VPWR sky130_fd_sc_hd__diode_2
XANTENNA_99 hold3560/X VGND VGND VPWR VPWR sky130_fd_sc_hd__diode_2
XFILLER_20_398 VGND VGND VPWR VPWR sky130_fd_sc_hd__fill_1
Xg_row\[0\].g_col\[0\].pe__2287_ g_row\[0\].g_col\[0\].pe__2287_/A g_row\[0\].g_col\[0\].pe__2309_/B
+ VGND VGND VPWR VPWR g_row\[0\].g_col\[0\].pe__2291_/A sky130_fd_sc_hd__xnor2_2
XTAP_TAPCELL_ROW_7_314 VGND VPWR sky130_fd_sc_hd__tapvpwrvgnd_1
XFILLER_48_708 VGND VGND VPWR VPWR sky130_fd_sc_hd__decap_3
XFILLER_28_421 VGND VGND VPWR VPWR sky130_fd_sc_hd__fill_2
XFILLER_55_251 VGND VGND VPWR VPWR sky130_fd_sc_hd__fill_2
Xg_row\[0\].g_col\[1\].pe_hold2032 g_row\[0\].g_col\[1\].pe__2587_/X VGND VGND VPWR
+ VPWR g_row\[0\].g_col\[1\].pe__2588_/B sky130_fd_sc_hd__clkbuf_2
XTAP_TAPCELL_ROW_26_600 VGND VPWR sky130_fd_sc_hd__tapvpwrvgnd_1
Xg_row\[0\].g_col\[1\].pe__2708_ clkbuf_leaf_96_clk/X g_row\[0\].g_col\[1\].pe__2708_/D
+ VGND VGND VPWR VPWR hold3026/A sky130_fd_sc_hd__dfxtp_2
XFILLER_43_468 VGND VGND VPWR VPWR sky130_fd_sc_hd__fill_1
XFILLER_24_682 VGND VGND VPWR VPWR sky130_fd_sc_hd__decap_3
XFILLER_70_276 VGND VGND VPWR VPWR sky130_fd_sc_hd__fill_2
Xg_row\[0\].g_col\[1\].pe__2639_ place1248/X g_row\[0\].g_col\[1\].pe__2639_/B VGND
+ VGND VPWR VPWR g_row\[0\].g_col\[1\].pe__2639_/X sky130_fd_sc_hd__or2_2
XFILLER_24_693 VGND VGND VPWR VPWR sky130_fd_sc_hd__fill_2
XFILLER_8_804 VGND VGND VPWR VPWR sky130_fd_sc_hd__decap_3
Xclkbuf_leaf_50_clk clkload6/A VGND VGND VPWR VPWR clkbuf_leaf_50_clk/X sky130_fd_sc_hd__clkbuf_16
XFILLER_11_398 VGND VGND VPWR VPWR sky130_fd_sc_hd__decap_3
Xg_row\[1\].g_col\[0\].pe__1580_ g_row\[1\].g_col\[0\].pe__1580_/A g_row\[1\].g_col\[0\].pe__1580_/B
+ VGND VGND VPWR VPWR g_row\[1\].g_col\[0\].pe__1580_/X sky130_fd_sc_hd__and2_2
XFILLER_78_365 VGND VGND VPWR VPWR sky130_fd_sc_hd__fill_1
XFILLER_78_387 VGND VGND VPWR VPWR sky130_fd_sc_hd__fill_1
Xg_row\[1\].g_col\[0\].pe_hold1916 g_row\[1\].g_col\[0\].pe__2116_/Y VGND VGND VPWR
+ VPWR g_row\[1\].g_col\[0\].pe__2158_/A2 sky130_fd_sc_hd__clkbuf_2
Xg_row\[1\].g_col\[0\].pe__2201_ g_row\[1\].g_col\[0\].pe__2155_/B g_row\[1\].g_col\[0\].pe__2300_/A
+ g_row\[1\].g_col\[0\].pe__2299_/A VGND VGND VPWR VPWR g_row\[1\].g_col\[0\].pe__2233_/A
+ sky130_fd_sc_hd__a21o_2
XTAP_TAPCELL_ROW_66_1203 VGND VPWR sky130_fd_sc_hd__tapvpwrvgnd_1
XFILLER_34_402 VGND VGND VPWR VPWR sky130_fd_sc_hd__decap_3
XFILLER_47_785 VGND VGND VPWR VPWR sky130_fd_sc_hd__fill_1
Xg_row\[1\].g_col\[0\].pe__2132_ g_row\[1\].g_col\[0\].pe__2132_/A g_row\[1\].g_col\[0\].pe__2132_/B
+ VGND VGND VPWR VPWR g_row\[1\].g_col\[0\].pe__2222_/A sky130_fd_sc_hd__xnor2_2
Xg_row\[1\].g_col\[0\].pe__2063_ g_row\[1\].g_col\[0\].pe__2157_/A g_row\[1\].g_col\[0\].pe__2061_/Y
+ g_row\[1\].g_col\[0\].pe__2062_/X g_row\[1\].g_col\[0\].pe__2063_/B1 g_row\[1\].g_col\[0\].pe__1950_/A
+ VGND VGND VPWR VPWR g_row\[1\].g_col\[0\].pe__2063_/Y sky130_fd_sc_hd__a32oi_2
XFILLER_42_490 VGND VGND VPWR VPWR sky130_fd_sc_hd__decap_3
Xclkbuf_leaf_41_clk clkbuf_4_12_0_clk/X VGND VGND VPWR VPWR clkbuf_leaf_41_clk/X sky130_fd_sc_hd__clkbuf_16
Xg_row\[0\].g_col\[0\].pe__2210_ g_row\[0\].g_col\[0\].pe__2210_/A g_row\[0\].g_col\[0\].pe__2210_/B
+ VGND VGND VPWR VPWR g_row\[0\].g_col\[0\].pe__2211_/A sky130_fd_sc_hd__xor2_2
Xg_row\[0\].g_col\[0\].pe__2141_ g_row\[0\].g_col\[0\].pe__2174_/A g_row\[0\].g_col\[0\].pe__2174_/B
+ VGND VGND VPWR VPWR g_row\[0\].g_col\[0\].pe__2187_/B sky130_fd_sc_hd__xor2_2
XTAP_TAPCELL_ROW_12_393 VGND VPWR sky130_fd_sc_hd__tapvpwrvgnd_1
Xg_row\[0\].g_col\[0\].pe__2072_ g_row\[0\].g_col\[0\].pe__2038_/B g_row\[0\].g_col\[0\].pe__2038_/C
+ g_row\[0\].g_col\[0\].pe__2038_/A VGND VGND VPWR VPWR g_row\[0\].g_col\[0\].pe__2077_/A
+ sky130_fd_sc_hd__a21boi_2
Xg_row\[1\].g_col\[1\].pe__1932_ g_row\[1\].g_col\[1\].pe__1877_/B g_row\[1\].g_col\[1\].pe__1932_/B
+ VGND VGND VPWR VPWR g_row\[1\].g_col\[1\].pe__1932_/X sky130_fd_sc_hd__and2b_2
Xg_row\[1\].g_col\[0\].pe__1916_ g_row\[1\].g_col\[0\].pe__1916_/A g_row\[1\].g_col\[0\].pe__1916_/B
+ VGND VGND VPWR VPWR g_row\[1\].g_col\[0\].pe__1931_/A sky130_fd_sc_hd__xor2_2
XTAP_TAPCELL_ROW_77_1365 VGND VPWR sky130_fd_sc_hd__tapvpwrvgnd_1
Xg_row\[1\].g_col\[1\].pe__1863_ g_row\[1\].g_col\[1\].pe__2036_/B2 g_row\[1\].g_col\[1\].pe__2163_/B
+ g_row\[1\].g_col\[1\].pe__1863_/B1 g_row\[1\].g_col\[1\].pe__2177_/B2 VGND VGND
+ VPWR VPWR g_row\[1\].g_col\[1\].pe__1864_/B sky130_fd_sc_hd__a22o_2
XFILLER_89_608 VGND VGND VPWR VPWR sky130_fd_sc_hd__fill_1
Xg_row\[1\].g_col\[0\].pe__1847_ g_row\[1\].g_col\[0\].pe__1847_/A g_row\[1\].g_col\[0\].pe__1847_/B
+ VGND VGND VPWR VPWR g_row\[1\].g_col\[0\].pe__1888_/B sky130_fd_sc_hd__nor2_2
Xg_row\[1\].g_col\[1\].pe__1794_ g_row\[1\].g_col\[1\].pe__1794_/A g_row\[1\].g_col\[1\].pe__1794_/B
+ VGND VGND VPWR VPWR g_row\[1\].g_col\[1\].pe__1795_/C sky130_fd_sc_hd__or2_4
Xg_row\[1\].g_col\[0\].pe__1778_ g_row\[1\].g_col\[0\].pe__1778_/A g_row\[1\].g_col\[0\].pe__1816_/C
+ VGND VGND VPWR VPWR g_row\[1\].g_col\[0\].pe__1813_/B sky130_fd_sc_hd__xnor2_2
XTAP_TAPCELL_ROW_90_1554 VGND VPWR sky130_fd_sc_hd__tapvpwrvgnd_1
XTAP_TAPCELL_ROW_90_1565 VGND VPWR sky130_fd_sc_hd__tapvpwrvgnd_1
XFILLER_57_505 VGND VGND VPWR VPWR sky130_fd_sc_hd__decap_3
Xg_row\[0\].g_col\[0\].pe__1925_ g_row\[0\].g_col\[0\].pe__1924_/B g_row\[0\].g_col\[0\].pe__1924_/C
+ g_row\[0\].g_col\[0\].pe__2094_/A VGND VGND VPWR VPWR g_row\[0\].g_col\[0\].pe__1980_/C
+ sky130_fd_sc_hd__o21a_2
Xhold1504 hold3362/X VGND VGND VPWR VPWR hold3363/A sky130_fd_sc_hd__clkbuf_2
Xhold1515 hold2586/X VGND VGND VPWR VPWR hold2587/A sky130_fd_sc_hd__clkbuf_2
Xhold1526 hold3345/X VGND VGND VPWR VPWR hold3346/A sky130_fd_sc_hd__clkbuf_2
Xg_row\[0\].g_col\[1\].pe__1941_ g_row\[0\].g_col\[1\].pe__1941_/A g_row\[0\].g_col\[1\].pe__1941_/B
+ g_row\[0\].g_col\[1\].pe__1941_/C VGND VGND VPWR VPWR g_row\[0\].g_col\[1\].pe__1942_/B
+ sky130_fd_sc_hd__and3_2
Xhold1537 hold3306/X VGND VGND VPWR VPWR hold3307/A sky130_fd_sc_hd__clkbuf_2
Xhold1548 hold2646/X VGND VGND VPWR VPWR hold2647/A sky130_fd_sc_hd__clkbuf_2
Xhold1559 hold3492/X VGND VGND VPWR VPWR hold3493/A sky130_fd_sc_hd__clkbuf_2
Xg_row\[1\].g_col\[1\].pe__2415_ g_row\[1\].g_col\[1\].pe__2450_/A1 g_row\[1\].g_col\[1\].pe__2746_/Q
+ g_row\[1\].g_col\[1\].pe__2439_/B VGND VGND VPWR VPWR g_row\[1\].g_col\[1\].pe__2436_/B
+ sky130_fd_sc_hd__a21o_2
Xg_row\[0\].g_col\[1\].pe__1872_ g_row\[0\].g_col\[1\].pe__2627_/B g_row\[0\].g_col\[1\].pe__1982_/B
+ g_row\[0\].g_col\[1\].pe__1424_/Y g_row\[0\].g_col\[1\].pe__2030_/A VGND VGND VPWR
+ VPWR g_row\[0\].g_col\[1\].pe__1873_/B sky130_fd_sc_hd__a22o_2
XFILLER_38_763 VGND VGND VPWR VPWR sky130_fd_sc_hd__fill_2
Xg_row\[0\].g_col\[0\].pe__1856_ g_row\[0\].g_col\[0\].pe__1857_/A g_row\[0\].g_col\[0\].pe__1857_/B
+ VGND VGND VPWR VPWR g_row\[0\].g_col\[0\].pe__1908_/A sky130_fd_sc_hd__nand2_2
XFILLER_25_424 VGND VGND VPWR VPWR sky130_fd_sc_hd__fill_2
XFILLER_65_582 VGND VGND VPWR VPWR sky130_fd_sc_hd__decap_3
Xg_row\[0\].g_col\[0\].pe__1787_ g_row\[0\].g_col\[0\].pe__1791_/A g_row\[0\].g_col\[0\].pe__1797_/A
+ VGND VGND VPWR VPWR g_row\[0\].g_col\[0\].pe__1789_/B sky130_fd_sc_hd__xor2_2
Xg_row\[1\].g_col\[1\].pe__2346_ g_row\[1\].g_col\[1\].pe__2346_/A g_row\[1\].g_col\[1\].pe__2346_/B
+ VGND VGND VPWR VPWR g_row\[1\].g_col\[1\].pe__2347_/B sky130_fd_sc_hd__nand2_2
Xg_row\[1\].g_col\[0\].pe_place909 g_row\[1\].g_col\[0\].pe__2406_/Y VGND VGND VPWR
+ VPWR g_row\[1\].g_col\[0\].pe__2591_/A2 sky130_fd_sc_hd__buf_6
Xg_row\[1\].g_col\[1\].pe__2277_ g_row\[1\].g_col\[1\].pe__2277_/A g_row\[1\].g_col\[1\].pe__2277_/B
+ VGND VGND VPWR VPWR g_row\[1\].g_col\[1\].pe__2285_/A sky130_fd_sc_hd__and2_2
Xclkbuf_leaf_32_clk clkbuf_4_6_0_clk/X VGND VGND VPWR VPWR clkbuf_leaf_32_clk/X sky130_fd_sc_hd__clkbuf_16
Xg_row\[0\].g_col\[0\].pe__2408_ g_row\[0\].g_col\[0\].pe__2739_/Q VGND VGND VPWR
+ VPWR g_row\[0\].g_col\[0\].pe__2410_/B sky130_fd_sc_hd__inv_2
Xg_row\[1\].g_col\[0\].pe_place1075 g_row\[1\].g_col\[0\].pe__1749_/A1 VGND VGND VPWR
+ VPWR g_row\[1\].g_col\[0\].pe__1804_/A sky130_fd_sc_hd__buf_6
Xg_row\[1\].g_col\[0\].pe_place1064 g_row\[1\].g_col\[0\].pe__1910_/A VGND VGND VPWR
+ VPWR g_row\[1\].g_col\[0\].pe__1816_/A sky130_fd_sc_hd__buf_6
Xg_row\[0\].g_col\[1\].pe__2424_ g_row\[0\].g_col\[1\].pe__2424_/A g_row\[0\].g_col\[1\].pe__2424_/B
+ VGND VGND VPWR VPWR g_row\[0\].g_col\[1\].pe__2425_/B sky130_fd_sc_hd__and2_2
XTAP_TAPCELL_ROW_51_978 VGND VPWR sky130_fd_sc_hd__tapvpwrvgnd_1
Xg_row\[1\].g_col\[0\].pe_place1097 place1098/X VGND VGND VPWR VPWR g_row\[1\].g_col\[0\].pe__2610_/B
+ sky130_fd_sc_hd__buf_6
Xg_row\[0\].g_col\[1\].pe__2355_ g_row\[0\].g_col\[1\].pe__2355_/A g_row\[0\].g_col\[1\].pe__2355_/B
+ VGND VGND VPWR VPWR g_row\[0\].g_col\[1\].pe__2356_/B sky130_fd_sc_hd__nor2_2
XFILLER_20_173 VGND VGND VPWR VPWR sky130_fd_sc_hd__fill_2
XTAP_TAPCELL_ROW_31_680 VGND VPWR sky130_fd_sc_hd__tapvpwrvgnd_1
Xg_row\[0\].g_col\[0\].pe__2339_ g_row\[0\].g_col\[0\].pe__2311_/A g_row\[0\].g_col\[0\].pe__2311_/B
+ g_row\[0\].g_col\[0\].pe__2319_/B g_row\[0\].g_col\[0\].pe__2318_/B g_row\[0\].g_col\[0\].pe__2318_/A
+ VGND VGND VPWR VPWR g_row\[0\].g_col\[0\].pe__2350_/A sky130_fd_sc_hd__a32o_2
Xg_row\[0\].g_col\[1\].pe__2286_ g_row\[0\].g_col\[1\].pe__2286_/A g_row\[0\].g_col\[1\].pe__2310_/B
+ VGND VGND VPWR VPWR g_row\[0\].g_col\[1\].pe__2309_/B sky130_fd_sc_hd__xnor2_2
XFILLER_0_501 VGND VGND VPWR VPWR sky130_fd_sc_hd__decap_3
XFILLER_88_630 VGND VGND VPWR VPWR sky130_fd_sc_hd__decap_3
Xclkbuf_leaf_99_clk clkbuf_4_2_0_clk/X VGND VGND VPWR VPWR _337_/CLK sky130_fd_sc_hd__clkbuf_16
Xhold3451 hold3451/A VGND VGND VPWR VPWR hold3451/X sky130_fd_sc_hd__clkbuf_2
Xhold3440 hold3440/A VGND VGND VPWR VPWR hold3440/X sky130_fd_sc_hd__clkbuf_2
XFILLER_48_527 VGND VGND VPWR VPWR sky130_fd_sc_hd__decap_3
Xhold2750 hold3508/X VGND VGND VPWR VPWR hold3509/A sky130_fd_sc_hd__clkbuf_2
Xoutput1390 output1390/A VGND VGND VPWR VPWR results_flat[41] sky130_fd_sc_hd__buf_2
Xhold3495 hold3495/A VGND VGND VPWR VPWR hold3495/X sky130_fd_sc_hd__clkbuf_2
Xhold3484 hold3484/A VGND VGND VPWR VPWR hold3484/X sky130_fd_sc_hd__clkbuf_2
Xhold3473 a_inputs_flat[17] VGND VGND VPWR VPWR hold3473/X sky130_fd_sc_hd__clkbuf_2
Xhold3462 hold3462/A VGND VGND VPWR VPWR hold3462/X sky130_fd_sc_hd__clkbuf_2
XFILLER_75_335 VGND VGND VPWR VPWR sky130_fd_sc_hd__fill_1
XFILLER_87_173 VGND VGND VPWR VPWR sky130_fd_sc_hd__decap_3
Xhold2761 hold2761/A VGND VGND VPWR VPWR _303_/D sky130_fd_sc_hd__clkbuf_2
Xhold2772 _191_/Y VGND VGND VPWR VPWR hold2772/X sky130_fd_sc_hd__clkbuf_2
Xhold2783 hold2783/A VGND VGND VPWR VPWR _169_/B_N sky130_fd_sc_hd__clkbuf_2
XFILLER_63_508 VGND VGND VPWR VPWR sky130_fd_sc_hd__decap_3
Xhold2794 hold3581/X VGND VGND VPWR VPWR hold3582/A sky130_fd_sc_hd__clkbuf_2
XFILLER_29_785 VGND VGND VPWR VPWR sky130_fd_sc_hd__fill_2
XTAP_TAPCELL_ROW_39_791 VGND VPWR sky130_fd_sc_hd__tapvpwrvgnd_1
XFILLER_31_438 VGND VGND VPWR VPWR sky130_fd_sc_hd__decap_3
XTAP_TAPCELL_ROW_61_1122 VGND VPWR sky130_fd_sc_hd__tapvpwrvgnd_1
Xclkbuf_leaf_23_clk clkload2/A VGND VGND VPWR VPWR _288_/CLK sky130_fd_sc_hd__clkbuf_16
XFILLER_12_696 VGND VGND VPWR VPWR sky130_fd_sc_hd__decap_3
XFILLER_8_623 VGND VGND VPWR VPWR sky130_fd_sc_hd__decap_3
XFILLER_11_184 VGND VGND VPWR VPWR sky130_fd_sc_hd__decap_3
Xg_row\[1\].g_col\[0\].pe__2750_ clkbuf_leaf_55_clk/X g_row\[1\].g_col\[0\].pe__2750_/D
+ VGND VGND VPWR VPWR g_row\[1\].g_col\[0\].pe__2750_/Q sky130_fd_sc_hd__dfxtp_2
XFILLER_4_840 VGND VGND VPWR VPWR sky130_fd_sc_hd__fill_2
Xg_row\[1\].g_col\[0\].pe__2681_ g_row\[1\].g_col\[0\].pe__2681_/A1 g_row\[1\].g_col\[0\].pe__2680_/B
+ g_row\[1\].g_col\[0\].pe__2681_/B1 g_row\[1\].g_col\[0\].pe__2687_/C1 VGND VGND
+ VPWR VPWR g_row\[1\].g_col\[0\].pe__2681_/X sky130_fd_sc_hd__o211a_2
Xg_row\[1\].g_col\[0\].pe__1701_ g_row\[1\].g_col\[0\].pe__1701_/A g_row\[1\].g_col\[0\].pe__1701_/B
+ VGND VGND VPWR VPWR g_row\[1\].g_col\[0\].pe__1827_/B sky130_fd_sc_hd__xnor2_2
XTAP_TAPCELL_ROW_59_1095 VGND VPWR sky130_fd_sc_hd__tapvpwrvgnd_1
Xg_row\[1\].g_col\[0\].pe_hold3104 g_row\[1\].g_col\[0\].pe__2726_/Q VGND VGND VPWR
+ VPWR g_row\[1\].g_col\[0\].pe__2686_/A sky130_fd_sc_hd__clkbuf_2
Xg_row\[1\].g_col\[0\].pe__1632_ g_row\[1\].g_col\[0\].pe__1883_/A g_row\[1\].g_col\[0\].pe__1883_/B
+ VGND VGND VPWR VPWR g_row\[1\].g_col\[0\].pe__1633_/B sky130_fd_sc_hd__xnor2_2
XPHY_EDGE_ROW_13_Left_107 VGND VGND VPWR VPWR sky130_fd_sc_hd__decap_3
XTAP_TAPCELL_ROW_72_1284 VGND VPWR sky130_fd_sc_hd__tapvpwrvgnd_1
XTAP_TAPCELL_ROW_72_1295 VGND VPWR sky130_fd_sc_hd__tapvpwrvgnd_1
Xg_row\[1\].g_col\[0\].pe__1563_ g_row\[1\].g_col\[0\].pe__1846_/A g_row\[1\].g_col\[0\].pe__1563_/B
+ VGND VGND VPWR VPWR g_row\[1\].g_col\[0\].pe__1587_/A sky130_fd_sc_hd__or2_2
XFILLER_39_549 VGND VGND VPWR VPWR sky130_fd_sc_hd__decap_3
XFILLER_78_184 VGND VGND VPWR VPWR sky130_fd_sc_hd__fill_1
Xg_row\[0\].g_col\[0\].pe__1710_ place1216/X g_row\[0\].g_col\[0\].pe__1732_/A2 g_row\[0\].g_col\[0\].pe__1732_/B1
+ place1217/X VGND VGND VPWR VPWR g_row\[0\].g_col\[0\].pe__1711_/B sky130_fd_sc_hd__a22o_2
Xg_row\[1\].g_col\[0\].pe_hold1735 g_row\[1\].g_col\[0\].pe__2576_/X VGND VGND VPWR
+ VPWR g_row\[1\].g_col\[0\].pe__2577_/B sky130_fd_sc_hd__clkbuf_2
Xg_row\[1\].g_col\[0\].pe_hold1724 g_row\[1\].g_col\[0\].pe_hold3094/X VGND VGND VPWR
+ VPWR g_row\[1\].g_col\[0\].pe__1384_/A1 sky130_fd_sc_hd__clkbuf_2
Xg_row\[1\].g_col\[0\].pe__1494_ g_row\[1\].g_col\[0\].pe__2610_/B g_row\[1\].g_col\[0\].pe__1715_/B
+ g_row\[1\].g_col\[0\].pe__1863_/B1 place1099/X VGND VGND VPWR VPWR g_row\[1\].g_col\[0\].pe__1495_/B
+ sky130_fd_sc_hd__a22o_2
XFILLER_82_817 VGND VGND VPWR VPWR sky130_fd_sc_hd__fill_2
Xg_row\[0\].g_col\[0\].pe__2690_ clkload12/A g_row\[0\].g_col\[0\].pe__2690_/D VGND
+ VGND VPWR VPWR place1223/A sky130_fd_sc_hd__dfxtp_2
Xg_row\[1\].g_col\[1\].pe__2200_ g_row\[1\].g_col\[1\].pe__2200_/A g_row\[1\].g_col\[1\].pe__2200_/B
+ VGND VGND VPWR VPWR g_row\[1\].g_col\[1\].pe__2299_/A sky130_fd_sc_hd__or2_4
Xg_row\[1\].g_col\[0\].pe_hold1757 g_row\[1\].g_col\[0\].pe__2564_/X VGND VGND VPWR
+ VPWR g_row\[1\].g_col\[0\].pe__2565_/B sky130_fd_sc_hd__clkbuf_2
XFILLER_93_176 VGND VGND VPWR VPWR sky130_fd_sc_hd__fill_2
Xg_row\[0\].g_col\[0\].pe__1641_ g_row\[0\].g_col\[0\].pe__1804_/A place1204/X place1205/X
+ g_row\[0\].g_col\[0\].pe__1804_/B VGND VGND VPWR VPWR g_row\[0\].g_col\[0\].pe__1642_/B
+ sky130_fd_sc_hd__a22o_2
XFILLER_34_221 VGND VGND VPWR VPWR sky130_fd_sc_hd__decap_3
XFILLER_62_552 VGND VGND VPWR VPWR sky130_fd_sc_hd__decap_3
Xg_row\[0\].g_col\[0\].pe__1572_ g_row\[0\].g_col\[0\].pe__1761_/A1 g_row\[0\].g_col\[1\].pe__2635_/C
+ place1195/X g_row\[0\].g_col\[0\].pe__1616_/A2 VGND VGND VPWR VPWR g_row\[0\].g_col\[0\].pe__1573_/B
+ sky130_fd_sc_hd__a22o_2
Xg_row\[1\].g_col\[1\].pe__2131_ g_row\[1\].g_col\[1\].pe__2209_/A g_row\[1\].g_col\[1\].pe__2131_/B
+ VGND VGND VPWR VPWR g_row\[1\].g_col\[1\].pe__2132_/B sky130_fd_sc_hd__xnor2_2
Xg_row\[1\].g_col\[0\].pe__2115_ g_row\[1\].g_col\[0\].pe__2514_/A g_row\[1\].g_col\[0\].pe__2115_/B
+ VGND VGND VPWR VPWR g_row\[1\].g_col\[0\].pe__2744_/D sky130_fd_sc_hd__nor2_2
XFILLER_35_777 VGND VGND VPWR VPWR sky130_fd_sc_hd__fill_2
XPHY_EDGE_ROW_22_Left_116 VGND VGND VPWR VPWR sky130_fd_sc_hd__decap_3
XTAP_TAPCELL_ROW_17_463 VGND VPWR sky130_fd_sc_hd__tapvpwrvgnd_1
Xg_row\[1\].g_col\[1\].pe__2062_ g_row\[1\].g_col\[1\].pe__2062_/A g_row\[1\].g_col\[1\].pe__2150_/C
+ g_row\[1\].g_col\[1\].pe__2062_/C VGND VGND VPWR VPWR g_row\[1\].g_col\[1\].pe__2062_/X
+ sky130_fd_sc_hd__or3_2
XFILLER_50_736 VGND VGND VPWR VPWR sky130_fd_sc_hd__decap_3
Xg_row\[1\].g_col\[0\].pe__2046_ g_row\[1\].g_col\[0\].pe__2094_/B g_row\[1\].g_col\[0\].pe__1988_/B
+ g_row\[1\].g_col\[0\].pe__1988_/C g_row\[1\].g_col\[0\].pe__2045_/X VGND VGND VPWR
+ VPWR g_row\[1\].g_col\[0\].pe__2047_/B sky130_fd_sc_hd__a31o_2
Xclkbuf_leaf_14_clk clkload2/A VGND VGND VPWR VPWR clkbuf_leaf_14_clk/X sky130_fd_sc_hd__clkbuf_16
XFILLER_30_471 VGND VGND VPWR VPWR sky130_fd_sc_hd__decap_3
Xg_row\[0\].g_col\[0\].pe__2124_ g_row\[0\].g_col\[0\].pe__2123_/B g_row\[0\].g_col\[0\].pe__2123_/C
+ g_row\[0\].g_col\[0\].pe__2123_/A VGND VGND VPWR VPWR g_row\[0\].g_col\[0\].pe__2128_/C
+ sky130_fd_sc_hd__a21o_2
Xg_row\[0\].g_col\[1\].pe__2140_ g_row\[0\].g_col\[1\].pe__2364_/A g_row\[0\].g_col\[1\].pe__2140_/B
+ VGND VGND VPWR VPWR g_row\[0\].g_col\[1\].pe__2174_/B sky130_fd_sc_hd__xnor2_2
Xg_row\[0\].g_col\[1\].pe__2071_ g_row\[0\].g_col\[1\].pe__2071_/A g_row\[0\].g_col\[1\].pe__2071_/B
+ VGND VGND VPWR VPWR g_row\[0\].g_col\[1\].pe__2078_/A sky130_fd_sc_hd__and2_2
Xg_row\[0\].g_col\[0\].pe__2055_ g_row\[0\].g_col\[0\].pe__2055_/A g_row\[0\].g_col\[0\].pe__2055_/B
+ VGND VGND VPWR VPWR g_row\[0\].g_col\[0\].pe__2055_/Y sky130_fd_sc_hd__nor2_2
Xg_row\[1\].g_col\[1\].pe__1915_ g_row\[1\].g_col\[1\].pe__2209_/A g_row\[1\].g_col\[1\].pe__1915_/B
+ VGND VGND VPWR VPWR g_row\[1\].g_col\[1\].pe__1916_/B sky130_fd_sc_hd__xnor2_2
XPHY_EDGE_ROW_31_Left_125 VGND VGND VPWR VPWR sky130_fd_sc_hd__decap_3
XPHY_EDGE_ROW_4_Right_4 VGND VGND VPWR VPWR sky130_fd_sc_hd__decap_3
Xg_row\[1\].g_col\[1\].pe__1846_ g_row\[1\].g_col\[1\].pe__1846_/A VGND VGND VPWR
+ VPWR g_row\[1\].g_col\[1\].pe__1847_/A sky130_fd_sc_hd__inv_2
XFILLER_69_151 VGND VGND VPWR VPWR sky130_fd_sc_hd__fill_1
Xg_row\[1\].g_col\[1\].pe__1777_ g_row\[1\].g_col\[1\].pe__1777_/A g_row\[1\].g_col\[1\].pe__1777_/B
+ VGND VGND VPWR VPWR g_row\[1\].g_col\[1\].pe__1816_/C sky130_fd_sc_hd__xor2_2
XFILLER_84_110 VGND VGND VPWR VPWR sky130_fd_sc_hd__fill_1
Xg_row\[0\].g_col\[1\].pe__1924_ g_row\[0\].g_col\[1\].pe__2094_/A g_row\[0\].g_col\[1\].pe__1924_/B
+ g_row\[0\].g_col\[1\].pe__1924_/C VGND VGND VPWR VPWR g_row\[0\].g_col\[1\].pe__1980_/B
+ sky130_fd_sc_hd__nor3_2
XFILLER_57_357 VGND VGND VPWR VPWR sky130_fd_sc_hd__fill_2
XFILLER_85_655 VGND VGND VPWR VPWR sky130_fd_sc_hd__decap_3
Xg_row\[0\].g_col\[0\].pe__1908_ g_row\[0\].g_col\[0\].pe__1908_/A g_row\[0\].g_col\[0\].pe__1908_/B
+ VGND VGND VPWR VPWR g_row\[0\].g_col\[0\].pe__1935_/A sky130_fd_sc_hd__xor2_2
XFILLER_27_47 VGND VGND VPWR VPWR sky130_fd_sc_hd__fill_1
XFILLER_38_560 VGND VGND VPWR VPWR sky130_fd_sc_hd__fill_1
XFILLER_84_187 VGND VGND VPWR VPWR sky130_fd_sc_hd__fill_2
Xg_row\[0\].g_col\[1\].pe__1855_ g_row\[0\].g_col\[1\].pe__2179_/A g_row\[0\].g_col\[1\].pe__1855_/B
+ VGND VGND VPWR VPWR g_row\[0\].g_col\[1\].pe__1857_/B sky130_fd_sc_hd__xnor2_2
XFILLER_26_766 VGND VGND VPWR VPWR sky130_fd_sc_hd__fill_1
XPHY_EDGE_ROW_40_Left_134 VGND VGND VPWR VPWR sky130_fd_sc_hd__decap_3
Xg_row\[1\].g_col\[1\].pe__2329_ g_row\[1\].g_col\[1\].pe__2329_/A g_row\[1\].g_col\[1\].pe__2329_/B
+ VGND VGND VPWR VPWR g_row\[1\].g_col\[1\].pe__2329_/Y sky130_fd_sc_hd__xnor2_2
Xg_row\[0\].g_col\[1\].pe__1786_ g_row\[0\].g_col\[1\].pe__1796_/A g_row\[0\].g_col\[1\].pe__1796_/B
+ VGND VGND VPWR VPWR g_row\[0\].g_col\[1\].pe__1797_/A sky130_fd_sc_hd__nand2_2
XTAP_TAPCELL_ROW_36_750 VGND VPWR sky130_fd_sc_hd__tapvpwrvgnd_1
XFILLER_13_427 VGND VGND VPWR VPWR sky130_fd_sc_hd__fill_1
XFILLER_13_449 VGND VGND VPWR VPWR sky130_fd_sc_hd__decap_3
Xclkbuf_4_8_0_clk clkbuf_0_clk/X VGND VGND VPWR VPWR clkbuf_4_8_0_clk/X sky130_fd_sc_hd__clkbuf_16
XFILLER_43_57 VGND VGND VPWR VPWR sky130_fd_sc_hd__fill_1
Xg_row\[0\].g_col\[1\].pe__2338_ g_row\[0\].g_col\[1\].pe__2338_/A g_row\[0\].g_col\[1\].pe__2325_/A
+ VGND VGND VPWR VPWR g_row\[0\].g_col\[1\].pe__2352_/B sky130_fd_sc_hd__or2b_2
Xinput1288 hold3538/X VGND VGND VPWR VPWR hold3539/A sky130_fd_sc_hd__buf_2
Xinput1299 hold3378/X VGND VGND VPWR VPWR hold3379/A sky130_fd_sc_hd__buf_2
Xg_row\[0\].g_col\[1\].pe__2269_ g_row\[0\].g_col\[1\].pe__2269_/A VGND VGND VPWR
+ VPWR g_row\[0\].g_col\[1\].pe__2432_/A sky130_fd_sc_hd__inv_2
XFILLER_4_29 VGND VGND VPWR VPWR sky130_fd_sc_hd__fill_2
Xg_row\[1\].g_col\[1\].pe_hold1810 g_row\[1\].g_col\[1\].pe__2762_/Q VGND VGND VPWR
+ VPWR g_row\[1\].g_col\[1\].pe__2554_/A1 sky130_fd_sc_hd__clkbuf_2
XFILLER_68_21 VGND VGND VPWR VPWR sky130_fd_sc_hd__decap_3
XFILLER_49_803 VGND VGND VPWR VPWR sky130_fd_sc_hd__fill_1
XFILLER_68_76 VGND VGND VPWR VPWR sky130_fd_sc_hd__fill_1
XFILLER_76_611 VGND VGND VPWR VPWR sky130_fd_sc_hd__decap_3
XFILLER_76_633 VGND VGND VPWR VPWR sky130_fd_sc_hd__decap_3
Xhold3270 enable VGND VGND VPWR VPWR hold3270/X sky130_fd_sc_hd__clkbuf_2
Xhold3281 hold3281/A VGND VGND VPWR VPWR hold3281/X sky130_fd_sc_hd__clkbuf_2
Xhold3292 hold3292/A VGND VGND VPWR VPWR hold3292/X sky130_fd_sc_hd__clkbuf_2
XFILLER_48_346 VGND VGND VPWR VPWR sky130_fd_sc_hd__fill_1
Xhold2580 _163_/Y VGND VGND VPWR VPWR hold2580/X sky130_fd_sc_hd__clkbuf_2
Xhold2591 hold3346/X VGND VGND VPWR VPWR _259_/B_N sky130_fd_sc_hd__clkbuf_2
XFILLER_17_722 VGND VGND VPWR VPWR sky130_fd_sc_hd__decap_3
XFILLER_90_135 VGND VGND VPWR VPWR sky130_fd_sc_hd__fill_1
XFILLER_91_658 VGND VGND VPWR VPWR sky130_fd_sc_hd__decap_3
XFILLER_91_669 VGND VGND VPWR VPWR sky130_fd_sc_hd__decap_3
XFILLER_71_393 VGND VGND VPWR VPWR sky130_fd_sc_hd__fill_2
XTAP_TAPCELL_ROW_14_422 VGND VPWR sky130_fd_sc_hd__tapvpwrvgnd_1
XFILLER_31_246 VGND VGND VPWR VPWR sky130_fd_sc_hd__decap_3
XFILLER_8_442 VGND VGND VPWR VPWR sky130_fd_sc_hd__fill_1
XTAP_TAPCELL_ROW_74_1313 VGND VPWR sky130_fd_sc_hd__tapvpwrvgnd_1
Xg_row\[1\].g_col\[0\].pe__2733_ clkbuf_leaf_45_clk/X g_row\[1\].g_col\[0\].pe__2733_/D
+ VGND VGND VPWR VPWR g_row\[1\].g_col\[0\].pe__2733_/Q sky130_fd_sc_hd__dfxtp_2
XTAP_TAPCELL_ROW_74_1324 VGND VPWR sky130_fd_sc_hd__tapvpwrvgnd_1
Xg_row\[1\].g_col\[1\].pe__2680_ g_row\[1\].g_col\[1\].pe__2680_/A g_row\[1\].g_col\[1\].pe__2680_/B
+ VGND VGND VPWR VPWR g_row\[1\].g_col\[1\].pe__2680_/Y sky130_fd_sc_hd__nand2_2
Xg_row\[1\].g_col\[1\].pe__1700_ g_row\[1\].g_col\[1\].pe__1823_/A g_row\[1\].g_col\[1\].pe__1823_/B
+ g_row\[1\].g_col\[1\].pe__1699_/X VGND VGND VPWR VPWR g_row\[1\].g_col\[1\].pe__1827_/A
+ sky130_fd_sc_hd__a21oi_2
XFILLER_4_681 VGND VGND VPWR VPWR sky130_fd_sc_hd__fill_1
Xg_row\[1\].g_col\[1\].pe__1631_ g_row\[1\].g_col\[1\].pe__1583_/A g_row\[1\].g_col\[1\].pe__1583_/B
+ g_row\[1\].g_col\[1\].pe__1630_/X VGND VGND VPWR VPWR g_row\[1\].g_col\[1\].pe__1883_/B
+ sky130_fd_sc_hd__a21oi_2
Xg_row\[1\].g_col\[0\].pe__2664_ g_row\[1\].g_col\[0\].pe__2670_/A1 g_row\[1\].g_col\[0\].pe__2664_/A2
+ g_row\[1\].g_col\[0\].pe__2670_/B1 g_row\[1\].g_col\[0\].pe__2664_/C1 VGND VGND
+ VPWR VPWR g_row\[1\].g_col\[0\].pe__2664_/X sky130_fd_sc_hd__o211a_2
Xclkbuf_leaf_3_clk clkbuf_4_0_0_clk/X VGND VGND VPWR VPWR clkbuf_leaf_3_clk/X sky130_fd_sc_hd__clkbuf_16
Xg_row\[1\].g_col\[0\].pe_hold2222 g_row\[1\].g_col\[0\].pe__2722_/Q VGND VGND VPWR
+ VPWR g_row\[1\].g_col\[0\].pe_hold2222/X sky130_fd_sc_hd__clkbuf_2
Xg_row\[1\].g_col\[0\].pe__2595_ g_row\[1\].g_col\[0\].pe__2595_/A g_row\[1\].g_col\[0\].pe__2595_/B
+ VGND VGND VPWR VPWR g_row\[1\].g_col\[0\].pe__2771_/D sky130_fd_sc_hd__and2_2
Xg_row\[1\].g_col\[0\].pe__1615_ g_row\[1\].g_col\[0\].pe__1615_/A g_row\[1\].g_col\[0\].pe__1615_/B
+ VGND VGND VPWR VPWR g_row\[1\].g_col\[0\].pe__1629_/A sky130_fd_sc_hd__xor2_2
Xg_row\[1\].g_col\[1\].pe__1562_ g_row\[1\].g_col\[1\].pe__1562_/A g_row\[1\].g_col\[1\].pe__1562_/B
+ g_row\[1\].g_col\[1\].pe__1562_/C VGND VGND VPWR VPWR g_row\[1\].g_col\[1\].pe__1563_/B
+ sky130_fd_sc_hd__nor3_2
Xg_row\[1\].g_col\[0\].pe_hold2233 g_row\[1\].g_col\[0\].pe__2360_/X VGND VGND VPWR
+ VPWR g_row\[1\].g_col\[0\].pe__2361_/B sky130_fd_sc_hd__clkbuf_2
Xg_row\[1\].g_col\[0\].pe__1546_ g_row\[1\].g_col\[0\].pe__1546_/A g_row\[1\].g_col\[0\].pe__1546_/B
+ VGND VGND VPWR VPWR g_row\[1\].g_col\[0\].pe__1547_/B sky130_fd_sc_hd__xnor2_2
XFILLER_27_508 VGND VGND VPWR VPWR sky130_fd_sc_hd__decap_3
Xg_row\[0\].g_col\[0\].pe__2742_ clkbuf_leaf_24_clk/X g_row\[0\].g_col\[0\].pe__2742_/D
+ VGND VGND VPWR VPWR g_row\[0\].g_col\[0\].pe__2742_/Q sky130_fd_sc_hd__dfxtp_2
Xg_row\[1\].g_col\[1\].pe_place836 g_row\[1\].g_col\[1\].pe__1471_/X VGND VGND VPWR
+ VPWR g_row\[1\].g_col\[1\].pe__1657_/B sky130_fd_sc_hd__buf_6
Xg_row\[1\].g_col\[1\].pe__1493_ g_row\[1\].g_col\[1\].pe__1739_/A g_row\[1\].g_col\[1\].pe__1493_/B
+ VGND VGND VPWR VPWR g_row\[1\].g_col\[1\].pe__1536_/A sky130_fd_sc_hd__xor2_2
XFILLER_54_305 VGND VGND VPWR VPWR sky130_fd_sc_hd__decap_3
Xg_row\[0\].g_col\[0\].pe__2673_ _310_/Q _309_/Q _312_/Q _311_/Q VGND VGND VPWR VPWR
+ g_row\[0\].g_col\[0\].pe__2673_/X sky130_fd_sc_hd__or4_2
Xg_row\[1\].g_col\[0\].pe__1477_ g_row\[1\].g_col\[0\].pe__1676_/A g_row\[1\].g_col\[0\].pe__1477_/B
+ VGND VGND VPWR VPWR g_row\[1\].g_col\[0\].pe__1478_/B sky130_fd_sc_hd__xnor2_2
Xg_row\[0\].g_col\[0\].pe__1624_ g_row\[0\].g_col\[0\].pe__1768_/A g_row\[0\].g_col\[0\].pe__1624_/B
+ VGND VGND VPWR VPWR g_row\[0\].g_col\[0\].pe__1625_/B sky130_fd_sc_hd__xor2_2
Xg_row\[0\].g_col\[1\].pe__1640_ g_row\[0\].g_col\[1\].pe__1640_/A g_row\[0\].g_col\[1\].pe__1640_/B
+ VGND VGND VPWR VPWR g_row\[0\].g_col\[1\].pe__1701_/A sky130_fd_sc_hd__xnor2_2
XFILLER_35_574 VGND VGND VPWR VPWR sky130_fd_sc_hd__decap_3
Xg_row\[0\].g_col\[1\].pe__1571_ g_row\[0\].g_col\[1\].pe__1571_/A g_row\[0\].g_col\[1\].pe__1571_/B
+ VGND VGND VPWR VPWR g_row\[0\].g_col\[1\].pe__1583_/A sky130_fd_sc_hd__xor2_2
Xg_row\[1\].g_col\[1\].pe__2114_ g_row\[1\].g_col\[1\].pe__2404_/A1 g_row\[1\].g_col\[1\].pe__2114_/A2
+ g_row\[1\].g_col\[1\].pe__2112_/Y g_row\[1\].g_col\[1\].pe__2113_/X VGND VGND VPWR
+ VPWR g_row\[1\].g_col\[1\].pe__2114_/X sky130_fd_sc_hd__o22a_2
XTAP_TAPCELL_ROW_85_1486 VGND VPWR sky130_fd_sc_hd__tapvpwrvgnd_1
Xg_row\[0\].g_col\[0\].pe__1555_ g_row\[0\].g_col\[0\].pe__1555_/A g_row\[0\].g_col\[0\].pe__1555_/B
+ VGND VGND VPWR VPWR g_row\[0\].g_col\[0\].pe__1562_/B sky130_fd_sc_hd__and2_2
Xg_row\[0\].g_col\[0\].pe__1486_ g_row\[0\].g_col\[0\].pe__2686_/A g_row\[0\].g_col\[0\].pe__1486_/B
+ VGND VGND VPWR VPWR g_row\[0\].g_col\[0\].pe__1514_/B sky130_fd_sc_hd__xor2_2
Xg_row\[1\].g_col\[1\].pe__2045_ g_row\[1\].g_col\[1\].pe__2726_/Q g_row\[1\].g_col\[1\].pe__2682_/A
+ VGND VGND VPWR VPWR g_row\[1\].g_col\[1\].pe__2045_/X sky130_fd_sc_hd__and2_2
Xg_row\[1\].g_col\[0\].pe__2029_ g_row\[1\].g_col\[0\].pe__2028_/B g_row\[1\].g_col\[0\].pe__2028_/C
+ g_row\[1\].g_col\[0\].pe__1910_/A VGND VGND VPWR VPWR g_row\[1\].g_col\[0\].pe__2034_/B
+ sky130_fd_sc_hd__a21bo_2
Xg_row\[0\].g_col\[1\].pe__2123_ g_row\[0\].g_col\[1\].pe__2123_/A g_row\[0\].g_col\[1\].pe__2123_/B
+ g_row\[0\].g_col\[1\].pe__2123_/C VGND VGND VPWR VPWR g_row\[0\].g_col\[1\].pe__2128_/B
+ sky130_fd_sc_hd__nand3_2
Xg_row\[0\].g_col\[0\].pe__2107_ g_row\[0\].g_col\[0\].pe__2107_/A g_row\[0\].g_col\[0\].pe__2107_/B
+ VGND VGND VPWR VPWR g_row\[0\].g_col\[0\].pe__2117_/B sky130_fd_sc_hd__xnor2_2
XFILLER_2_618 VGND VGND VPWR VPWR sky130_fd_sc_hd__fill_1
Xg_row\[0\].g_col\[0\].pe__2038_ g_row\[0\].g_col\[0\].pe__2038_/A g_row\[0\].g_col\[0\].pe__2038_/B
+ g_row\[0\].g_col\[0\].pe__2038_/C VGND VGND VPWR VPWR g_row\[0\].g_col\[0\].pe__2048_/A
+ sky130_fd_sc_hd__nand3_2
Xg_row\[0\].g_col\[1\].pe__2054_ g_row\[0\].g_col\[1\].pe__2054_/A g_row\[0\].g_col\[1\].pe__2054_/B
+ VGND VGND VPWR VPWR g_row\[0\].g_col\[1\].pe__2068_/A sky130_fd_sc_hd__nand2_2
Xg_row\[1\].g_col\[1\].pe__1829_ g_row\[1\].g_col\[1\].pe__1821_/X g_row\[1\].g_col\[1\].pe__1822_/X
+ g_row\[1\].g_col\[1\].pe__1826_/Y g_row\[1\].g_col\[1\].pe__1827_/Y g_row\[1\].g_col\[1\].pe__1828_/Y
+ VGND VGND VPWR VPWR g_row\[1\].g_col\[1\].pe__1829_/Y sky130_fd_sc_hd__o311ai_2
XFILLER_18_508 VGND VGND VPWR VPWR sky130_fd_sc_hd__fill_1
XFILLER_73_603 VGND VGND VPWR VPWR sky130_fd_sc_hd__decap_3
XFILLER_45_316 VGND VGND VPWR VPWR sky130_fd_sc_hd__decap_3
XFILLER_45_327 VGND VGND VPWR VPWR sky130_fd_sc_hd__decap_3
XPHY_EDGE_ROW_79_Right_79 VGND VGND VPWR VPWR sky130_fd_sc_hd__decap_3
Xg_row\[0\].g_col\[1\].pe__1907_ g_row\[0\].g_col\[1\].pe__1907_/A g_row\[0\].g_col\[1\].pe__1907_/B
+ VGND VGND VPWR VPWR g_row\[0\].g_col\[1\].pe__1908_/B sky130_fd_sc_hd__xor2_2
XFILLER_61_809 VGND VGND VPWR VPWR sky130_fd_sc_hd__fill_2
Xg_row\[0\].g_col\[1\].pe__1838_ g_row\[0\].g_col\[1\].pe__1838_/A place1233/X VGND
+ VGND VPWR VPWR g_row\[0\].g_col\[1\].pe__2010_/A sky130_fd_sc_hd__or2_2
XFILLER_14_736 VGND VGND VPWR VPWR sky130_fd_sc_hd__fill_1
XFILLER_41_522 VGND VGND VPWR VPWR sky130_fd_sc_hd__fill_1
XTAP_TAPCELL_ROW_0_194 VGND VPWR sky130_fd_sc_hd__tapvpwrvgnd_1
Xg_row\[0\].g_col\[0\].pe_hold2309 g_row\[0\].g_col\[0\].pe_hold2922/X VGND VGND VPWR
+ VPWR g_row\[0\].g_col\[0\].pe__2696_/D sky130_fd_sc_hd__clkbuf_2
Xg_row\[0\].g_col\[1\].pe__1769_ g_row\[0\].g_col\[1\].pe__1781_/A g_row\[0\].g_col\[1\].pe__1781_/B
+ VGND VGND VPWR VPWR g_row\[0\].g_col\[1\].pe__1793_/C sky130_fd_sc_hd__nand2_2
XPHY_EDGE_ROW_88_Right_88 VGND VGND VPWR VPWR sky130_fd_sc_hd__decap_3
Xg_row\[1\].g_col\[1\].pe_hold3020 g_row\[1\].g_col\[1\].pe__2668_/X VGND VGND VPWR
+ VPWR g_row\[1\].g_col\[1\].pe_hold3020/X sky130_fd_sc_hd__clkbuf_2
Xg_row\[1\].g_col\[1\].pe_hold3075 g_row\[1\].g_col\[1\].pe__2722_/Q VGND VGND VPWR
+ VPWR g_row\[1\].g_col\[1\].pe_hold3075/X sky130_fd_sc_hd__clkbuf_2
XFILLER_79_75 VGND VGND VPWR VPWR sky130_fd_sc_hd__decap_3
XFILLER_79_86 VGND VGND VPWR VPWR sky130_fd_sc_hd__fill_2
XFILLER_79_97 VGND VGND VPWR VPWR sky130_fd_sc_hd__decap_3
XTAP_TAPCELL_ROW_56_1043 VGND VPWR sky130_fd_sc_hd__tapvpwrvgnd_1
XTAP_TAPCELL_ROW_56_1054 VGND VPWR sky130_fd_sc_hd__tapvpwrvgnd_1
Xg_row\[1\].g_col\[1\].pe_hold3097 g_row\[1\].g_col\[1\].pe__2633_/X VGND VGND VPWR
+ VPWR g_row\[1\].g_col\[1\].pe_hold3097/X sky130_fd_sc_hd__clkbuf_2
Xg_row\[1\].g_col\[1\].pe_hold1673 g_row\[1\].g_col\[1\].pe__2738_/Q VGND VGND VPWR
+ VPWR g_row\[1\].g_col\[1\].pe__1406_/A sky130_fd_sc_hd__clkbuf_2
Xg_row\[1\].g_col\[1\].pe_hold1651 g_row\[1\].g_col\[1\].pe__2063_/Y VGND VGND VPWR
+ VPWR g_row\[1\].g_col\[1\].pe__2064_/B sky130_fd_sc_hd__clkbuf_2
XFILLER_1_673 VGND VGND VPWR VPWR sky130_fd_sc_hd__decap_3
Xg_row\[1\].g_col\[1\].pe_hold1695 g_row\[1\].g_col\[1\].pe__2746_/Q VGND VGND VPWR
+ VPWR g_row\[1\].g_col\[1\].pe__2160_/A sky130_fd_sc_hd__clkbuf_2
Xg_row\[1\].g_col\[1\].pe_hold1684 g_row\[1\].g_col\[1\].pe__2740_/Q VGND VGND VPWR
+ VPWR g_row\[1\].g_col\[1\].pe_hold1684/X sky130_fd_sc_hd__clkbuf_2
Xg_row\[1\].g_col\[0\].pe__2380_ g_row\[1\].g_col\[0\].pe__2376_/X g_row\[1\].g_col\[0\].pe__2378_/X
+ g_row\[1\].g_col\[0\].pe__2379_/Y g_row\[1\].g_col\[0\].pe__2380_/B1 g_row\[1\].g_col\[0\].pe__1950_/A
+ VGND VGND VPWR VPWR g_row\[1\].g_col\[0\].pe__2380_/X sky130_fd_sc_hd__a32o_2
Xg_row\[1\].g_col\[0\].pe__1400_ hold1884/X g_row\[1\].g_col\[0\].pe__1402_/B VGND
+ VGND VPWR VPWR g_row\[1\].g_col\[0\].pe__1400_/X sky130_fd_sc_hd__or2_2
XFILLER_0_183 VGND VGND VPWR VPWR sky130_fd_sc_hd__fill_1
XFILLER_64_636 VGND VGND VPWR VPWR sky130_fd_sc_hd__decap_3
XFILLER_76_474 VGND VGND VPWR VPWR sky130_fd_sc_hd__fill_2
Xg_row\[1\].g_col\[1\].pe_place1008 g_row\[1\].g_col\[1\].pe__1816_/A VGND VGND VPWR
+ VPWR g_row\[1\].g_col\[1\].pe__2126_/B2 sky130_fd_sc_hd__buf_6
Xg_row\[1\].g_col\[1\].pe_place1019 g_row\[1\].g_col\[1\].pe__2723_/Q VGND VGND VPWR
+ VPWR g_row\[1\].g_col\[1\].pe__1804_/A sky130_fd_sc_hd__buf_6
XFILLER_63_113 VGND VGND VPWR VPWR sky130_fd_sc_hd__fill_1
XFILLER_64_658 VGND VGND VPWR VPWR sky130_fd_sc_hd__fill_2
XFILLER_17_541 VGND VGND VPWR VPWR sky130_fd_sc_hd__decap_3
XFILLER_17_596 VGND VGND VPWR VPWR sky130_fd_sc_hd__decap_3
XFILLER_32_533 VGND VGND VPWR VPWR sky130_fd_sc_hd__fill_2
XFILLER_72_680 VGND VGND VPWR VPWR sky130_fd_sc_hd__decap_3
Xg_row\[0\].g_col\[0\].pe__1340_ g_row\[0\].g_col\[0\].pe__1340_/A VGND VGND VPWR
+ VPWR g_row\[0\].g_col\[0\].pe__2689_/A sky130_fd_sc_hd__inv_2
Xg_row\[0\].g_col\[0\].pe_hold2876 g_row\[0\].g_col\[0\].pe_hold2876/A VGND VGND VPWR
+ VPWR g_row\[0\].g_col\[0\].pe__2604_/A2 sky130_fd_sc_hd__clkbuf_2
Xg_row\[0\].g_col\[0\].pe_hold2887 g_row\[0\].g_col\[0\].pe_hold2887/A VGND VGND VPWR
+ VPWR g_row\[0\].g_col\[0\].pe__2613_/A2 sky130_fd_sc_hd__clkbuf_2
XFILLER_74_3 VGND VGND VPWR VPWR sky130_fd_sc_hd__decap_3
Xg_row\[0\].g_col\[0\].pe_hold2898 g_row\[0\].g_col\[0\].pe_hold2898/A VGND VGND VPWR
+ VPWR g_row\[0\].g_col\[0\].pe__2611_/A2 sky130_fd_sc_hd__clkbuf_2
XFILLER_9_795 VGND VGND VPWR VPWR sky130_fd_sc_hd__decap_3
Xg_row\[1\].g_col\[1\].pe__2732_ clkbuf_leaf_83_clk/X g_row\[1\].g_col\[1\].pe__2732_/D
+ VGND VGND VPWR VPWR g_row\[1\].g_col\[1\].pe__2732_/Q sky130_fd_sc_hd__dfxtp_2
Xg_row\[1\].g_col\[0\].pe__2716_ clkbuf_leaf_49_clk/X g_row\[1\].g_col\[0\].pe__2716_/D
+ VGND VGND VPWR VPWR g_row\[1\].g_col\[0\].pe__2716_/Q sky130_fd_sc_hd__dfxtp_2
Xg_row\[1\].g_col\[1\].pe__2663_ g_row\[1\].g_col\[1\].pe__2669_/A g_row\[1\].g_col\[1\].pe__2663_/B
+ VGND VGND VPWR VPWR g_row\[1\].g_col\[1\].pe__2663_/X sky130_fd_sc_hd__or2_2
Xg_row\[1\].g_col\[0\].pe__2647_ g_row\[1\].g_col\[0\].pe__2676_/A g_row\[1\].g_col\[0\].pe__2647_/B
+ VGND VGND VPWR VPWR g_row\[1\].g_col\[0\].pe__2647_/X sky130_fd_sc_hd__or2_2
XFILLER_39_110 VGND VGND VPWR VPWR sky130_fd_sc_hd__fill_2
Xg_row\[1\].g_col\[1\].pe__2594_ g_row\[1\].g_col\[1\].pe__2403_/A g_row\[1\].g_col\[1\].pe__2157_/A
+ g_row\[1\].g_col\[1\].pe__2516_/X g_row\[1\].g_col\[1\].pe__2406_/Y g_row\[1\].g_col\[1\].pe__1348_/A
+ VGND VGND VPWR VPWR g_row\[1\].g_col\[1\].pe__2594_/X sky130_fd_sc_hd__a32o_2
Xg_row\[1\].g_col\[1\].pe__1614_ g_row\[1\].g_col\[1\].pe__1676_/A g_row\[1\].g_col\[1\].pe__1614_/B
+ VGND VGND VPWR VPWR g_row\[1\].g_col\[1\].pe__1615_/B sky130_fd_sc_hd__xnor2_2
Xg_row\[1\].g_col\[1\].pe__1545_ g_row\[1\].g_col\[1\].pe__1545_/A g_row\[1\].g_col\[1\].pe__1552_/B
+ VGND VGND VPWR VPWR g_row\[1\].g_col\[1\].pe__1546_/B sky130_fd_sc_hd__xnor2_2
Xg_row\[1\].g_col\[0\].pe_hold2063 g_row\[1\].g_col\[0\].pe__2714_/Q VGND VGND VPWR
+ VPWR g_row\[1\].g_col\[0\].pe__2657_/B sky130_fd_sc_hd__clkbuf_2
Xg_row\[1\].g_col\[0\].pe_hold2052 g_row\[1\].g_col\[0\].pe__2680_/Y VGND VGND VPWR
+ VPWR g_row\[1\].g_col\[0\].pe__2681_/B1 sky130_fd_sc_hd__clkbuf_2
XTAP_TAPCELL_ROW_87_1515 VGND VPWR sky130_fd_sc_hd__tapvpwrvgnd_1
Xg_row\[0\].g_col\[0\].pe__2725_ clkbuf_leaf_39_clk/X g_row\[0\].g_col\[0\].pe__2725_/D
+ VGND VGND VPWR VPWR g_row\[0\].g_col\[0\].pe__2725_/Q sky130_fd_sc_hd__dfxtp_2
Xg_row\[1\].g_col\[0\].pe_hold2074 g_row\[1\].g_col\[0\].pe__2663_/X VGND VGND VPWR
+ VPWR g_row\[1\].g_col\[0\].pe__2664_/C1 sky130_fd_sc_hd__clkbuf_2
Xg_row\[1\].g_col\[0\].pe__1529_ g_row\[1\].g_col\[0\].pe__1554_/A g_row\[1\].g_col\[0\].pe__1554_/B
+ VGND VGND VPWR VPWR g_row\[1\].g_col\[0\].pe__1555_/A sky130_fd_sc_hd__xor2_2
Xg_row\[0\].g_col\[1\].pe_hold2406 g_row\[0\].g_col\[1\].pe__2063_/Y VGND VGND VPWR
+ VPWR g_row\[0\].g_col\[1\].pe__2064_/B sky130_fd_sc_hd__clkbuf_2
Xg_row\[0\].g_col\[1\].pe__2741_ clkbuf_leaf_7_clk/X g_row\[0\].g_col\[1\].pe__2741_/D
+ VGND VGND VPWR VPWR g_row\[0\].g_col\[1\].pe__2741_/Q sky130_fd_sc_hd__dfxtp_2
Xg_row\[1\].g_col\[1\].pe__1476_ g_row\[1\].g_col\[1\].pe__1853_/B2 g_row\[1\].g_col\[1\].pe__1657_/B
+ g_row\[1\].g_col\[1\].pe__1613_/B1 g_row\[1\].g_col\[1\].pe__1657_/A VGND VGND VPWR
+ VPWR g_row\[1\].g_col\[1\].pe__1477_/B sky130_fd_sc_hd__a22o_2
Xg_row\[0\].g_col\[0\].pe__2656_ g_row\[0\].g_col\[0\].pe__2656_/A1 g_row\[0\].g_col\[0\].pe__2656_/A2
+ g_row\[0\].g_col\[0\].pe__2687_/C1 g_row\[0\].g_col\[0\].pe__2655_/X VGND VGND VPWR
+ VPWR g_row\[0\].g_col\[0\].pe__2656_/X sky130_fd_sc_hd__o211a_2
Xg_row\[0\].g_col\[1\].pe__2672_ _338_/Q g_row\[0\].g_col\[1\].pe__2672_/B g_row\[0\].g_col\[1\].pe__2672_/C
+ g_row\[0\].g_col\[1\].pe__2672_/D VGND VGND VPWR VPWR g_row\[0\].g_col\[1\].pe__2672_/X
+ sky130_fd_sc_hd__or4_2
Xg_row\[0\].g_col\[0\].pe__1607_ g_row\[0\].g_col\[0\].pe__1607_/A g_row\[0\].g_col\[0\].pe__1849_/B
+ VGND VGND VPWR VPWR g_row\[0\].g_col\[0\].pe__1633_/A sky130_fd_sc_hd__xor2_2
Xg_row\[0\].g_col\[0\].pe__2587_ g_row\[0\].g_col\[0\].pe__2587_/A1 g_row\[0\].g_col\[0\].pe__2591_/A2
+ g_row\[0\].g_col\[0\].pe__2591_/B1 g_row\[0\].g_col\[0\].pe__2586_/X VGND VGND VPWR
+ VPWR g_row\[0\].g_col\[0\].pe__2587_/X sky130_fd_sc_hd__a22o_2
Xg_row\[0\].g_col\[1\].pe__1623_ g_row\[0\].g_col\[1\].pe__2030_/A g_row\[0\].g_col\[1\].pe__1982_/B
+ g_row\[0\].g_col\[1\].pe__1424_/Y g_row\[0\].g_col\[1\].pe__1970_/A VGND VGND VPWR
+ VPWR g_row\[0\].g_col\[1\].pe__1624_/B sky130_fd_sc_hd__a22o_2
Xg_row\[0\].g_col\[0\].pe__1538_ g_row\[0\].g_col\[0\].pe__2736_/Q VGND VGND VPWR
+ VPWR g_row\[0\].g_col\[0\].pe__1602_/A sky130_fd_sc_hd__inv_2
Xg_row\[0\].g_col\[1\].pe__1554_ g_row\[0\].g_col\[1\].pe__1554_/A g_row\[0\].g_col\[1\].pe__1554_/B
+ VGND VGND VPWR VPWR g_row\[0\].g_col\[1\].pe__1562_/A sky130_fd_sc_hd__and2_2
Xg_row\[0\].g_col\[0\].pe__1469_ g_row\[0\].g_col\[0\].pe__2733_/Q ANTENNA_182/DIODE
+ VGND VGND VPWR VPWR g_row\[0\].g_col\[0\].pe__1471_/A sky130_fd_sc_hd__nand2_2
Xg_row\[0\].g_col\[1\].pe__1485_ g_row\[0\].g_col\[1\].pe__1911_/A1 g_row\[0\].g_col\[1\].pe__1729_/A2
+ g_row\[0\].g_col\[1\].pe__1729_/A3 g_row\[0\].g_col\[1\].pe__1729_/B1 g_row\[0\].g_col\[1\].pe__1970_/A
+ VGND VGND VPWR VPWR g_row\[0\].g_col\[1\].pe__1486_/B sky130_fd_sc_hd__a32o_2
Xg_row\[1\].g_col\[1\].pe__2028_ g_row\[1\].g_col\[1\].pe__2126_/B2 g_row\[1\].g_col\[1\].pe__2028_/B
+ g_row\[1\].g_col\[1\].pe__2028_/C VGND VGND VPWR VPWR g_row\[1\].g_col\[1\].pe__2034_/A
+ sky130_fd_sc_hd__nand3b_2
Xg_row\[0\].g_col\[1\].pe__2106_ g_row\[0\].g_col\[1\].pe__2106_/A g_row\[0\].g_col\[1\].pe__2105_/X
+ VGND VGND VPWR VPWR g_row\[0\].g_col\[1\].pe__2107_/B sky130_fd_sc_hd__nor2b_4
Xg_row\[0\].g_col\[1\].pe__2037_ g_row\[0\].g_col\[1\].pe__2209_/A g_row\[0\].g_col\[1\].pe__2037_/B
+ VGND VGND VPWR VPWR g_row\[0\].g_col\[1\].pe__2038_/C sky130_fd_sc_hd__xnor2_2
XFILLER_49_34 VGND VGND VPWR VPWR sky130_fd_sc_hd__fill_2
XFILLER_19_817 VGND VGND VPWR VPWR sky130_fd_sc_hd__fill_2
XFILLER_19_839 VGND VGND VPWR VPWR sky130_fd_sc_hd__fill_1
XFILLER_86_794 VGND VGND VPWR VPWR sky130_fd_sc_hd__fill_2
XTAP_TAPCELL_ROW_5_286 VGND VPWR sky130_fd_sc_hd__tapvpwrvgnd_1
XFILLER_18_338 VGND VGND VPWR VPWR sky130_fd_sc_hd__fill_2
XFILLER_34_809 VGND VGND VPWR VPWR sky130_fd_sc_hd__decap_3
XFILLER_45_113 VGND VGND VPWR VPWR sky130_fd_sc_hd__decap_3
XFILLER_46_636 VGND VGND VPWR VPWR sky130_fd_sc_hd__fill_1
XFILLER_46_658 VGND VGND VPWR VPWR sky130_fd_sc_hd__decap_3
XFILLER_58_496 VGND VGND VPWR VPWR sky130_fd_sc_hd__fill_2
Xg_row\[0\].g_col\[1\].pe_hold2940 g_row\[0\].g_col\[1\].pe__2722_/Q VGND VGND VPWR
+ VPWR g_row\[0\].g_col\[1\].pe_hold2940/X sky130_fd_sc_hd__clkbuf_2
XANTENNA_101 b_inputs_flat[25] VGND VGND VPWR VPWR sky130_fd_sc_hd__diode_2
XANTENNA_112 hold3285/A VGND VGND VPWR VPWR sky130_fd_sc_hd__diode_2
XANTENNA_123 hold3419/X VGND VGND VPWR VPWR sky130_fd_sc_hd__diode_2
XANTENNA_134 a_inputs_flat[9] VGND VGND VPWR VPWR sky130_fd_sc_hd__diode_2
XFILLER_61_617 VGND VGND VPWR VPWR sky130_fd_sc_hd__decap_3
XANTENNA_145 ANTENNA_145/DIODE VGND VGND VPWR VPWR sky130_fd_sc_hd__diode_2
XANTENNA_156 hold2472/X VGND VGND VPWR VPWR sky130_fd_sc_hd__diode_2
XANTENNA_167 hold3538/A VGND VGND VPWR VPWR sky130_fd_sc_hd__diode_2
Xg_row\[0\].g_col\[0\].pe_hold2106 g_row\[0\].g_col\[0\].pe__2768_/Q VGND VGND VPWR
+ VPWR g_row\[0\].g_col\[0\].pe__2581_/A1 sky130_fd_sc_hd__clkbuf_2
Xg_row\[0\].g_col\[1\].pe_hold2995 g_row\[0\].g_col\[1\].pe__2670_/X VGND VGND VPWR
+ VPWR g_row\[0\].g_col\[1\].pe_hold2995/X sky130_fd_sc_hd__clkbuf_2
XANTENNA_178 _338_/Q VGND VGND VPWR VPWR sky130_fd_sc_hd__diode_2
XTAP_TAPCELL_ROW_24_572 VGND VPWR sky130_fd_sc_hd__tapvpwrvgnd_1
X_285_ _288_/CLK _285_/D VGND VGND VPWR VPWR _285_/Q sky130_fd_sc_hd__dfxtp_2
XFILLER_10_783 VGND VGND VPWR VPWR sky130_fd_sc_hd__decap_3
Xg_row\[1\].g_col\[0\].pe__1880_ g_row\[1\].g_col\[0\].pe__1629_/A g_row\[1\].g_col\[0\].pe__1629_/B
+ g_row\[1\].g_col\[0\].pe__1879_/Y VGND VGND VPWR VPWR g_row\[1\].g_col\[0\].pe__1936_/B
+ sky130_fd_sc_hd__a21oi_2
XFILLER_6_776 VGND VGND VPWR VPWR sky130_fd_sc_hd__decap_3
XFILLER_6_798 VGND VGND VPWR VPWR sky130_fd_sc_hd__decap_3
XFILLER_69_717 VGND VGND VPWR VPWR sky130_fd_sc_hd__fill_1
Xg_row\[1\].g_col\[1\].pe_hold2182 g_row\[1\].g_col\[1\].pe_hold3028/X VGND VGND VPWR
+ VPWR g_row\[1\].g_col\[1\].pe__2708_/D sky130_fd_sc_hd__clkbuf_2
Xg_row\[1\].g_col\[1\].pe_hold2171 hold2162/X VGND VGND VPWR VPWR g_row\[1\].g_col\[1\].pe__2683_/A1
+ sky130_fd_sc_hd__clkbuf_2
Xg_row\[1\].g_col\[0\].pe__2501_ g_row\[1\].g_col\[0\].pe__2538_/A g_row\[1\].g_col\[0\].pe__2526_/A
+ g_row\[1\].g_col\[0\].pe__2501_/C g_row\[1\].g_col\[0\].pe__2533_/B VGND VGND VPWR
+ VPWR g_row\[1\].g_col\[0\].pe__2502_/D sky130_fd_sc_hd__and4_2
Xg_row\[1\].g_col\[1\].pe_hold2193 g_row\[1\].g_col\[1\].pe__2711_/Q VGND VGND VPWR
+ VPWR g_row\[1\].g_col\[1\].pe__2651_/B sky130_fd_sc_hd__clkbuf_2
Xg_row\[1\].g_col\[0\].pe__2432_ g_row\[1\].g_col\[0\].pe__2432_/A g_row\[1\].g_col\[0\].pe__2432_/B
+ VGND VGND VPWR VPWR g_row\[1\].g_col\[0\].pe__2474_/B sky130_fd_sc_hd__xnor2_2
XFILLER_77_783 VGND VGND VPWR VPWR sky130_fd_sc_hd__fill_1
Xg_row\[1\].g_col\[0\].pe__2363_ g_row\[1\].g_col\[0\].pe__2388_/A g_row\[1\].g_col\[0\].pe__2363_/A2
+ g_row\[1\].g_col\[0\].pe__2388_/B g_row\[1\].g_col\[0\].pe__2121_/A VGND VGND VPWR
+ VPWR g_row\[1\].g_col\[0\].pe__2364_/B sky130_fd_sc_hd__a22o_2
XFILLER_49_496 VGND VGND VPWR VPWR sky130_fd_sc_hd__decap_3
XTAP_TAPCELL_ROW_69_1245 VGND VPWR sky130_fd_sc_hd__tapvpwrvgnd_1
Xg_row\[1\].g_col\[0\].pe__2294_ g_row\[1\].g_col\[0\].pe__2294_/A VGND VGND VPWR
+ VPWR g_row\[1\].g_col\[0\].pe__2329_/A sky130_fd_sc_hd__inv_2
XFILLER_52_606 VGND VGND VPWR VPWR sky130_fd_sc_hd__fill_1
Xg_row\[0\].g_col\[0\].pe__2510_ g_row\[0\].g_col\[0\].pe__2516_/B g_row\[0\].g_col\[0\].pe__2507_/Y
+ g_row\[0\].g_col\[0\].pe__2508_/Y g_row\[0\].g_col\[0\].pe__2509_/X VGND VGND VPWR
+ VPWR g_row\[0\].g_col\[0\].pe__2510_/X sky130_fd_sc_hd__a31o_2
XFILLER_64_499 VGND VGND VPWR VPWR sky130_fd_sc_hd__fill_1
Xg_row\[0\].g_col\[0\].pe__2441_ ANTENNA_145/DIODE g_row\[0\].g_col\[0\].pe__2441_/B
+ VGND VGND VPWR VPWR g_row\[0\].g_col\[0\].pe__2443_/B sky130_fd_sc_hd__xnor2_2
XTAP_TAPCELL_ROW_82_1434 VGND VPWR sky130_fd_sc_hd__tapvpwrvgnd_1
XTAP_TAPCELL_ROW_82_1445 VGND VPWR sky130_fd_sc_hd__tapvpwrvgnd_1
Xg_row\[0\].g_col\[0\].pe__2372_ g_row\[0\].g_col\[0\].pe__2372_/A g_row\[0\].g_col\[0\].pe__2386_/A
+ VGND VGND VPWR VPWR g_row\[0\].g_col\[0\].pe__2385_/A sky130_fd_sc_hd__xnor2_2
Xg_row\[0\].g_col\[0\].pe_hold1994 g_row\[0\].g_col\[0\].pe__2757_/Q VGND VGND VPWR
+ VPWR g_row\[0\].g_col\[0\].pe__2521_/A1 sky130_fd_sc_hd__clkbuf_2
XFILLER_9_592 VGND VGND VPWR VPWR sky130_fd_sc_hd__decap_3
Xg_row\[1\].g_col\[1\].pe__2715_ clkbuf_leaf_80_clk/X g_row\[1\].g_col\[1\].pe__2715_/D
+ VGND VGND VPWR VPWR g_row\[1\].g_col\[1\].pe__2715_/Q sky130_fd_sc_hd__dfxtp_2
Xg_row\[1\].g_col\[1\].pe__2646_ g_row\[1\].g_col\[1\].pe__2656_/A1 g_row\[1\].g_col\[1\].pe__2685_/A1
+ g_row\[1\].g_col\[1\].pe__2687_/C1 g_row\[1\].g_col\[1\].pe__2646_/C1 VGND VGND
+ VPWR VPWR g_row\[1\].g_col\[1\].pe__2646_/X sky130_fd_sc_hd__o211a_2
Xg_row\[1\].g_col\[1\].pe__2577_ g_row\[1\].g_col\[1\].pe__2592_/A g_row\[1\].g_col\[1\].pe__2577_/B
+ VGND VGND VPWR VPWR g_row\[1\].g_col\[1\].pe__2767_/D sky130_fd_sc_hd__and2_2
XTAP_TAPCELL_ROW_2_234 VGND VPWR sky130_fd_sc_hd__tapvpwrvgnd_1
XTAP_TAPCELL_ROW_2_245 VGND VPWR sky130_fd_sc_hd__tapvpwrvgnd_1
Xg_row\[1\].g_col\[1\].pe__1528_ g_row\[1\].g_col\[1\].pe__1673_/A g_row\[1\].g_col\[1\].pe__1528_/B
+ VGND VGND VPWR VPWR g_row\[1\].g_col\[1\].pe__1554_/B sky130_fd_sc_hd__xnor2_2
Xg_row\[0\].g_col\[1\].pe_hold2214 g_row\[0\].g_col\[1\].pe__2610_/X VGND VGND VPWR
+ VPWR g_row\[0\].g_col\[1\].pe__2611_/C1 sky130_fd_sc_hd__clkbuf_2
Xg_row\[0\].g_col\[1\].pe_hold2203 g_row\[0\].g_col\[1\].pe__2618_/X VGND VGND VPWR
+ VPWR g_row\[0\].g_col\[1\].pe__2619_/C1 sky130_fd_sc_hd__clkbuf_2
XFILLER_43_617 VGND VGND VPWR VPWR sky130_fd_sc_hd__fill_2
Xg_row\[0\].g_col\[0\].pe__2708_ clkbuf_leaf_41_clk/X g_row\[0\].g_col\[0\].pe__2708_/D
+ VGND VGND VPWR VPWR hold2047/A sky130_fd_sc_hd__dfxtp_2
Xg_row\[1\].g_col\[1\].pe__1459_ g_row\[1\].g_col\[1\].pe__2250_/A g_row\[1\].g_col\[1\].pe__2731_/Q
+ g_row\[1\].g_col\[1\].pe__1816_/A VGND VGND VPWR VPWR g_row\[1\].g_col\[1\].pe__1461_/A
+ sky130_fd_sc_hd__nand3b_2
Xg_row\[0\].g_col\[1\].pe__2724_ _332_/CLK g_row\[0\].g_col\[1\].pe__2724_/D VGND
+ VGND VPWR VPWR g_row\[0\].g_col\[1\].pe__2724_/Q sky130_fd_sc_hd__dfxtp_2
Xg_row\[0\].g_col\[0\].pe__2639_ g_row\[0\].g_col\[0\].pe__2639_/A hold1929/X VGND
+ VGND VPWR VPWR g_row\[0\].g_col\[0\].pe__2639_/X sky130_fd_sc_hd__or2_2
Xg_row\[0\].g_col\[1\].pe__2655_ place1239/X hold1778/X VGND VGND VPWR VPWR g_row\[0\].g_col\[1\].pe__2655_/X
+ sky130_fd_sc_hd__or2_2
XFILLER_35_190 VGND VGND VPWR VPWR sky130_fd_sc_hd__fill_1
Xg_row\[0\].g_col\[1\].pe__1606_ g_row\[0\].g_col\[1\].pe__1606_/A g_row\[0\].g_col\[1\].pe__1848_/B
+ VGND VGND VPWR VPWR g_row\[0\].g_col\[1\].pe__1849_/B sky130_fd_sc_hd__xnor2_2
XFILLER_23_363 VGND VGND VPWR VPWR sky130_fd_sc_hd__fill_1
XTAP_TAPCELL_ROW_41_818 VGND VPWR sky130_fd_sc_hd__tapvpwrvgnd_1
XTAP_TAPCELL_ROW_41_829 VGND VPWR sky130_fd_sc_hd__tapvpwrvgnd_1
Xg_row\[0\].g_col\[1\].pe__2586_ g_row\[0\].g_col\[1\].pe__2586_/A g_row\[0\].g_col\[1\].pe__2586_/B
+ g_row\[0\].g_col\[1\].pe__2586_/C VGND VGND VPWR VPWR g_row\[0\].g_col\[1\].pe__2586_/X
+ sky130_fd_sc_hd__or3_2
XFILLER_50_193 VGND VGND VPWR VPWR sky130_fd_sc_hd__decap_3
XTAP_TAPCELL_ROW_21_520 VGND VPWR sky130_fd_sc_hd__tapvpwrvgnd_1
Xg_row\[0\].g_col\[1\].pe__1537_ g_row\[0\].g_col\[1\].pe__1499_/A g_row\[0\].g_col\[1\].pe__1499_/B
+ g_row\[0\].g_col\[1\].pe__1536_/X VGND VGND VPWR VPWR g_row\[0\].g_col\[1\].pe__1545_/A
+ sky130_fd_sc_hd__a21oi_2
XFILLER_51_57 VGND VGND VPWR VPWR sky130_fd_sc_hd__fill_1
XTAP_TAPCELL_ROW_21_531 VGND VPWR sky130_fd_sc_hd__tapvpwrvgnd_1
Xg_row\[0\].g_col\[1\].pe__1399_ g_row\[0\].g_col\[1\].pe__1399_/A1 g_row\[0\].g_col\[1\].pe__2678_/A
+ g_row\[0\].g_col\[1\].pe__1398_/X g_row\[0\].g_col\[1\].pe__2679_/C1 VGND VGND VPWR
+ VPWR g_row\[0\].g_col\[1\].pe__1399_/X sky130_fd_sc_hd__o211a_2
Xg_row\[0\].g_col\[0\].pe_place976 g_row\[0\].g_col\[0\].pe__2364_/A VGND VGND VPWR
+ VPWR g_row\[0\].g_col\[0\].pe__2217_/A sky130_fd_sc_hd__buf_6
Xg_row\[0\].g_col\[0\].pe_place987 g_row\[0\].g_col\[0\].pe__1784_/B1 VGND VGND VPWR
+ VPWR g_row\[0\].g_col\[0\].pe__1801_/B sky130_fd_sc_hd__buf_6
Xg_row\[0\].g_col\[0\].pe_place998 g_row\[0\].g_col\[0\].pe__1385_/B VGND VGND VPWR
+ VPWR g_row\[0\].g_col\[0\].pe__1402_/B sky130_fd_sc_hd__buf_6
XFILLER_3_757 VGND VGND VPWR VPWR sky130_fd_sc_hd__decap_3
XFILLER_4_3 VGND VGND VPWR VPWR sky130_fd_sc_hd__decap_3
XTAP_TAPCELL_ROW_53_1002 VGND VPWR sky130_fd_sc_hd__tapvpwrvgnd_1
XFILLER_2_278 VGND VGND VPWR VPWR sky130_fd_sc_hd__decap_3
XFILLER_65_208 VGND VGND VPWR VPWR sky130_fd_sc_hd__decap_3
XFILLER_18_102 VGND VGND VPWR VPWR sky130_fd_sc_hd__decap_3
XFILLER_18_113 VGND VGND VPWR VPWR sky130_fd_sc_hd__fill_2
XFILLER_59_794 VGND VGND VPWR VPWR sky130_fd_sc_hd__fill_1
XFILLER_86_580 VGND VGND VPWR VPWR sky130_fd_sc_hd__fill_1
XFILLER_46_477 VGND VGND VPWR VPWR sky130_fd_sc_hd__decap_3
XTAP_TAPCELL_ROW_29_642 VGND VPWR sky130_fd_sc_hd__tapvpwrvgnd_1
XFILLER_92_42 VGND VGND VPWR VPWR sky130_fd_sc_hd__fill_2
XFILLER_27_691 VGND VGND VPWR VPWR sky130_fd_sc_hd__decap_3
XFILLER_61_447 VGND VGND VPWR VPWR sky130_fd_sc_hd__fill_1
XTAP_TAPCELL_ROW_64_1164 VGND VPWR sky130_fd_sc_hd__tapvpwrvgnd_1
XTAP_TAPCELL_ROW_64_1175 VGND VPWR sky130_fd_sc_hd__tapvpwrvgnd_1
X_337_ _337_/CLK _337_/D VGND VGND VPWR VPWR _337_/Q sky130_fd_sc_hd__dfxtp_2
Xg_row\[1\].g_col\[0\].pe__1932_ g_row\[1\].g_col\[0\].pe__1877_/B g_row\[1\].g_col\[0\].pe__1932_/B
+ VGND VGND VPWR VPWR g_row\[1\].g_col\[0\].pe__1932_/X sky130_fd_sc_hd__and2b_2
X_199_ _199_/A _199_/B_N VGND VGND VPWR VPWR _199_/Y sky130_fd_sc_hd__nor2b_4
Xg_row\[1\].g_col\[0\].pe__1863_ place1090/A g_row\[1\].g_col\[0\].pe__2163_/B g_row\[1\].g_col\[0\].pe__1863_/B1
+ place1092/A VGND VGND VPWR VPWR g_row\[1\].g_col\[0\].pe__1864_/B sky130_fd_sc_hd__a22o_2
XFILLER_6_573 VGND VGND VPWR VPWR sky130_fd_sc_hd__fill_2
XFILLER_6_584 VGND VGND VPWR VPWR sky130_fd_sc_hd__decap_3
XFILLER_6_595 VGND VGND VPWR VPWR sky130_fd_sc_hd__fill_1
Xg_row\[1\].g_col\[0\].pe__1794_ g_row\[1\].g_col\[0\].pe__1794_/A g_row\[1\].g_col\[0\].pe__1794_/B
+ VGND VGND VPWR VPWR g_row\[1\].g_col\[0\].pe__1795_/C sky130_fd_sc_hd__or2_4
Xg_row\[0\].g_col\[0\].pe__1941_ g_row\[0\].g_col\[0\].pe__1941_/A g_row\[0\].g_col\[0\].pe__1941_/B
+ g_row\[0\].g_col\[0\].pe__1941_/C VGND VGND VPWR VPWR g_row\[0\].g_col\[0\].pe__1942_/B
+ sky130_fd_sc_hd__and3_2
Xhold2409 hold3132/X VGND VGND VPWR VPWR hold3133/A sky130_fd_sc_hd__clkbuf_2
Xg_row\[1\].g_col\[1\].pe__2500_ g_row\[1\].g_col\[1\].pe__2464_/X g_row\[1\].g_col\[1\].pe__2538_/B
+ VGND VGND VPWR VPWR g_row\[1\].g_col\[1\].pe__2533_/B sky130_fd_sc_hd__and2b_2
XFILLER_69_569 VGND VGND VPWR VPWR sky130_fd_sc_hd__decap_3
Xg_row\[0\].g_col\[0\].pe__1872_ place1198/X g_row\[0\].g_col\[0\].pe__1982_/B g_row\[0\].g_col\[0\].pe__1424_/Y
+ place1199/X VGND VGND VPWR VPWR g_row\[0\].g_col\[0\].pe__1873_/B sky130_fd_sc_hd__a22o_2
Xg_row\[1\].g_col\[1\].pe__2431_ g_row\[1\].g_col\[1\].pe__2476_/B g_row\[1\].g_col\[1\].pe__2767_/Q
+ VGND VGND VPWR VPWR g_row\[1\].g_col\[1\].pe__2579_/B sky130_fd_sc_hd__or2b_2
Xg_row\[1\].g_col\[0\].pe__2415_ g_row\[1\].g_col\[0\].pe__2421_/A1 g_row\[1\].g_col\[0\].pe__2746_/Q
+ g_row\[1\].g_col\[0\].pe__2439_/B VGND VGND VPWR VPWR g_row\[1\].g_col\[0\].pe__2436_/B
+ sky130_fd_sc_hd__a21o_2
XFILLER_49_293 VGND VGND VPWR VPWR sky130_fd_sc_hd__decap_3
XFILLER_77_580 VGND VGND VPWR VPWR sky130_fd_sc_hd__fill_1
Xg_row\[1\].g_col\[0\].pe__2346_ g_row\[1\].g_col\[0\].pe__2346_/A g_row\[1\].g_col\[0\].pe__2346_/B
+ VGND VGND VPWR VPWR g_row\[1\].g_col\[0\].pe__2347_/B sky130_fd_sc_hd__nand2_2
XFILLER_92_550 VGND VGND VPWR VPWR sky130_fd_sc_hd__fill_2
XFILLER_25_617 VGND VGND VPWR VPWR sky130_fd_sc_hd__decap_3
XFILLER_37_499 VGND VGND VPWR VPWR sky130_fd_sc_hd__fill_1
XFILLER_52_403 VGND VGND VPWR VPWR sky130_fd_sc_hd__decap_3
Xg_row\[1\].g_col\[1\].pe__2293_ g_row\[1\].g_col\[1\].pe__2295_/A g_row\[1\].g_col\[1\].pe__2295_/B
+ g_row\[1\].g_col\[1\].pe__2292_/X VGND VGND VPWR VPWR g_row\[1\].g_col\[1\].pe__2294_/A
+ sky130_fd_sc_hd__o21ba_2
Xg_row\[1\].g_col\[0\].pe__2277_ g_row\[1\].g_col\[0\].pe__2277_/A g_row\[1\].g_col\[0\].pe__2277_/B
+ VGND VGND VPWR VPWR g_row\[1\].g_col\[0\].pe__2285_/A sky130_fd_sc_hd__and2_2
XFILLER_18_691 VGND VGND VPWR VPWR sky130_fd_sc_hd__decap_3
Xg_row\[0\].g_col\[1\].pe__2440_ g_row\[0\].g_col\[1\].pe__2763_/Q g_row\[0\].g_col\[1\].pe__2439_/Y
+ VGND VGND VPWR VPWR g_row\[0\].g_col\[1\].pe__2495_/A sky130_fd_sc_hd__or2b_2
XFILLER_33_661 VGND VGND VPWR VPWR sky130_fd_sc_hd__fill_1
Xg_row\[0\].g_col\[0\].pe__2424_ g_row\[0\].g_col\[0\].pe__2424_/A g_row\[0\].g_col\[0\].pe__2424_/B
+ VGND VGND VPWR VPWR g_row\[0\].g_col\[0\].pe__2425_/B sky130_fd_sc_hd__and2_2
XANTENNA_12 a_inputs_flat[24] VGND VGND VPWR VPWR sky130_fd_sc_hd__diode_2
XANTENNA_23 b_inputs_flat[26] VGND VGND VPWR VPWR sky130_fd_sc_hd__diode_2
XFILLER_32_171 VGND VGND VPWR VPWR sky130_fd_sc_hd__fill_2
Xg_row\[0\].g_col\[0\].pe__2355_ g_row\[0\].g_col\[0\].pe__2355_/A g_row\[0\].g_col\[0\].pe__2355_/B
+ VGND VGND VPWR VPWR g_row\[0\].g_col\[0\].pe__2356_/B sky130_fd_sc_hd__nor2_2
Xg_row\[0\].g_col\[1\].pe__2371_ g_row\[0\].g_col\[1\].pe__2347_/A g_row\[0\].g_col\[1\].pe__2346_/B
+ g_row\[0\].g_col\[1\].pe__2346_/A VGND VGND VPWR VPWR g_row\[0\].g_col\[1\].pe__2386_/A
+ sky130_fd_sc_hd__a21boi_2
XANTENNA_34 _263_/Y VGND VGND VPWR VPWR sky130_fd_sc_hd__diode_2
XANTENNA_45 a_inputs_flat[3] VGND VGND VPWR VPWR sky130_fd_sc_hd__diode_2
XANTENNA_56 hold1640/A VGND VGND VPWR VPWR sky130_fd_sc_hd__diode_2
XANTENNA_67 _337_/D VGND VGND VPWR VPWR sky130_fd_sc_hd__diode_2
XANTENNA_78 hold3212/X VGND VGND VPWR VPWR sky130_fd_sc_hd__diode_2
XANTENNA_89 hold3286/X VGND VGND VPWR VPWR sky130_fd_sc_hd__diode_2
Xg_row\[0\].g_col\[0\].pe__2286_ g_row\[0\].g_col\[0\].pe__2286_/A g_row\[0\].g_col\[0\].pe__2310_/B
+ VGND VGND VPWR VPWR g_row\[0\].g_col\[0\].pe__2309_/B sky130_fd_sc_hd__xnor2_2
XFILLER_0_716 VGND VGND VPWR VPWR sky130_fd_sc_hd__decap_3
XTAP_TAPCELL_ROW_7_315 VGND VPWR sky130_fd_sc_hd__tapvpwrvgnd_1
XFILLER_83_561 VGND VGND VPWR VPWR sky130_fd_sc_hd__decap_3
Xg_row\[0\].g_col\[1\].pe_hold2033 g_row\[0\].g_col\[1\].pe__2768_/Q VGND VGND VPWR
+ VPWR g_row\[0\].g_col\[1\].pe__2581_/A1 sky130_fd_sc_hd__clkbuf_2
XFILLER_15_116 VGND VGND VPWR VPWR sky130_fd_sc_hd__decap_3
XFILLER_28_477 VGND VGND VPWR VPWR sky130_fd_sc_hd__decap_3
XFILLER_28_499 VGND VGND VPWR VPWR sky130_fd_sc_hd__decap_3
XFILLER_43_403 VGND VGND VPWR VPWR sky130_fd_sc_hd__decap_3
XTAP_TAPCELL_ROW_26_601 VGND VPWR sky130_fd_sc_hd__tapvpwrvgnd_1
Xg_row\[0\].g_col\[1\].pe__2707_ clkbuf_leaf_96_clk/X g_row\[0\].g_col\[1\].pe__2707_/D
+ VGND VGND VPWR VPWR hold2170/A sky130_fd_sc_hd__dfxtp_2
XFILLER_15_138 VGND VGND VPWR VPWR sky130_fd_sc_hd__decap_3
XFILLER_24_661 VGND VGND VPWR VPWR sky130_fd_sc_hd__decap_3
XFILLER_71_789 VGND VGND VPWR VPWR sky130_fd_sc_hd__fill_1
Xg_row\[0\].g_col\[1\].pe__2638_ g_row\[0\].g_col\[1\].pe__2635_/X g_row\[0\].g_col\[1\].pe__2636_/X
+ g_row\[0\].g_col\[1\].pe__2637_/X hold1929/X VGND VGND VPWR VPWR g_row\[0\].g_col\[1\].pe__2638_/X
+ sky130_fd_sc_hd__o31a_2
Xg_row\[0\].g_col\[1\].pe__2569_ g_row\[0\].g_col\[1\].pe__2592_/A g_row\[0\].g_col\[1\].pe__2569_/B
+ VGND VGND VPWR VPWR g_row\[0\].g_col\[1\].pe__2765_/D sky130_fd_sc_hd__and2_2
Xg_row\[0\].g_col\[1\].pe_place1234 place1250/X VGND VGND VPWR VPWR g_row\[0\].g_col\[1\].pe__2406_/B1
+ sky130_fd_sc_hd__buf_6
XFILLER_7_337 VGND VGND VPWR VPWR sky130_fd_sc_hd__fill_2
XFILLER_3_532 VGND VGND VPWR VPWR sky130_fd_sc_hd__fill_1
XFILLER_3_565 VGND VGND VPWR VPWR sky130_fd_sc_hd__fill_1
XFILLER_79_823 VGND VGND VPWR VPWR sky130_fd_sc_hd__fill_2
Xg_row\[1\].g_col\[0\].pe_hold1917 g_row\[1\].g_col\[0\].pe__2158_/X VGND VGND VPWR
+ VPWR g_row\[1\].g_col\[0\].pe__2159_/B sky130_fd_sc_hd__clkbuf_2
Xg_row\[1\].g_col\[0\].pe_hold1906 g_row\[1\].g_col\[0\].pe_hold2836/X VGND VGND VPWR
+ VPWR g_row\[1\].g_col\[0\].pe_hold2837/A sky130_fd_sc_hd__clkbuf_2
XFILLER_59_580 VGND VGND VPWR VPWR sky130_fd_sc_hd__decap_3
Xg_row\[1\].g_col\[0\].pe__2200_ g_row\[1\].g_col\[0\].pe__2200_/A g_row\[1\].g_col\[0\].pe__2200_/B
+ VGND VGND VPWR VPWR g_row\[1\].g_col\[0\].pe__2299_/A sky130_fd_sc_hd__or2_4
XFILLER_62_701 VGND VGND VPWR VPWR sky130_fd_sc_hd__decap_3
XFILLER_93_369 VGND VGND VPWR VPWR sky130_fd_sc_hd__fill_1
XFILLER_46_274 VGND VGND VPWR VPWR sky130_fd_sc_hd__decap_3
XTAP_TAPCELL_ROW_66_1204 VGND VPWR sky130_fd_sc_hd__tapvpwrvgnd_1
Xg_row\[1\].g_col\[0\].pe__2131_ g_row\[1\].g_col\[0\].pe__2348_/A g_row\[1\].g_col\[0\].pe__2131_/B
+ VGND VGND VPWR VPWR g_row\[1\].g_col\[0\].pe__2132_/B sky130_fd_sc_hd__xnor2_2
Xg_row\[1\].g_col\[0\].pe__2062_ g_row\[1\].g_col\[0\].pe__2062_/A g_row\[1\].g_col\[0\].pe__2150_/C
+ g_row\[1\].g_col\[0\].pe__2062_/C VGND VGND VPWR VPWR g_row\[1\].g_col\[0\].pe__2062_/X
+ sky130_fd_sc_hd__or3_2
XFILLER_22_609 VGND VGND VPWR VPWR sky130_fd_sc_hd__fill_1
XFILLER_42_480 VGND VGND VPWR VPWR sky130_fd_sc_hd__decap_3
Xg_row\[0\].g_col\[0\].pe__2140_ g_row\[0\].g_col\[0\].pe__2217_/A g_row\[0\].g_col\[0\].pe__2140_/B
+ VGND VGND VPWR VPWR g_row\[0\].g_col\[0\].pe__2174_/B sky130_fd_sc_hd__xnor2_2
XTAP_TAPCELL_ROW_12_383 VGND VPWR sky130_fd_sc_hd__tapvpwrvgnd_1
XTAP_TAPCELL_ROW_12_394 VGND VPWR sky130_fd_sc_hd__tapvpwrvgnd_1
Xg_row\[0\].g_col\[0\].pe__2071_ g_row\[0\].g_col\[0\].pe__2071_/A g_row\[0\].g_col\[0\].pe__2071_/B
+ VGND VGND VPWR VPWR g_row\[0\].g_col\[0\].pe__2078_/A sky130_fd_sc_hd__and2_2
Xg_row\[1\].g_col\[1\].pe__1931_ g_row\[1\].g_col\[1\].pe__1931_/A g_row\[1\].g_col\[1\].pe__1931_/B
+ VGND VGND VPWR VPWR g_row\[1\].g_col\[1\].pe__1999_/A sky130_fd_sc_hd__xnor2_2
Xg_row\[1\].g_col\[0\].pe__1915_ g_row\[1\].g_col\[0\].pe__2209_/A g_row\[1\].g_col\[0\].pe__1915_/B
+ VGND VGND VPWR VPWR g_row\[1\].g_col\[0\].pe__1916_/B sky130_fd_sc_hd__xnor2_2
Xg_row\[1\].g_col\[1\].pe__1862_ g_row\[1\].g_col\[1\].pe__2167_/A g_row\[1\].g_col\[1\].pe__1862_/B
+ VGND VGND VPWR VPWR g_row\[1\].g_col\[1\].pe__1899_/A sky130_fd_sc_hd__xor2_2
XTAP_TAPCELL_ROW_77_1366 VGND VPWR sky130_fd_sc_hd__tapvpwrvgnd_1
Xg_row\[1\].g_col\[0\].pe__1846_ g_row\[1\].g_col\[0\].pe__1846_/A VGND VGND VPWR
+ VPWR g_row\[1\].g_col\[0\].pe__1847_/A sky130_fd_sc_hd__inv_2
Xg_row\[1\].g_col\[1\].pe__1793_ g_row\[1\].g_col\[1\].pe__1793_/A g_row\[1\].g_col\[1\].pe__1793_/B
+ g_row\[1\].g_col\[1\].pe__1793_/C VGND VGND VPWR VPWR g_row\[1\].g_col\[1\].pe__1794_/B
+ sky130_fd_sc_hd__and3_2
Xg_row\[1\].g_col\[0\].pe__1777_ g_row\[1\].g_col\[0\].pe__1777_/A g_row\[1\].g_col\[0\].pe__1777_/B
+ VGND VGND VPWR VPWR g_row\[1\].g_col\[0\].pe__1816_/C sky130_fd_sc_hd__xor2_2
XTAP_TAPCELL_ROW_90_1555 VGND VPWR sky130_fd_sc_hd__tapvpwrvgnd_1
XTAP_TAPCELL_ROW_90_1566 VGND VPWR sky130_fd_sc_hd__tapvpwrvgnd_1
Xg_row\[0\].g_col\[0\].pe__1924_ g_row\[0\].g_col\[0\].pe__2094_/A g_row\[0\].g_col\[0\].pe__1924_/B
+ g_row\[0\].g_col\[0\].pe__1924_/C VGND VGND VPWR VPWR g_row\[0\].g_col\[0\].pe__1980_/B
+ sky130_fd_sc_hd__nor3_2
Xhold1505 hold3366/X VGND VGND VPWR VPWR hold3367/A sky130_fd_sc_hd__clkbuf_2
Xhold1516 hold3320/X VGND VGND VPWR VPWR hold3321/A sky130_fd_sc_hd__clkbuf_2
Xg_row\[0\].g_col\[1\].pe__1940_ g_row\[0\].g_col\[1\].pe__1941_/A g_row\[0\].g_col\[1\].pe__1941_/B
+ g_row\[0\].g_col\[1\].pe__1941_/C VGND VGND VPWR VPWR g_row\[0\].g_col\[1\].pe__2005_/A
+ sky130_fd_sc_hd__a21oi_2
XFILLER_57_528 VGND VGND VPWR VPWR sky130_fd_sc_hd__decap_3
Xg_row\[0\].g_col\[0\].pe__1855_ g_row\[0\].g_col\[0\].pe__2364_/A g_row\[0\].g_col\[0\].pe__1855_/B
+ VGND VGND VPWR VPWR g_row\[0\].g_col\[0\].pe__1857_/B sky130_fd_sc_hd__xnor2_2
Xhold1527 hold2592/X VGND VGND VPWR VPWR hold2593/A sky130_fd_sc_hd__clkbuf_2
Xhold1538 hold3310/X VGND VGND VPWR VPWR hold3311/A sky130_fd_sc_hd__clkbuf_2
Xhold1549 hold3481/X VGND VGND VPWR VPWR hold3482/A sky130_fd_sc_hd__clkbuf_2
Xg_row\[1\].g_col\[1\].pe__2414_ g_row\[1\].g_col\[1\].pe__2754_/Q g_row\[1\].g_col\[1\].pe__2116_/Y
+ g_row\[1\].g_col\[1\].pe__2441_/B VGND VGND VPWR VPWR g_row\[1\].g_col\[1\].pe__2439_/B
+ sky130_fd_sc_hd__o21ai_2
Xg_row\[0\].g_col\[1\].pe__1871_ g_row\[0\].g_col\[1\].pe__2045_/B g_row\[0\].g_col\[1\].pe__1928_/B
+ VGND VGND VPWR VPWR g_row\[0\].g_col\[1\].pe__1874_/A sky130_fd_sc_hd__xor2_2
XFILLER_84_369 VGND VGND VPWR VPWR sky130_fd_sc_hd__fill_1
XFILLER_37_263 VGND VGND VPWR VPWR sky130_fd_sc_hd__decap_3
XFILLER_65_561 VGND VGND VPWR VPWR sky130_fd_sc_hd__decap_3
Xg_row\[0\].g_col\[0\].pe__1786_ g_row\[0\].g_col\[0\].pe__1796_/A g_row\[0\].g_col\[0\].pe__1796_/B
+ VGND VGND VPWR VPWR g_row\[0\].g_col\[0\].pe__1797_/A sky130_fd_sc_hd__nand2_2
Xg_row\[1\].g_col\[1\].pe__2345_ g_row\[1\].g_col\[1\].pe__2368_/A g_row\[1\].g_col\[1\].pe__2345_/B
+ VGND VGND VPWR VPWR g_row\[1\].g_col\[1\].pe__2346_/B sky130_fd_sc_hd__or2_2
Xg_row\[1\].g_col\[0\].pe__2329_ g_row\[1\].g_col\[0\].pe__2329_/A g_row\[1\].g_col\[0\].pe__2329_/B
+ VGND VGND VPWR VPWR g_row\[1\].g_col\[0\].pe__2329_/Y sky130_fd_sc_hd__xnor2_2
XFILLER_25_436 VGND VGND VPWR VPWR sky130_fd_sc_hd__fill_2
XFILLER_25_447 VGND VGND VPWR VPWR sky130_fd_sc_hd__fill_1
XFILLER_52_222 VGND VGND VPWR VPWR sky130_fd_sc_hd__fill_1
XFILLER_52_233 VGND VGND VPWR VPWR sky130_fd_sc_hd__decap_3
XFILLER_53_756 VGND VGND VPWR VPWR sky130_fd_sc_hd__fill_1
XFILLER_80_520 VGND VGND VPWR VPWR sky130_fd_sc_hd__decap_3
Xg_row\[1\].g_col\[1\].pe__2276_ g_row\[1\].g_col\[1\].pe__2318_/A g_row\[1\].g_col\[1\].pe__2276_/B
+ VGND VGND VPWR VPWR g_row\[1\].g_col\[1\].pe__2286_/A sky130_fd_sc_hd__and2b_2
XFILLER_52_266 VGND VGND VPWR VPWR sky130_fd_sc_hd__fill_1
XFILLER_80_575 VGND VGND VPWR VPWR sky130_fd_sc_hd__fill_2
Xg_row\[1\].g_col\[0\].pe_place1076 g_row\[1\].g_col\[0\].pe__2723_/Q VGND VGND VPWR
+ VPWR g_row\[1\].g_col\[0\].pe__1749_/A1 sky130_fd_sc_hd__buf_6
Xg_row\[1\].g_col\[0\].pe_place1065 g_row\[1\].g_col\[0\].pe__1460_/B VGND VGND VPWR
+ VPWR g_row\[1\].g_col\[0\].pe__1910_/A sky130_fd_sc_hd__buf_6
Xg_row\[0\].g_col\[1\].pe__2423_ g_row\[0\].g_col\[1\].pe__2424_/A g_row\[0\].g_col\[1\].pe__2424_/B
+ VGND VGND VPWR VPWR g_row\[0\].g_col\[1\].pe__2425_/A sky130_fd_sc_hd__nor2_2
XTAP_TAPCELL_ROW_51_968 VGND VPWR sky130_fd_sc_hd__tapvpwrvgnd_1
XTAP_TAPCELL_ROW_51_979 VGND VPWR sky130_fd_sc_hd__tapvpwrvgnd_1
Xg_row\[0\].g_col\[1\].pe__2354_ g_row\[0\].g_col\[1\].pe__2355_/A g_row\[0\].g_col\[1\].pe__2355_/B
+ VGND VGND VPWR VPWR g_row\[0\].g_col\[1\].pe__2356_/A sky130_fd_sc_hd__and2_2
XFILLER_21_686 VGND VGND VPWR VPWR sky130_fd_sc_hd__decap_3
XTAP_TAPCELL_ROW_31_670 VGND VPWR sky130_fd_sc_hd__tapvpwrvgnd_1
Xg_row\[0\].g_col\[0\].pe__2338_ g_row\[0\].g_col\[0\].pe__2338_/A g_row\[0\].g_col\[0\].pe__2325_/A
+ VGND VGND VPWR VPWR g_row\[0\].g_col\[0\].pe__2352_/B sky130_fd_sc_hd__or2b_2
XFILLER_4_307 VGND VGND VPWR VPWR sky130_fd_sc_hd__fill_1
XTAP_TAPCELL_ROW_31_681 VGND VPWR sky130_fd_sc_hd__tapvpwrvgnd_1
Xg_row\[0\].g_col\[0\].pe__2269_ g_row\[0\].g_col\[0\].pe__2269_/A VGND VGND VPWR
+ VPWR ANTENNA_179/DIODE sky130_fd_sc_hd__inv_2
Xg_row\[0\].g_col\[1\].pe__2285_ g_row\[0\].g_col\[1\].pe__2285_/A g_row\[0\].g_col\[1\].pe__2285_/B
+ VGND VGND VPWR VPWR g_row\[0\].g_col\[1\].pe__2310_/B sky130_fd_sc_hd__xnor2_2
XFILLER_88_642 VGND VGND VPWR VPWR sky130_fd_sc_hd__fill_2
Xhold3452 a_inputs_flat[22] VGND VGND VPWR VPWR hold3452/X sky130_fd_sc_hd__clkbuf_2
Xhold3441 hold3441/A VGND VGND VPWR VPWR hold3441/X sky130_fd_sc_hd__clkbuf_2
Xhold3430 hold3430/A VGND VGND VPWR VPWR hold3430/X sky130_fd_sc_hd__clkbuf_2
XFILLER_0_579 VGND VGND VPWR VPWR sky130_fd_sc_hd__fill_1
Xhold2740 hold3505/X VGND VGND VPWR VPWR hold3506/A sky130_fd_sc_hd__clkbuf_2
Xoutput1391 output1391/A VGND VGND VPWR VPWR results_flat[42] sky130_fd_sc_hd__buf_2
Xoutput1380 output1380/A VGND VGND VPWR VPWR results_flat[32] sky130_fd_sc_hd__buf_2
Xhold3485 hold3485/A VGND VGND VPWR VPWR hold3485/X sky130_fd_sc_hd__clkbuf_2
Xhold3474 hold3474/A VGND VGND VPWR VPWR hold3474/X sky130_fd_sc_hd__clkbuf_2
Xhold3463 hold3463/A VGND VGND VPWR VPWR hold3463/X sky130_fd_sc_hd__clkbuf_2
XFILLER_29_720 VGND VGND VPWR VPWR sky130_fd_sc_hd__decap_3
Xhold2751 hold3510/X VGND VGND VPWR VPWR hold3511/A sky130_fd_sc_hd__clkbuf_2
Xhold2762 hold3535/X VGND VGND VPWR VPWR hold3536/A sky130_fd_sc_hd__clkbuf_2
Xhold2773 hold2773/A VGND VGND VPWR VPWR _301_/D sky130_fd_sc_hd__clkbuf_2
Xhold3496 hold3496/A VGND VGND VPWR VPWR hold3496/X sky130_fd_sc_hd__clkbuf_2
Xhold2784 _169_/Y VGND VGND VPWR VPWR hold2784/X sky130_fd_sc_hd__clkbuf_2
Xhold2795 hold2795/A VGND VGND VPWR VPWR _199_/B_N sky130_fd_sc_hd__clkbuf_2
XFILLER_44_701 VGND VGND VPWR VPWR sky130_fd_sc_hd__fill_1
XTAP_TAPCELL_ROW_39_792 VGND VPWR sky130_fd_sc_hd__tapvpwrvgnd_1
XFILLER_71_553 VGND VGND VPWR VPWR sky130_fd_sc_hd__decap_3
XFILLER_71_564 VGND VGND VPWR VPWR sky130_fd_sc_hd__decap_3
XFILLER_24_480 VGND VGND VPWR VPWR sky130_fd_sc_hd__decap_3
XTAP_TAPCELL_ROW_61_1123 VGND VPWR sky130_fd_sc_hd__tapvpwrvgnd_1
XFILLER_12_642 VGND VGND VPWR VPWR sky130_fd_sc_hd__fill_2
XFILLER_22_70 VGND VGND VPWR VPWR sky130_fd_sc_hd__fill_1
XFILLER_7_156 VGND VGND VPWR VPWR sky130_fd_sc_hd__decap_3
XFILLER_8_668 VGND VGND VPWR VPWR sky130_fd_sc_hd__decap_3
XFILLER_7_167 VGND VGND VPWR VPWR sky130_fd_sc_hd__fill_1
Xg_row\[1\].g_col\[0\].pe__1700_ g_row\[1\].g_col\[0\].pe__1823_/A g_row\[1\].g_col\[0\].pe__1823_/B
+ g_row\[1\].g_col\[0\].pe__1699_/X VGND VGND VPWR VPWR g_row\[1\].g_col\[0\].pe__1827_/A
+ sky130_fd_sc_hd__a21oi_2
Xg_row\[1\].g_col\[0\].pe__2680_ g_row\[1\].g_col\[0\].pe__2680_/A g_row\[1\].g_col\[0\].pe__2680_/B
+ VGND VGND VPWR VPWR g_row\[1\].g_col\[0\].pe__2680_/Y sky130_fd_sc_hd__nand2_2
XTAP_TAPCELL_ROW_59_1096 VGND VPWR sky130_fd_sc_hd__tapvpwrvgnd_1
Xg_row\[1\].g_col\[0\].pe__1631_ g_row\[1\].g_col\[0\].pe__1583_/A g_row\[1\].g_col\[0\].pe__1583_/B
+ g_row\[1\].g_col\[0\].pe__1630_/X VGND VGND VPWR VPWR g_row\[1\].g_col\[0\].pe__1883_/B
+ sky130_fd_sc_hd__a21oi_2
XFILLER_79_620 VGND VGND VPWR VPWR sky130_fd_sc_hd__fill_1
Xg_row\[1\].g_col\[0\].pe__1562_ g_row\[1\].g_col\[0\].pe__1562_/A g_row\[1\].g_col\[0\].pe__1562_/B
+ g_row\[1\].g_col\[0\].pe__1562_/C VGND VGND VPWR VPWR g_row\[1\].g_col\[0\].pe__1563_/B
+ sky130_fd_sc_hd__nor3_2
XFILLER_78_141 VGND VGND VPWR VPWR sky130_fd_sc_hd__fill_1
XFILLER_79_653 VGND VGND VPWR VPWR sky130_fd_sc_hd__decap_3
XTAP_TAPCELL_ROW_72_1285 VGND VPWR sky130_fd_sc_hd__tapvpwrvgnd_1
XTAP_TAPCELL_ROW_72_1296 VGND VPWR sky130_fd_sc_hd__tapvpwrvgnd_1
Xg_row\[1\].g_col\[0\].pe_hold1725 g_row\[1\].g_col\[0\].pe_hold3095/X VGND VGND VPWR
+ VPWR g_row\[1\].g_col\[0\].pe__2728_/D sky130_fd_sc_hd__clkbuf_2
Xg_row\[1\].g_col\[0\].pe__1493_ g_row\[1\].g_col\[0\].pe__1816_/A g_row\[1\].g_col\[0\].pe__1493_/B
+ VGND VGND VPWR VPWR g_row\[1\].g_col\[0\].pe__1536_/A sky130_fd_sc_hd__xor2_2
Xg_row\[1\].g_col\[0\].pe_hold1769 g_row\[1\].g_col\[0\].pe__2755_/Q VGND VGND VPWR
+ VPWR g_row\[1\].g_col\[0\].pe__2403_/A sky130_fd_sc_hd__clkbuf_2
Xg_row\[1\].g_col\[0\].pe_hold1758 g_row\[1\].g_col\[0\].pe__2766_/Q VGND VGND VPWR
+ VPWR g_row\[1\].g_col\[0\].pe__2572_/A1 sky130_fd_sc_hd__clkbuf_2
XFILLER_34_200 VGND VGND VPWR VPWR sky130_fd_sc_hd__decap_3
XFILLER_47_583 VGND VGND VPWR VPWR sky130_fd_sc_hd__decap_3
XFILLER_93_166 VGND VGND VPWR VPWR sky130_fd_sc_hd__fill_2
Xg_row\[0\].g_col\[0\].pe__1640_ g_row\[0\].g_col\[0\].pe__1640_/A g_row\[0\].g_col\[0\].pe__1640_/B
+ VGND VGND VPWR VPWR g_row\[0\].g_col\[0\].pe__1701_/A sky130_fd_sc_hd__xnor2_2
XFILLER_34_233 VGND VGND VPWR VPWR sky130_fd_sc_hd__decap_3
Xg_row\[0\].g_col\[0\].pe__1571_ g_row\[0\].g_col\[0\].pe__1571_/A g_row\[0\].g_col\[0\].pe__1571_/B
+ VGND VGND VPWR VPWR g_row\[0\].g_col\[0\].pe__1583_/A sky130_fd_sc_hd__xor2_2
Xg_row\[1\].g_col\[1\].pe__2130_ g_row\[1\].g_col\[1\].pe__2030_/A g_row\[1\].g_col\[1\].pe__1471_/X
+ g_row\[1\].g_col\[1\].pe__1474_/Y g_row\[1\].g_col\[1\].pe__2278_/B2 VGND VGND VPWR
+ VPWR g_row\[1\].g_col\[1\].pe__2131_/B sky130_fd_sc_hd__a22o_2
Xg_row\[1\].g_col\[0\].pe__2114_ g_row\[1\].g_col\[0\].pe__2404_/A1 g_row\[1\].g_col\[0\].pe__2114_/A2
+ g_row\[1\].g_col\[0\].pe__2112_/Y g_row\[1\].g_col\[0\].pe__2113_/X VGND VGND VPWR
+ VPWR g_row\[1\].g_col\[0\].pe__2114_/X sky130_fd_sc_hd__o22a_2
XFILLER_22_406 VGND VGND VPWR VPWR sky130_fd_sc_hd__fill_1
XFILLER_50_715 VGND VGND VPWR VPWR sky130_fd_sc_hd__fill_1
XFILLER_62_564 VGND VGND VPWR VPWR sky130_fd_sc_hd__fill_2
XTAP_TAPCELL_ROW_17_464 VGND VPWR sky130_fd_sc_hd__tapvpwrvgnd_1
Xg_row\[1\].g_col\[1\].pe__2061_ g_row\[1\].g_col\[1\].pe__2062_/A g_row\[1\].g_col\[1\].pe__2062_/C
+ g_row\[1\].g_col\[1\].pe__2150_/C VGND VGND VPWR VPWR g_row\[1\].g_col\[1\].pe__2061_/Y
+ sky130_fd_sc_hd__o21ai_2
Xg_row\[1\].g_col\[0\].pe__2045_ g_row\[1\].g_col\[0\].pe__2726_/Q g_row\[1\].g_col\[0\].pe__2682_/A
+ VGND VGND VPWR VPWR g_row\[1\].g_col\[0\].pe__2045_/X sky130_fd_sc_hd__and2_2
XFILLER_30_450 VGND VGND VPWR VPWR sky130_fd_sc_hd__decap_3
Xg_row\[0\].g_col\[0\].pe__2123_ g_row\[0\].g_col\[0\].pe__2123_/A g_row\[0\].g_col\[0\].pe__2123_/B
+ g_row\[0\].g_col\[0\].pe__2123_/C VGND VGND VPWR VPWR g_row\[0\].g_col\[0\].pe__2128_/B
+ sky130_fd_sc_hd__nand3_2
Xg_row\[0\].g_col\[0\].pe__2054_ g_row\[0\].g_col\[0\].pe__2054_/A g_row\[0\].g_col\[0\].pe__2054_/B
+ VGND VGND VPWR VPWR g_row\[0\].g_col\[0\].pe__2068_/A sky130_fd_sc_hd__nand2_2
Xg_row\[1\].g_col\[1\].pe__1914_ g_row\[1\].g_col\[1\].pe__2177_/B2 g_row\[1\].g_col\[1\].pe__1471_/X
+ g_row\[1\].g_col\[1\].pe__2247_/B1 g_row\[1\].g_col\[1\].pe__2138_/B2 VGND VGND
+ VPWR VPWR g_row\[1\].g_col\[1\].pe__1915_/B sky130_fd_sc_hd__a22o_2
Xg_row\[0\].g_col\[1\].pe__2070_ g_row\[0\].g_col\[1\].pe__1961_/A g_row\[0\].g_col\[1\].pe__1961_/B
+ g_row\[0\].g_col\[1\].pe__2024_/B g_row\[0\].g_col\[1\].pe__2023_/B g_row\[0\].g_col\[1\].pe__2023_/A
+ VGND VGND VPWR VPWR g_row\[0\].g_col\[1\].pe__2107_/A sky130_fd_sc_hd__a32o_2
Xg_row\[1\].g_col\[1\].pe__1845_ g_row\[1\].g_col\[1\].pe__1636_/B g_row\[1\].g_col\[1\].pe__1845_/B
+ VGND VGND VPWR VPWR g_row\[1\].g_col\[1\].pe__1888_/A sky130_fd_sc_hd__and2b_2
Xg_row\[1\].g_col\[0\].pe__1829_ g_row\[1\].g_col\[0\].pe__1821_/X g_row\[1\].g_col\[0\].pe__1822_/X
+ g_row\[1\].g_col\[0\].pe__1826_/Y g_row\[1\].g_col\[0\].pe__1827_/Y g_row\[1\].g_col\[0\].pe__1828_/Y
+ VGND VGND VPWR VPWR g_row\[1\].g_col\[0\].pe__1829_/Y sky130_fd_sc_hd__o311ai_2
Xg_row\[1\].g_col\[1\].pe__1776_ g_row\[1\].g_col\[1\].pe__1776_/A g_row\[1\].g_col\[1\].pe__1776_/B
+ VGND VGND VPWR VPWR g_row\[1\].g_col\[1\].pe__1777_/B sky130_fd_sc_hd__xor2_2
Xhold2047 hold2047/A VGND VGND VPWR VPWR hold2047/X sky130_fd_sc_hd__clkbuf_2
Xhold2069 hold2069/A VGND VGND VPWR VPWR hold2069/X sky130_fd_sc_hd__clkbuf_2
Xg_row\[1\].g_col\[0\].pe_hold2960 g_row\[1\].g_col\[0\].pe_hold2960/A VGND VGND VPWR
+ VPWR g_row\[1\].g_col\[0\].pe__2600_/A2 sky130_fd_sc_hd__clkbuf_2
Xg_row\[0\].g_col\[1\].pe__1923_ g_row\[0\].g_col\[1\].pe__1424_/A g_row\[0\].g_col\[1\].pe__1424_/B
+ g_row\[0\].g_col\[1\].pe__1922_/Y VGND VGND VPWR VPWR g_row\[0\].g_col\[1\].pe__1924_/C
+ sky130_fd_sc_hd__a21oi_2
XFILLER_85_667 VGND VGND VPWR VPWR sky130_fd_sc_hd__fill_1
Xg_row\[0\].g_col\[0\].pe__1907_ g_row\[0\].g_col\[0\].pe__1907_/A g_row\[0\].g_col\[0\].pe__1907_/B
+ VGND VGND VPWR VPWR g_row\[0\].g_col\[0\].pe__1908_/B sky130_fd_sc_hd__xor2_2
XFILLER_25_200 VGND VGND VPWR VPWR sky130_fd_sc_hd__fill_2
XFILLER_26_701 VGND VGND VPWR VPWR sky130_fd_sc_hd__fill_1
Xg_row\[0\].g_col\[0\].pe__1838_ g_row\[0\].g_col\[0\].pe__1838_/A _275_/Q VGND VGND
+ VPWR VPWR g_row\[0\].g_col\[0\].pe__2010_/A sky130_fd_sc_hd__or2_2
Xg_row\[0\].g_col\[1\].pe__1854_ g_row\[0\].g_col\[1\].pe__2694_/Q g_row\[0\].g_col\[1\].pe__1549_/B
+ g_row\[0\].g_col\[1\].pe__2216_/B1 g_row\[0\].g_col\[1\].pe__1957_/B2 VGND VGND
+ VPWR VPWR g_row\[0\].g_col\[1\].pe__1855_/B sky130_fd_sc_hd__a22o_2
Xg_row\[0\].g_col\[0\].pe__1769_ g_row\[0\].g_col\[0\].pe__1781_/A g_row\[0\].g_col\[0\].pe__1781_/B
+ VGND VGND VPWR VPWR g_row\[0\].g_col\[0\].pe__1793_/C sky130_fd_sc_hd__nand2_2
Xg_row\[1\].g_col\[1\].pe__2328_ g_row\[1\].g_col\[1\].pe__2355_/A g_row\[1\].g_col\[1\].pe__2328_/B
+ VGND VGND VPWR VPWR g_row\[1\].g_col\[1\].pe__2329_/B sky130_fd_sc_hd__or2_2
Xg_row\[0\].g_col\[1\].pe__1785_ g_row\[0\].g_col\[1\].pe__2686_/A g_row\[0\].g_col\[1\].pe__1785_/B
+ VGND VGND VPWR VPWR g_row\[0\].g_col\[1\].pe__1796_/B sky130_fd_sc_hd__xor2_2
XTAP_TAPCELL_ROW_36_751 VGND VPWR sky130_fd_sc_hd__tapvpwrvgnd_1
Xg_row\[1\].g_col\[1\].pe__2259_ g_row\[1\].g_col\[1\].pe__2226_/A g_row\[1\].g_col\[1\].pe__2226_/B
+ g_row\[1\].g_col\[1\].pe__2258_/X VGND VGND VPWR VPWR g_row\[1\].g_col\[1\].pe__2330_/B
+ sky130_fd_sc_hd__a21oi_2
Xg_row\[0\].g_col\[1\].pe__2406_ g_row\[0\].g_col\[1\].pe__2755_/Q _275_/Q g_row\[0\].g_col\[1\].pe__2406_/B1
+ VGND VGND VPWR VPWR g_row\[0\].g_col\[1\].pe__2406_/Y sky130_fd_sc_hd__o21ai_2
Xg_row\[0\].g_col\[1\].pe__2337_ g_row\[0\].g_col\[1\].pe__2337_/A g_row\[0\].g_col\[1\].pe__2337_/B
+ g_row\[0\].g_col\[1\].pe__2337_/C VGND VGND VPWR VPWR g_row\[0\].g_col\[1\].pe__2352_/A
+ sky130_fd_sc_hd__or3_2
XFILLER_4_104 VGND VGND VPWR VPWR sky130_fd_sc_hd__decap_3
Xg_row\[0\].g_col\[1\].pe__2268_ g_row\[0\].g_col\[1\].pe__2405_/A g_row\[0\].g_col\[1\].pe__2268_/B
+ VGND VGND VPWR VPWR g_row\[0\].g_col\[1\].pe__2748_/D sky130_fd_sc_hd__nor2_2
Xinput1289 hold3336/X VGND VGND VPWR VPWR hold3337/A sky130_fd_sc_hd__buf_2
Xg_row\[1\].g_col\[1\].pe_hold1811 g_row\[1\].g_col\[1\].pe__2554_/X VGND VGND VPWR
+ VPWR g_row\[1\].g_col\[1\].pe__2555_/B sky130_fd_sc_hd__clkbuf_2
Xg_row\[0\].g_col\[1\].pe__2199_ _199_/A g_row\[0\].g_col\[1\].pe__2199_/B VGND VGND
+ VPWR VPWR g_row\[0\].g_col\[1\].pe__2746_/D sky130_fd_sc_hd__nor2_2
XFILLER_88_461 VGND VGND VPWR VPWR sky130_fd_sc_hd__fill_1
Xhold3260 hold3260/A VGND VGND VPWR VPWR hold3260/X sky130_fd_sc_hd__clkbuf_2
Xhold3271 hold3271/A VGND VGND VPWR VPWR hold3271/X sky130_fd_sc_hd__clkbuf_2
Xhold3282 hold3282/A VGND VGND VPWR VPWR hold3282/X sky130_fd_sc_hd__clkbuf_2
Xhold3293 hold3293/A VGND VGND VPWR VPWR hold3293/X sky130_fd_sc_hd__clkbuf_2
XFILLER_76_645 VGND VGND VPWR VPWR sky130_fd_sc_hd__fill_1
XFILLER_76_678 VGND VGND VPWR VPWR sky130_fd_sc_hd__decap_3
Xhold2570 hold3263/X VGND VGND VPWR VPWR hold3264/A sky130_fd_sc_hd__clkbuf_2
Xhold2581 hold2581/A VGND VGND VPWR VPWR _287_/D sky130_fd_sc_hd__clkbuf_2
Xhold2592 _259_/Y VGND VGND VPWR VPWR hold2592/X sky130_fd_sc_hd__clkbuf_2
XFILLER_17_701 VGND VGND VPWR VPWR sky130_fd_sc_hd__decap_3
XFILLER_75_155 VGND VGND VPWR VPWR sky130_fd_sc_hd__decap_3
XFILLER_75_177 VGND VGND VPWR VPWR sky130_fd_sc_hd__fill_1
XFILLER_91_637 VGND VGND VPWR VPWR sky130_fd_sc_hd__decap_3
XFILLER_29_583 VGND VGND VPWR VPWR sky130_fd_sc_hd__decap_3
XFILLER_56_380 VGND VGND VPWR VPWR sky130_fd_sc_hd__decap_3
XFILLER_32_704 VGND VGND VPWR VPWR sky130_fd_sc_hd__decap_3
XFILLER_44_553 VGND VGND VPWR VPWR sky130_fd_sc_hd__decap_3
XTAP_TAPCELL_ROW_14_423 VGND VPWR sky130_fd_sc_hd__tapvpwrvgnd_1
XFILLER_76_7 VGND VGND VPWR VPWR sky130_fd_sc_hd__fill_2
Xg_row\[1\].g_col\[0\].pe__2732_ clkbuf_leaf_46_clk/X g_row\[1\].g_col\[0\].pe__2732_/D
+ VGND VGND VPWR VPWR g_row\[1\].g_col\[0\].pe__2732_/Q sky130_fd_sc_hd__dfxtp_2
XTAP_TAPCELL_ROW_74_1314 VGND VPWR sky130_fd_sc_hd__tapvpwrvgnd_1
XTAP_TAPCELL_ROW_74_1325 VGND VPWR sky130_fd_sc_hd__tapvpwrvgnd_1
Xg_row\[1\].g_col\[0\].pe__2663_ g_row\[1\].g_col\[0\].pe__2663_/A g_row\[1\].g_col\[0\].pe__2663_/B
+ VGND VGND VPWR VPWR g_row\[1\].g_col\[0\].pe__2663_/X sky130_fd_sc_hd__or2_2
Xg_row\[1\].g_col\[1\].pe__1630_ g_row\[1\].g_col\[1\].pe__1582_/B g_row\[1\].g_col\[1\].pe__1630_/B
+ VGND VGND VPWR VPWR g_row\[1\].g_col\[1\].pe__1630_/X sky130_fd_sc_hd__and2b_2
Xg_row\[1\].g_col\[0\].pe__1614_ g_row\[1\].g_col\[0\].pe__1676_/A g_row\[1\].g_col\[0\].pe__1614_/B
+ VGND VGND VPWR VPWR g_row\[1\].g_col\[0\].pe__1615_/B sky130_fd_sc_hd__xnor2_2
XFILLER_79_461 VGND VGND VPWR VPWR sky130_fd_sc_hd__fill_1
XFILLER_86_409 VGND VGND VPWR VPWR sky130_fd_sc_hd__fill_2
Xg_row\[1\].g_col\[0\].pe__2594_ g_row\[1\].g_col\[0\].pe__2403_/A g_row\[1\].g_col\[0\].pe__2157_/A
+ g_row\[1\].g_col\[0\].pe__2516_/X g_row\[1\].g_col\[0\].pe__2406_/Y g_row\[1\].g_col\[0\].pe__2594_/B2
+ VGND VGND VPWR VPWR g_row\[1\].g_col\[0\].pe__2594_/X sky130_fd_sc_hd__a32o_2
XFILLER_67_612 VGND VGND VPWR VPWR sky130_fd_sc_hd__decap_3
Xg_row\[1\].g_col\[1\].pe__1561_ g_row\[1\].g_col\[1\].pe__1562_/A g_row\[1\].g_col\[1\].pe__1562_/B
+ g_row\[1\].g_col\[1\].pe__1562_/C VGND VGND VPWR VPWR g_row\[1\].g_col\[1\].pe__1846_/A
+ sky130_fd_sc_hd__o21a_2
Xg_row\[1\].g_col\[0\].pe_hold2234 g_row\[1\].g_col\[0\].pe__2753_/Q VGND VGND VPWR
+ VPWR g_row\[1\].g_col\[0\].pe__2383_/A sky130_fd_sc_hd__clkbuf_2
Xg_row\[1\].g_col\[0\].pe_hold2223 g_row\[1\].g_col\[0\].pe__2397_/Y VGND VGND VPWR
+ VPWR g_row\[1\].g_col\[0\].pe__2401_/A2 sky130_fd_sc_hd__clkbuf_2
Xg_row\[1\].g_col\[0\].pe__1545_ g_row\[1\].g_col\[0\].pe__1545_/A g_row\[1\].g_col\[0\].pe__1552_/B
+ VGND VGND VPWR VPWR g_row\[1\].g_col\[0\].pe__1546_/B sky130_fd_sc_hd__xnor2_2
XFILLER_39_358 VGND VGND VPWR VPWR sky130_fd_sc_hd__decap_3
XFILLER_67_656 VGND VGND VPWR VPWR sky130_fd_sc_hd__decap_3
Xg_row\[0\].g_col\[0\].pe__2741_ clkbuf_leaf_24_clk/X g_row\[0\].g_col\[0\].pe__2741_/D
+ VGND VGND VPWR VPWR g_row\[0\].g_col\[0\].pe__2741_/Q sky130_fd_sc_hd__dfxtp_2
Xg_row\[1\].g_col\[1\].pe_place837 g_row\[1\].g_col\[1\].pe__1461_/Y VGND VGND VPWR
+ VPWR g_row\[1\].g_col\[1\].pe__1863_/B1 sky130_fd_sc_hd__buf_6
Xg_row\[1\].g_col\[1\].pe__1492_ g_row\[1\].g_col\[1\].pe__2696_/Q g_row\[1\].g_col\[1\].pe__1748_/B
+ g_row\[1\].g_col\[1\].pe__1738_/B1 g_row\[1\].g_col\[1\].pe__2073_/B2 VGND VGND
+ VPWR VPWR g_row\[1\].g_col\[1\].pe__1493_/B sky130_fd_sc_hd__a22o_2
Xg_row\[1\].g_col\[0\].pe_hold2278 g_row\[1\].g_col\[0\].pe__2738_/Q VGND VGND VPWR
+ VPWR g_row\[1\].g_col\[0\].pe_hold2278/X sky130_fd_sc_hd__clkbuf_2
Xg_row\[1\].g_col\[0\].pe_hold2256 g_row\[1\].g_col\[0\].pe__2750_/Q VGND VGND VPWR
+ VPWR g_row\[1\].g_col\[0\].pe__2308_/A sky130_fd_sc_hd__clkbuf_2
Xg_row\[1\].g_col\[0\].pe__1476_ place1104/A g_row\[1\].g_col\[0\].pe__1657_/B g_row\[1\].g_col\[0\].pe__2036_/B1
+ g_row\[1\].g_col\[0\].pe__2599_/B VGND VGND VPWR VPWR g_row\[1\].g_col\[0\].pe__1477_/B
+ sky130_fd_sc_hd__a22o_2
XFILLER_54_328 VGND VGND VPWR VPWR sky130_fd_sc_hd__fill_2
XFILLER_67_689 VGND VGND VPWR VPWR sky130_fd_sc_hd__decap_3
XFILLER_82_626 VGND VGND VPWR VPWR sky130_fd_sc_hd__fill_1
Xg_row\[0\].g_col\[0\].pe__2672_ g_row\[0\].g_col\[0\].pe__2672_/A _321_/Q g_row\[0\].g_col\[0\].pe__2672_/C
+ g_row\[0\].g_col\[0\].pe__2672_/D VGND VGND VPWR VPWR g_row\[0\].g_col\[0\].pe__2672_/X
+ sky130_fd_sc_hd__or4_2
Xg_row\[0\].g_col\[0\].pe__1623_ place1199/X g_row\[0\].g_col\[0\].pe__1982_/B g_row\[0\].g_col\[0\].pe__1424_/Y
+ place1201/X VGND VGND VPWR VPWR g_row\[0\].g_col\[0\].pe__1624_/B sky130_fd_sc_hd__a22o_2
Xg_row\[0\].g_col\[1\].pe__1570_ g_row\[0\].g_col\[1\].pe__1676_/A g_row\[0\].g_col\[1\].pe__1570_/B
+ VGND VGND VPWR VPWR g_row\[0\].g_col\[1\].pe__1571_/B sky130_fd_sc_hd__xnor2_2
Xg_row\[1\].g_col\[1\].pe__2113_ g_row\[1\].g_col\[1\].pe__2066_/Y g_row\[1\].g_col\[1\].pe__2061_/Y
+ g_row\[1\].g_col\[1\].pe__2111_/X g_row\[1\].g_col\[1\].pe__2010_/A VGND VGND VPWR
+ VPWR g_row\[1\].g_col\[1\].pe__2113_/X sky130_fd_sc_hd__a31o_2
XFILLER_35_597 VGND VGND VPWR VPWR sky130_fd_sc_hd__decap_3
XTAP_TAPCELL_ROW_33_710 VGND VPWR sky130_fd_sc_hd__tapvpwrvgnd_1
XTAP_TAPCELL_ROW_85_1487 VGND VPWR sky130_fd_sc_hd__tapvpwrvgnd_1
Xg_row\[0\].g_col\[0\].pe__1554_ g_row\[0\].g_col\[0\].pe__1554_/A g_row\[0\].g_col\[0\].pe__1554_/B
+ VGND VGND VPWR VPWR g_row\[0\].g_col\[0\].pe__1562_/A sky130_fd_sc_hd__and2_2
Xg_row\[0\].g_col\[0\].pe__1485_ place1204/X g_row\[0\].g_col\[0\].pe__1784_/A2 g_row\[0\].g_col\[0\].pe__1784_/A3
+ g_row\[0\].g_col\[0\].pe__1801_/B place1201/X VGND VGND VPWR VPWR g_row\[0\].g_col\[0\].pe__1486_/B
+ sky130_fd_sc_hd__a32o_2
Xg_row\[1\].g_col\[1\].pe__2044_ g_row\[1\].g_col\[1\].pe__2094_/C g_row\[1\].g_col\[1\].pe__2044_/B
+ VGND VGND VPWR VPWR g_row\[1\].g_col\[1\].pe__2047_/A sky130_fd_sc_hd__and2_2
Xg_row\[1\].g_col\[0\].pe__2028_ g_row\[1\].g_col\[0\].pe__1910_/A g_row\[1\].g_col\[0\].pe__2028_/B
+ g_row\[1\].g_col\[0\].pe__2028_/C VGND VGND VPWR VPWR g_row\[1\].g_col\[0\].pe__2034_/A
+ sky130_fd_sc_hd__nand3b_2
XFILLER_13_39 VGND VGND VPWR VPWR sky130_fd_sc_hd__fill_1
XFILLER_50_589 VGND VGND VPWR VPWR sky130_fd_sc_hd__fill_1
Xg_row\[0\].g_col\[0\].pe__2106_ g_row\[0\].g_col\[0\].pe__2106_/A g_row\[0\].g_col\[0\].pe__2105_/X
+ VGND VGND VPWR VPWR g_row\[0\].g_col\[0\].pe__2107_/B sky130_fd_sc_hd__nor2b_4
Xg_row\[0\].g_col\[1\].pe__2122_ g_row\[0\].g_col\[1\].pe__1461_/A g_row\[0\].g_col\[1\].pe__1461_/B
+ g_row\[0\].g_col\[1\].pe__1922_/Y VGND VGND VPWR VPWR g_row\[0\].g_col\[1\].pe__2123_/C
+ sky130_fd_sc_hd__a21o_2
XFILLER_2_608 VGND VGND VPWR VPWR sky130_fd_sc_hd__fill_1
Xg_row\[0\].g_col\[0\].pe__2037_ g_row\[0\].g_col\[0\].pe__2171_/A g_row\[0\].g_col\[0\].pe__2037_/B
+ VGND VGND VPWR VPWR g_row\[0\].g_col\[0\].pe__2038_/C sky130_fd_sc_hd__xnor2_2
Xg_row\[0\].g_col\[1\].pe__2053_ g_row\[0\].g_col\[1\].pe__2052_/B g_row\[0\].g_col\[1\].pe__2052_/C
+ g_row\[0\].g_col\[1\].pe__2052_/A VGND VGND VPWR VPWR g_row\[0\].g_col\[1\].pe__2054_/B
+ sky130_fd_sc_hd__o21ai_2
Xg_row\[1\].g_col\[1\].pe__1828_ g_row\[1\].g_col\[1\].pe__1828_/A g_row\[1\].g_col\[1\].pe__1828_/B
+ VGND VGND VPWR VPWR g_row\[1\].g_col\[1\].pe__1828_/Y sky130_fd_sc_hd__nand2_2
XFILLER_58_601 VGND VGND VPWR VPWR sky130_fd_sc_hd__fill_2
Xg_row\[1\].g_col\[1\].pe__1759_ g_row\[1\].g_col\[1\].pe__1774_/A g_row\[1\].g_col\[1\].pe__1774_/B
+ VGND VGND VPWR VPWR g_row\[1\].g_col\[1\].pe__1760_/B sky130_fd_sc_hd__xor2_2
Xg_row\[0\].g_col\[1\].pe__1906_ g_row\[0\].g_col\[1\].pe__1964_/A g_row\[0\].g_col\[1\].pe__1906_/B
+ VGND VGND VPWR VPWR g_row\[0\].g_col\[1\].pe__1907_/B sky130_fd_sc_hd__and2_2
XFILLER_26_520 VGND VGND VPWR VPWR sky130_fd_sc_hd__decap_3
XFILLER_13_225 VGND VGND VPWR VPWR sky130_fd_sc_hd__fill_1
XFILLER_81_670 VGND VGND VPWR VPWR sky130_fd_sc_hd__fill_2
XTAP_TAPCELL_ROW_0_195 VGND VPWR sky130_fd_sc_hd__tapvpwrvgnd_1
Xg_row\[0\].g_col\[1\].pe__1768_ g_row\[0\].g_col\[1\].pe__2125_/C g_row\[0\].g_col\[1\].pe__1768_/B
+ VGND VGND VPWR VPWR g_row\[0\].g_col\[1\].pe__1781_/B sky130_fd_sc_hd__xnor2_2
Xg_row\[0\].g_col\[1\].pe__1699_ g_row\[0\].g_col\[1\].pe__1698_/A g_row\[0\].g_col\[1\].pe__1699_/B
+ VGND VGND VPWR VPWR g_row\[0\].g_col\[1\].pe__1699_/X sky130_fd_sc_hd__and2b_2
Xg_row\[1\].g_col\[1\].pe_hold3021 g_row\[1\].g_col\[1\].pe__2732_/Q VGND VGND VPWR
+ VPWR g_row\[1\].g_col\[1\].pe_hold3021/X sky130_fd_sc_hd__clkbuf_2
Xg_row\[1\].g_col\[1\].pe_hold3065 g_row\[1\].g_col\[1\].pe__2737_/Q VGND VGND VPWR
+ VPWR g_row\[1\].g_col\[1\].pe_hold3065/X sky130_fd_sc_hd__clkbuf_2
Xg_row\[1\].g_col\[1\].pe_hold3076 g_row\[1\].g_col\[1\].pe__2679_/X VGND VGND VPWR
+ VPWR g_row\[1\].g_col\[1\].pe_hold3076/X sky130_fd_sc_hd__clkbuf_2
XTAP_TAPCELL_ROW_56_1044 VGND VPWR sky130_fd_sc_hd__tapvpwrvgnd_1
XTAP_TAPCELL_ROW_56_1055 VGND VPWR sky130_fd_sc_hd__tapvpwrvgnd_1
Xg_row\[1\].g_col\[1\].pe_hold1663 g_row\[1\].g_col\[1\].pe__2757_/Q VGND VGND VPWR
+ VPWR g_row\[1\].g_col\[1\].pe__2521_/A1 sky130_fd_sc_hd__clkbuf_2
Xg_row\[1\].g_col\[1\].pe_hold1652 g_row\[1\].g_col\[1\].pe__2064_/Y VGND VGND VPWR
+ VPWR g_row\[1\].g_col\[1\].pe__2743_/D sky130_fd_sc_hd__clkbuf_2
XFILLER_49_612 VGND VGND VPWR VPWR sky130_fd_sc_hd__decap_3
XFILLER_89_770 VGND VGND VPWR VPWR sky130_fd_sc_hd__decap_3
Xg_row\[1\].g_col\[1\].pe_hold1696 g_row\[1\].g_col\[1\].pe__2439_/A VGND VGND VPWR
+ VPWR g_row\[1\].g_col\[1\].pe__2198_/A2 sky130_fd_sc_hd__clkbuf_2
Xg_row\[1\].g_col\[1\].pe_hold1685 g_row\[1\].g_col\[1\].pe__1892_/X VGND VGND VPWR
+ VPWR g_row\[1\].g_col\[1\].pe__1893_/B sky130_fd_sc_hd__clkbuf_2
Xg_row\[1\].g_col\[1\].pe_hold1674 g_row\[1\].g_col\[1\].pe__1406_/Y VGND VGND VPWR
+ VPWR g_row\[1\].g_col\[1\].pe__2404_/B1 sky130_fd_sc_hd__clkbuf_2
XFILLER_36_306 VGND VGND VPWR VPWR sky130_fd_sc_hd__fill_2
Xg_row\[1\].g_col\[1\].pe_place1009 g_row\[1\].g_col\[1\].pe_hold3069/X VGND VGND
+ VPWR VPWR g_row\[1\].g_col\[1\].pe__1816_/A sky130_fd_sc_hd__buf_6
XFILLER_36_339 VGND VGND VPWR VPWR sky130_fd_sc_hd__fill_2
XFILLER_32_501 VGND VGND VPWR VPWR sky130_fd_sc_hd__fill_1
XFILLER_32_567 VGND VGND VPWR VPWR sky130_fd_sc_hd__fill_1
Xg_row\[0\].g_col\[0\].pe_hold2877 _279_/Q VGND VGND VPWR VPWR g_row\[0\].g_col\[0\].pe_hold2877/X
+ sky130_fd_sc_hd__clkbuf_2
Xg_row\[0\].g_col\[0\].pe_hold2888 g_row\[0\].g_col\[0\].pe__2613_/X VGND VGND VPWR
+ VPWR g_row\[0\].g_col\[0\].pe_hold2888/X sky130_fd_sc_hd__clkbuf_2
XFILLER_13_781 VGND VGND VPWR VPWR sky130_fd_sc_hd__decap_3
XFILLER_12_291 VGND VGND VPWR VPWR sky130_fd_sc_hd__fill_1
XFILLER_8_251 VGND VGND VPWR VPWR sky130_fd_sc_hd__fill_1
XFILLER_9_785 VGND VGND VPWR VPWR sky130_fd_sc_hd__fill_1
XFILLER_67_3 VGND VGND VPWR VPWR sky130_fd_sc_hd__decap_3
Xg_row\[1\].g_col\[1\].pe__2731_ clkbuf_leaf_83_clk/X g_row\[1\].g_col\[1\].pe__2731_/D
+ VGND VGND VPWR VPWR g_row\[1\].g_col\[1\].pe__2731_/Q sky130_fd_sc_hd__dfxtp_2
Xg_row\[1\].g_col\[0\].pe__2715_ clkbuf_leaf_50_clk/X g_row\[1\].g_col\[0\].pe__2715_/D
+ VGND VGND VPWR VPWR g_row\[1\].g_col\[0\].pe__2715_/Q sky130_fd_sc_hd__dfxtp_2
XFILLER_87_707 VGND VGND VPWR VPWR sky130_fd_sc_hd__decap_3
Xg_row\[1\].g_col\[1\].pe__2662_ g_row\[1\].g_col\[1\].pe__2670_/A1 hold2090/X g_row\[1\].g_col\[1\].pe__2670_/B1
+ g_row\[1\].g_col\[1\].pe__2662_/C1 VGND VGND VPWR VPWR g_row\[1\].g_col\[1\].pe__2662_/X
+ sky130_fd_sc_hd__o211a_2
Xg_row\[1\].g_col\[0\].pe__2646_ g_row\[1\].g_col\[0\].pe__2652_/A1 hold2048/X g_row\[1\].g_col\[0\].pe__2677_/B1
+ g_row\[1\].g_col\[0\].pe__2646_/C1 VGND VGND VPWR VPWR g_row\[1\].g_col\[0\].pe__2646_/X
+ sky130_fd_sc_hd__o211a_2
Xclkbuf_4_7_0_clk clkbuf_0_clk/X VGND VGND VPWR VPWR clkload3/A sky130_fd_sc_hd__clkbuf_16
Xg_row\[1\].g_col\[1\].pe__1613_ g_row\[1\].g_col\[1\].pe__2073_/B2 g_row\[1\].g_col\[1\].pe__1657_/B
+ g_row\[1\].g_col\[1\].pe__1613_/B1 g_row\[1\].g_col\[1\].pe__2019_/B2 VGND VGND
+ VPWR VPWR g_row\[1\].g_col\[1\].pe__1614_/B sky130_fd_sc_hd__a22o_2
Xg_row\[1\].g_col\[0\].pe__2577_ g_row\[1\].g_col\[0\].pe__2595_/A g_row\[1\].g_col\[0\].pe__2577_/B
+ VGND VGND VPWR VPWR g_row\[1\].g_col\[0\].pe__2767_/D sky130_fd_sc_hd__and2_2
Xg_row\[1\].g_col\[1\].pe__1544_ g_row\[1\].g_col\[1\].pe__1602_/A g_row\[1\].g_col\[1\].pe__1544_/B
+ VGND VGND VPWR VPWR g_row\[1\].g_col\[1\].pe__1552_/B sky130_fd_sc_hd__xnor2_2
Xg_row\[1\].g_col\[0\].pe_hold2064 g_row\[1\].g_col\[0\].pe__2657_/X VGND VGND VPWR
+ VPWR g_row\[1\].g_col\[0\].pe__2658_/C1 sky130_fd_sc_hd__clkbuf_2
Xg_row\[1\].g_col\[0\].pe_hold2053 g_row\[1\].g_col\[0\].pe__2681_/X VGND VGND VPWR
+ VPWR g_row\[1\].g_col\[0\].pe__2723_/D sky130_fd_sc_hd__clkbuf_2
Xg_row\[1\].g_col\[0\].pe__1528_ g_row\[1\].g_col\[0\].pe__1864_/A g_row\[1\].g_col\[0\].pe__1528_/B
+ VGND VGND VPWR VPWR g_row\[1\].g_col\[0\].pe__1554_/B sky130_fd_sc_hd__xnor2_2
Xg_row\[0\].g_col\[1\].pe_hold3108 _326_/Q VGND VGND VPWR VPWR g_row\[0\].g_col\[1\].pe_hold3108/X
+ sky130_fd_sc_hd__clkbuf_2
XFILLER_55_615 VGND VGND VPWR VPWR sky130_fd_sc_hd__fill_1
XFILLER_55_626 VGND VGND VPWR VPWR sky130_fd_sc_hd__decap_3
XTAP_TAPCELL_ROW_87_1516 VGND VPWR sky130_fd_sc_hd__tapvpwrvgnd_1
Xg_row\[0\].g_col\[0\].pe__2724_ clkload12/A g_row\[0\].g_col\[0\].pe__2724_/D VGND
+ VGND VPWR VPWR g_row\[0\].g_col\[0\].pe__2724_/Q sky130_fd_sc_hd__dfxtp_2
Xg_row\[1\].g_col\[0\].pe_hold2075 g_row\[1\].g_col\[0\].pe_hold3037/X VGND VGND VPWR
+ VPWR g_row\[1\].g_col\[0\].pe__2717_/D sky130_fd_sc_hd__clkbuf_2
Xg_row\[0\].g_col\[1\].pe_hold2407 g_row\[0\].g_col\[1\].pe__2064_/Y VGND VGND VPWR
+ VPWR g_row\[0\].g_col\[1\].pe__2743_/D sky130_fd_sc_hd__clkbuf_2
Xg_row\[0\].g_col\[1\].pe__2740_ clkbuf_leaf_7_clk/X g_row\[0\].g_col\[1\].pe__2740_/D
+ VGND VGND VPWR VPWR g_row\[0\].g_col\[1\].pe__2740_/Q sky130_fd_sc_hd__dfxtp_2
Xg_row\[1\].g_col\[0\].pe__1459_ g_row\[1\].g_col\[0\].pe__2732_/Q g_row\[1\].g_col\[0\].pe__2731_/Q
+ g_row\[1\].g_col\[0\].pe__1460_/B VGND VGND VPWR VPWR g_row\[1\].g_col\[0\].pe__1461_/A
+ sky130_fd_sc_hd__nand3b_2
Xg_row\[0\].g_col\[1\].pe__2671_ _334_/Q _333_/Q _336_/Q _335_/Q VGND VGND VPWR VPWR
+ g_row\[0\].g_col\[1\].pe__2672_/D sky130_fd_sc_hd__or4_2
XFILLER_54_158 VGND VGND VPWR VPWR sky130_fd_sc_hd__fill_1
Xg_row\[0\].g_col\[0\].pe__2655_ g_row\[0\].g_col\[0\].pe__2676_/A hold1763/X VGND
+ VGND VPWR VPWR g_row\[0\].g_col\[0\].pe__2655_/X sky130_fd_sc_hd__or2_2
Xg_row\[0\].g_col\[1\].pe__1622_ g_row\[0\].g_col\[1\].pe__1622_/A g_row\[0\].g_col\[1\].pe__1875_/C
+ VGND VGND VPWR VPWR g_row\[0\].g_col\[1\].pe__1625_/A sky130_fd_sc_hd__xnor2_2
Xg_row\[0\].g_col\[0\].pe__1606_ g_row\[0\].g_col\[0\].pe__1606_/A g_row\[0\].g_col\[0\].pe__1848_/B
+ VGND VGND VPWR VPWR g_row\[0\].g_col\[0\].pe__1849_/B sky130_fd_sc_hd__xnor2_2
Xg_row\[0\].g_col\[0\].pe__2586_ g_row\[0\].g_col\[0\].pe__2590_/A g_row\[0\].g_col\[0\].pe__2586_/B
+ g_row\[0\].g_col\[0\].pe__2586_/C VGND VGND VPWR VPWR g_row\[0\].g_col\[0\].pe__2586_/X
+ sky130_fd_sc_hd__or3_2
XFILLER_24_49 VGND VGND VPWR VPWR sky130_fd_sc_hd__fill_2
Xg_row\[0\].g_col\[0\].pe__1537_ g_row\[0\].g_col\[0\].pe__1499_/A g_row\[0\].g_col\[0\].pe__1499_/B
+ g_row\[0\].g_col\[0\].pe__1536_/X VGND VGND VPWR VPWR g_row\[0\].g_col\[0\].pe__1545_/A
+ sky130_fd_sc_hd__a21oi_2
Xg_row\[0\].g_col\[1\].pe__1553_ g_row\[0\].g_col\[1\].pe__2736_/Q g_row\[0\].g_col\[1\].pe__1535_/B
+ g_row\[0\].g_col\[1\].pe__1546_/B g_row\[0\].g_col\[1\].pe__1552_/X VGND VGND VPWR
+ VPWR g_row\[0\].g_col\[1\].pe__1591_/A sky130_fd_sc_hd__a31oi_2
XFILLER_11_729 VGND VGND VPWR VPWR sky130_fd_sc_hd__decap_3
Xg_row\[0\].g_col\[1\].pe__1484_ g_row\[0\].g_col\[1\].pe__1728_/A g_row\[0\].g_col\[1\].pe__1484_/B
+ VGND VGND VPWR VPWR g_row\[0\].g_col\[1\].pe__1514_/A sky130_fd_sc_hd__xnor2_2
Xg_row\[1\].g_col\[1\].pe__2027_ g_row\[1\].g_col\[1\].pe__1449_/A g_row\[1\].g_col\[1\].pe__1449_/B
+ g_row\[1\].g_col\[1\].pe__1922_/Y VGND VGND VPWR VPWR g_row\[1\].g_col\[1\].pe__2028_/C
+ sky130_fd_sc_hd__a21o_2
Xg_row\[0\].g_col\[0\].pe__1399_ g_row\[0\].g_col\[0\].pe__1399_/A1 g_row\[0\].g_col\[0\].pe__1399_/A2
+ g_row\[0\].g_col\[0\].pe__1398_/X g_row\[0\].g_col\[0\].pe__2633_/B1 VGND VGND VPWR
+ VPWR g_row\[0\].g_col\[0\].pe__1399_/X sky130_fd_sc_hd__o211a_2
Xg_row\[0\].g_col\[1\].pe__2105_ g_row\[0\].g_col\[1\].pe__2104_/A g_row\[0\].g_col\[1\].pe__2104_/B
+ g_row\[0\].g_col\[1\].pe__2104_/C VGND VGND VPWR VPWR g_row\[0\].g_col\[1\].pe__2105_/X
+ sky130_fd_sc_hd__a21o_2
Xg_row\[0\].g_col\[1\].pe__2036_ g_row\[0\].g_col\[1\].pe__2621_/B g_row\[0\].g_col\[1\].pe__1471_/X
+ g_row\[0\].g_col\[1\].pe__1474_/Y g_row\[0\].g_col\[1\].pe__2036_/B2 VGND VGND VPWR
+ VPWR g_row\[0\].g_col\[1\].pe__2037_/B sky130_fd_sc_hd__a22o_2
XFILLER_49_57 VGND VGND VPWR VPWR sky130_fd_sc_hd__fill_1
XFILLER_77_239 VGND VGND VPWR VPWR sky130_fd_sc_hd__fill_1
XFILLER_58_475 VGND VGND VPWR VPWR sky130_fd_sc_hd__fill_1
XTAP_TAPCELL_ROW_5_287 VGND VPWR sky130_fd_sc_hd__tapvpwrvgnd_1
XFILLER_45_136 VGND VGND VPWR VPWR sky130_fd_sc_hd__decap_3
XFILLER_73_434 VGND VGND VPWR VPWR sky130_fd_sc_hd__fill_2
XANTENNA_102 b_inputs_flat[9] VGND VGND VPWR VPWR sky130_fd_sc_hd__diode_2
XANTENNA_113 hold3287/A VGND VGND VPWR VPWR sky130_fd_sc_hd__diode_2
XANTENNA_124 hold3535/X VGND VGND VPWR VPWR sky130_fd_sc_hd__diode_2
XFILLER_45_169 VGND VGND VPWR VPWR sky130_fd_sc_hd__fill_2
Xg_row\[0\].g_col\[1\].pe_hold2952 g_row\[0\].g_col\[1\].pe__2723_/Q VGND VGND VPWR
+ VPWR g_row\[0\].g_col\[1\].pe__1340_/A sky130_fd_sc_hd__clkbuf_2
Xg_row\[0\].g_col\[1\].pe_hold2941 g_row\[0\].g_col\[1\].pe__2398_/A VGND VGND VPWR
+ VPWR g_row\[0\].g_col\[1\].pe__2679_/A1 sky130_fd_sc_hd__clkbuf_2
XANTENNA_135 b_inputs_flat[21] VGND VGND VPWR VPWR sky130_fd_sc_hd__diode_2
XANTENNA_146 ANTENNA_146/DIODE VGND VGND VPWR VPWR sky130_fd_sc_hd__diode_2
XANTENNA_157 hold3196/A VGND VGND VPWR VPWR sky130_fd_sc_hd__diode_2
Xg_row\[0\].g_col\[0\].pe_hold2107 g_row\[0\].g_col\[0\].pe__2581_/X VGND VGND VPWR
+ VPWR g_row\[0\].g_col\[0\].pe__2582_/B sky130_fd_sc_hd__clkbuf_2
XANTENNA_168 hold3586/A VGND VGND VPWR VPWR sky130_fd_sc_hd__diode_2
XANTENNA_179 ANTENNA_179/DIODE VGND VGND VPWR VPWR sky130_fd_sc_hd__diode_2
XFILLER_41_331 VGND VGND VPWR VPWR sky130_fd_sc_hd__fill_1
XFILLER_41_386 VGND VGND VPWR VPWR sky130_fd_sc_hd__decap_3
XTAP_TAPCELL_ROW_24_573 VGND VPWR sky130_fd_sc_hd__tapvpwrvgnd_1
X_284_ _291_/CLK _284_/D VGND VGND VPWR VPWR _284_/Q sky130_fd_sc_hd__dfxtp_2
XFILLER_14_93 VGND VGND VPWR VPWR sky130_fd_sc_hd__decap_3
Xg_row\[1\].g_col\[1\].pe_hold2172 g_row\[1\].g_col\[1\].pe__2683_/X VGND VGND VPWR
+ VPWR g_row\[1\].g_col\[1\].pe__2724_/D sky130_fd_sc_hd__clkbuf_2
Xg_row\[1\].g_col\[0\].pe__2500_ g_row\[1\].g_col\[0\].pe__2464_/X g_row\[1\].g_col\[0\].pe__2538_/B
+ VGND VGND VPWR VPWR g_row\[1\].g_col\[0\].pe__2533_/B sky130_fd_sc_hd__and2b_2
XFILLER_69_729 VGND VGND VPWR VPWR sky130_fd_sc_hd__decap_3
Xg_row\[1\].g_col\[1\].pe_hold2194 g_row\[1\].g_col\[1\].pe__2651_/X VGND VGND VPWR
+ VPWR g_row\[1\].g_col\[1\].pe__2652_/C1 sky130_fd_sc_hd__clkbuf_2
Xg_row\[1\].g_col\[0\].pe__2431_ g_row\[1\].g_col\[0\].pe__2476_/B g_row\[1\].g_col\[0\].pe__2767_/Q
+ VGND VGND VPWR VPWR g_row\[1\].g_col\[0\].pe__2579_/B sky130_fd_sc_hd__or2b_2
XFILLER_37_615 VGND VGND VPWR VPWR sky130_fd_sc_hd__fill_1
XFILLER_37_648 VGND VGND VPWR VPWR sky130_fd_sc_hd__decap_3
XFILLER_76_272 VGND VGND VPWR VPWR sky130_fd_sc_hd__fill_1
XTAP_TAPCELL_ROW_69_1246 VGND VPWR sky130_fd_sc_hd__tapvpwrvgnd_1
Xg_row\[1\].g_col\[0\].pe__2293_ g_row\[1\].g_col\[0\].pe__2295_/A g_row\[1\].g_col\[0\].pe__2295_/B
+ g_row\[1\].g_col\[0\].pe__2292_/X VGND VGND VPWR VPWR g_row\[1\].g_col\[0\].pe__2294_/A
+ sky130_fd_sc_hd__o21ba_2
XFILLER_92_776 VGND VGND VPWR VPWR sky130_fd_sc_hd__fill_2
XFILLER_45_670 VGND VGND VPWR VPWR sky130_fd_sc_hd__fill_2
XFILLER_45_681 VGND VGND VPWR VPWR sky130_fd_sc_hd__fill_2
XFILLER_52_629 VGND VGND VPWR VPWR sky130_fd_sc_hd__decap_3
Xg_row\[0\].g_col\[0\].pe__2440_ g_row\[0\].g_col\[0\].pe__2763_/Q g_row\[0\].g_col\[0\].pe__2439_/Y
+ VGND VGND VPWR VPWR g_row\[0\].g_col\[0\].pe__2495_/A sky130_fd_sc_hd__or2b_2
XTAP_TAPCELL_ROW_82_1435 VGND VPWR sky130_fd_sc_hd__tapvpwrvgnd_1
XTAP_TAPCELL_ROW_82_1446 VGND VPWR sky130_fd_sc_hd__tapvpwrvgnd_1
Xg_row\[0\].g_col\[0\].pe__2371_ g_row\[0\].g_col\[0\].pe__2347_/A g_row\[0\].g_col\[0\].pe__2346_/B
+ g_row\[0\].g_col\[0\].pe__2346_/A VGND VGND VPWR VPWR g_row\[0\].g_col\[0\].pe__2386_/A
+ sky130_fd_sc_hd__a21boi_2
XTAP_TAPCELL_ROW_43_860 VGND VPWR sky130_fd_sc_hd__tapvpwrvgnd_1
Xg_row\[0\].g_col\[0\].pe_hold1995 g_row\[0\].g_col\[0\].pe_hold2265/X VGND VGND VPWR
+ VPWR g_row\[0\].g_col\[0\].pe__2594_/A1 sky130_fd_sc_hd__clkbuf_2
XFILLER_10_29 VGND VGND VPWR VPWR sky130_fd_sc_hd__fill_1
Xg_row\[1\].g_col\[1\].pe__2714_ _327_/CLK g_row\[1\].g_col\[1\].pe__2714_/D VGND
+ VGND VPWR VPWR g_row\[1\].g_col\[1\].pe__2714_/Q sky130_fd_sc_hd__dfxtp_2
XFILLER_87_526 VGND VGND VPWR VPWR sky130_fd_sc_hd__fill_2
Xg_row\[1\].g_col\[1\].pe__2645_ place1239/X g_row\[1\].g_col\[1\].pe__2645_/B VGND
+ VGND VPWR VPWR g_row\[1\].g_col\[1\].pe__2645_/X sky130_fd_sc_hd__or2_2
Xg_row\[1\].g_col\[1\].pe__2576_ g_row\[1\].g_col\[1\].pe__2576_/A1 g_row\[1\].g_col\[1\].pe__2591_/A2
+ g_row\[1\].g_col\[1\].pe__2591_/B1 g_row\[1\].g_col\[1\].pe__2575_/X VGND VGND VPWR
+ VPWR g_row\[1\].g_col\[1\].pe__2576_/X sky130_fd_sc_hd__a22o_2
XTAP_TAPCELL_ROW_2_235 VGND VPWR sky130_fd_sc_hd__tapvpwrvgnd_1
XTAP_TAPCELL_ROW_2_246 VGND VPWR sky130_fd_sc_hd__tapvpwrvgnd_1
Xg_row\[1\].g_col\[1\].pe__1527_ g_row\[1\].g_col\[1\].pe__2073_/B2 g_row\[1\].g_col\[1\].pe__1715_/B
+ g_row\[1\].g_col\[1\].pe__1863_/B1 g_row\[1\].g_col\[1\].pe__2019_/B2 VGND VGND
+ VPWR VPWR g_row\[1\].g_col\[1\].pe__1528_/B sky130_fd_sc_hd__a22o_2
Xg_row\[0\].g_col\[1\].pe_hold2215 g_row\[0\].g_col\[1\].pe__2611_/X VGND VGND VPWR
+ VPWR g_row\[0\].g_col\[1\].pe__2694_/D sky130_fd_sc_hd__clkbuf_2
Xg_row\[0\].g_col\[1\].pe_hold2204 g_row\[0\].g_col\[1\].pe__2619_/X VGND VGND VPWR
+ VPWR g_row\[0\].g_col\[1\].pe__2698_/D sky130_fd_sc_hd__clkbuf_2
Xg_row\[0\].g_col\[1\].pe__2723_ clkload10/A g_row\[0\].g_col\[1\].pe__2723_/D VGND
+ VGND VPWR VPWR g_row\[0\].g_col\[1\].pe__2723_/Q sky130_fd_sc_hd__dfxtp_2
XFILLER_55_467 VGND VGND VPWR VPWR sky130_fd_sc_hd__decap_3
XFILLER_83_776 VGND VGND VPWR VPWR sky130_fd_sc_hd__fill_1
Xg_row\[0\].g_col\[0\].pe__2707_ clkbuf_leaf_40_clk/X g_row\[0\].g_col\[0\].pe__2707_/D
+ VGND VGND VPWR VPWR hold3060/A sky130_fd_sc_hd__dfxtp_2
Xg_row\[0\].g_col\[0\].pe__2638_ g_row\[0\].g_col\[0\].pe__2635_/X g_row\[0\].g_col\[0\].pe__2636_/X
+ g_row\[0\].g_col\[0\].pe__2637_/X g_row\[0\].g_col\[0\].pe__2638_/B1 VGND VGND VPWR
+ VPWR g_row\[0\].g_col\[0\].pe__2638_/X sky130_fd_sc_hd__o31a_2
Xg_row\[0\].g_col\[1\].pe__2654_ g_row\[0\].g_col\[1\].pe__2666_/A1 g_row\[0\].g_col\[1\].pe__2654_/A2
+ g_row\[0\].g_col\[1\].pe__2677_/B1 g_row\[0\].g_col\[1\].pe__2653_/X VGND VGND VPWR
+ VPWR g_row\[0\].g_col\[1\].pe__2654_/X sky130_fd_sc_hd__o211a_2
Xg_row\[0\].g_col\[1\].pe__1605_ g_row\[0\].g_col\[1\].pe__1860_/A g_row\[0\].g_col\[1\].pe__1605_/B
+ VGND VGND VPWR VPWR g_row\[0\].g_col\[1\].pe__1848_/B sky130_fd_sc_hd__and2_2
Xg_row\[1\].g_col\[1\].pe__1389_ hold2097/X g_row\[1\].g_col\[1\].pe__1402_/B VGND
+ VGND VPWR VPWR g_row\[1\].g_col\[1\].pe__1389_/X sky130_fd_sc_hd__or2_2
Xg_row\[0\].g_col\[1\].pe__2585_ g_row\[0\].g_col\[1\].pe__2585_/A g_row\[0\].g_col\[1\].pe__2585_/B
+ VGND VGND VPWR VPWR g_row\[0\].g_col\[1\].pe__2586_/C sky130_fd_sc_hd__and2_2
XTAP_TAPCELL_ROW_41_819 VGND VPWR sky130_fd_sc_hd__tapvpwrvgnd_1
Xg_row\[0\].g_col\[0\].pe__2569_ g_row\[0\].g_col\[0\].pe__2592_/A g_row\[0\].g_col\[0\].pe__2569_/B
+ VGND VGND VPWR VPWR g_row\[0\].g_col\[0\].pe__2765_/D sky130_fd_sc_hd__and2_2
Xg_row\[0\].g_col\[1\].pe__1536_ g_row\[0\].g_col\[1\].pe__1536_/A g_row\[0\].g_col\[1\].pe__1536_/B
+ VGND VGND VPWR VPWR g_row\[0\].g_col\[1\].pe__1536_/X sky130_fd_sc_hd__and2_2
XTAP_TAPCELL_ROW_21_521 VGND VPWR sky130_fd_sc_hd__tapvpwrvgnd_1
XTAP_TAPCELL_ROW_21_532 VGND VPWR sky130_fd_sc_hd__tapvpwrvgnd_1
Xg_row\[0\].g_col\[1\].pe__1398_ g_row\[0\].g_col\[1\].pe__2672_/B g_row\[0\].g_col\[1\].pe__1402_/B
+ VGND VGND VPWR VPWR g_row\[0\].g_col\[1\].pe__1398_/X sky130_fd_sc_hd__or2_2
XFILLER_3_703 VGND VGND VPWR VPWR sky130_fd_sc_hd__fill_1
Xg_row\[0\].g_col\[0\].pe_place977 g_row\[0\].g_col\[0\].pe__1602_/A VGND VGND VPWR
+ VPWR g_row\[0\].g_col\[0\].pe__2364_/A sky130_fd_sc_hd__buf_6
Xg_row\[0\].g_col\[0\].pe_place988 g_row\[0\].g_col\[0\].pe__1416_/X VGND VGND VPWR
+ VPWR g_row\[0\].g_col\[0\].pe__1784_/B1 sky130_fd_sc_hd__buf_6
XTAP_TAPCELL_ROW_53_1003 VGND VPWR sky130_fd_sc_hd__tapvpwrvgnd_1
Xg_row\[0\].g_col\[0\].pe_place999 g_row\[0\].g_col\[0\].pe__2686_/B VGND VGND VPWR
+ VPWR g_row\[0\].g_col\[0\].pe__1399_/A2 sky130_fd_sc_hd__buf_6
XFILLER_78_537 VGND VGND VPWR VPWR sky130_fd_sc_hd__decap_3
Xg_row\[0\].g_col\[1\].pe__2019_ g_row\[0\].g_col\[1\].pe__2073_/B2 g_row\[0\].g_col\[1\].pe__2177_/A2
+ g_row\[0\].g_col\[1\].pe__2215_/B1 g_row\[0\].g_col\[1\].pe__2019_/B2 VGND VGND
+ VPWR VPWR g_row\[0\].g_col\[1\].pe__2071_/A sky130_fd_sc_hd__a22o_2
XFILLER_78_548 VGND VGND VPWR VPWR sky130_fd_sc_hd__decap_3
XFILLER_19_615 VGND VGND VPWR VPWR sky130_fd_sc_hd__fill_1
XFILLER_93_529 VGND VGND VPWR VPWR sky130_fd_sc_hd__decap_3
XFILLER_18_125 VGND VGND VPWR VPWR sky130_fd_sc_hd__decap_3
XFILLER_19_637 VGND VGND VPWR VPWR sky130_fd_sc_hd__fill_1
XFILLER_74_754 VGND VGND VPWR VPWR sky130_fd_sc_hd__fill_2
XTAP_TAPCELL_ROW_29_643 VGND VPWR sky130_fd_sc_hd__tapvpwrvgnd_1
XFILLER_18_169 VGND VGND VPWR VPWR sky130_fd_sc_hd__decap_3
XFILLER_46_489 VGND VGND VPWR VPWR sky130_fd_sc_hd__decap_3
XFILLER_30_813 VGND VGND VPWR VPWR sky130_fd_sc_hd__fill_2
XTAP_TAPCELL_ROW_64_1165 VGND VPWR sky130_fd_sc_hd__tapvpwrvgnd_1
XTAP_TAPCELL_ROW_64_1176 VGND VPWR sky130_fd_sc_hd__tapvpwrvgnd_1
X_336_ _336_/CLK _336_/D VGND VGND VPWR VPWR _336_/Q sky130_fd_sc_hd__dfxtp_2
X_267_ _267_/A _267_/B_N VGND VGND VPWR VPWR _267_/Y sky130_fd_sc_hd__nor2b_4
Xg_row\[1\].g_col\[0\].pe__1931_ g_row\[1\].g_col\[0\].pe__1931_/A g_row\[1\].g_col\[0\].pe__1931_/B
+ VGND VGND VPWR VPWR g_row\[1\].g_col\[0\].pe__1999_/A sky130_fd_sc_hd__xnor2_2
Xg_row\[1\].g_col\[0\].pe__1862_ g_row\[1\].g_col\[0\].pe__1910_/A g_row\[1\].g_col\[0\].pe__1862_/B
+ VGND VGND VPWR VPWR g_row\[1\].g_col\[0\].pe__1899_/A sky130_fd_sc_hd__xor2_2
Xg_row\[1\].g_col\[0\].pe__1793_ g_row\[1\].g_col\[0\].pe__1793_/A g_row\[1\].g_col\[0\].pe__1793_/B
+ g_row\[1\].g_col\[0\].pe__1793_/C VGND VGND VPWR VPWR g_row\[1\].g_col\[0\].pe__1794_/B
+ sky130_fd_sc_hd__and3_2
Xg_row\[0\].g_col\[0\].pe__1940_ g_row\[0\].g_col\[0\].pe__1941_/A g_row\[0\].g_col\[0\].pe__1941_/B
+ g_row\[0\].g_col\[0\].pe__1941_/C VGND VGND VPWR VPWR g_row\[0\].g_col\[0\].pe__2005_/A
+ sky130_fd_sc_hd__a21oi_2
Xg_row\[1\].g_col\[1\].pe__2430_ g_row\[1\].g_col\[1\].pe__2430_/A g_row\[1\].g_col\[1\].pe__2430_/B
+ VGND VGND VPWR VPWR g_row\[1\].g_col\[1\].pe__2476_/B sky130_fd_sc_hd__xnor2_2
XFILLER_84_518 VGND VGND VPWR VPWR sky130_fd_sc_hd__fill_1
Xg_row\[0\].g_col\[0\].pe__1871_ g_row\[0\].g_col\[0\].pe__2045_/B g_row\[0\].g_col\[0\].pe__1928_/B
+ VGND VGND VPWR VPWR g_row\[0\].g_col\[0\].pe__1874_/A sky130_fd_sc_hd__xor2_2
Xg_row\[1\].g_col\[0\].pe__2414_ g_row\[1\].g_col\[0\].pe__2754_/Q g_row\[1\].g_col\[0\].pe__2116_/Y
+ g_row\[1\].g_col\[0\].pe__2441_/B VGND VGND VPWR VPWR g_row\[1\].g_col\[0\].pe__2439_/B
+ sky130_fd_sc_hd__o21ai_2
XFILLER_2_63 VGND VGND VPWR VPWR sky130_fd_sc_hd__fill_1
XFILLER_37_423 VGND VGND VPWR VPWR sky130_fd_sc_hd__fill_1
XFILLER_49_261 VGND VGND VPWR VPWR sky130_fd_sc_hd__decap_3
XTAP_TAPCELL_ROW_48_930 VGND VPWR sky130_fd_sc_hd__tapvpwrvgnd_1
Xg_row\[1\].g_col\[1\].pe__2361_ g_row\[1\].g_col\[1\].pe__2396_/A g_row\[1\].g_col\[1\].pe__2361_/B
+ VGND VGND VPWR VPWR g_row\[1\].g_col\[1\].pe__2751_/D sky130_fd_sc_hd__nor2_2
Xg_row\[1\].g_col\[0\].pe__2345_ g_row\[1\].g_col\[0\].pe__2368_/A g_row\[1\].g_col\[0\].pe__2345_/B
+ VGND VGND VPWR VPWR g_row\[1\].g_col\[0\].pe__2346_/B sky130_fd_sc_hd__or2_2
Xg_row\[1\].g_col\[1\].pe__2292_ g_row\[1\].g_col\[1\].pe__2292_/A g_row\[1\].g_col\[1\].pe__2327_/B
+ VGND VGND VPWR VPWR g_row\[1\].g_col\[1\].pe__2292_/X sky130_fd_sc_hd__or2_2
XFILLER_25_629 VGND VGND VPWR VPWR sky130_fd_sc_hd__fill_1
XFILLER_80_735 VGND VGND VPWR VPWR sky130_fd_sc_hd__decap_3
Xg_row\[1\].g_col\[0\].pe__2276_ g_row\[1\].g_col\[0\].pe__2318_/A g_row\[1\].g_col\[0\].pe__2276_/B
+ VGND VGND VPWR VPWR g_row\[1\].g_col\[0\].pe__2286_/A sky130_fd_sc_hd__and2b_2
XFILLER_52_459 VGND VGND VPWR VPWR sky130_fd_sc_hd__decap_3
XFILLER_80_757 VGND VGND VPWR VPWR sky130_fd_sc_hd__fill_1
XFILLER_33_673 VGND VGND VPWR VPWR sky130_fd_sc_hd__fill_1
Xg_row\[0\].g_col\[0\].pe__2423_ g_row\[0\].g_col\[0\].pe__2424_/A g_row\[0\].g_col\[0\].pe__2424_/B
+ VGND VGND VPWR VPWR g_row\[0\].g_col\[0\].pe__2425_/A sky130_fd_sc_hd__nor2_2
Xg_row\[1\].g_col\[0\].pe_place1258 g_row\[1\].g_col\[0\].pe__2669_/A VGND VGND VPWR
+ VPWR g_row\[1\].g_col\[0\].pe__2676_/A sky130_fd_sc_hd__buf_6
XANTENNA_13 a_inputs_flat[22] VGND VGND VPWR VPWR sky130_fd_sc_hd__diode_2
XFILLER_21_835 VGND VGND VPWR VPWR sky130_fd_sc_hd__fill_1
XFILLER_60_470 VGND VGND VPWR VPWR sky130_fd_sc_hd__decap_3
Xg_row\[0\].g_col\[0\].pe__2354_ g_row\[0\].g_col\[0\].pe__2355_/A g_row\[0\].g_col\[0\].pe__2355_/B
+ VGND VGND VPWR VPWR g_row\[0\].g_col\[0\].pe__2356_/A sky130_fd_sc_hd__and2_2
Xg_row\[0\].g_col\[1\].pe__2370_ g_row\[0\].g_col\[1\].pe__2387_/A g_row\[0\].g_col\[1\].pe__2370_/B
+ VGND VGND VPWR VPWR g_row\[0\].g_col\[1\].pe__2372_/A sky130_fd_sc_hd__and2_2
XANTENNA_24 b_inputs_flat[28] VGND VGND VPWR VPWR sky130_fd_sc_hd__diode_2
XANTENNA_35 _267_/Y VGND VGND VPWR VPWR sky130_fd_sc_hd__diode_2
XANTENNA_46 a_inputs_flat[31] VGND VGND VPWR VPWR sky130_fd_sc_hd__diode_2
XANTENNA_57 hold3138/A VGND VGND VPWR VPWR sky130_fd_sc_hd__diode_2
Xg_row\[0\].g_col\[0\].pe__2285_ g_row\[0\].g_col\[0\].pe__2285_/A g_row\[0\].g_col\[0\].pe__2285_/B
+ VGND VGND VPWR VPWR g_row\[0\].g_col\[0\].pe__2310_/B sky130_fd_sc_hd__xnor2_2
XANTENNA_68 hold3387/A VGND VGND VPWR VPWR sky130_fd_sc_hd__diode_2
XANTENNA_79 hold3213/X VGND VGND VPWR VPWR sky130_fd_sc_hd__diode_2
XTAP_TAPCELL_ROW_7_316 VGND VPWR sky130_fd_sc_hd__tapvpwrvgnd_1
Xg_row\[1\].g_col\[1\].pe__2628_ g_row\[1\].g_col\[1\].pe__1950_/A hold1795/X g_row\[1\].g_col\[1\].pe__2640_/C1
+ g_row\[1\].g_col\[1\].pe__2627_/X VGND VGND VPWR VPWR g_row\[1\].g_col\[1\].pe__2628_/X
+ sky130_fd_sc_hd__o211a_2
Xg_row\[1\].g_col\[1\].pe__2559_ g_row\[1\].g_col\[1\].pe__2559_/A g_row\[1\].g_col\[1\].pe__2559_/B
+ VGND VGND VPWR VPWR g_row\[1\].g_col\[1\].pe__2559_/X sky130_fd_sc_hd__or2_2
XFILLER_55_231 VGND VGND VPWR VPWR sky130_fd_sc_hd__decap_3
Xg_row\[0\].g_col\[1\].pe_hold2034 g_row\[0\].g_col\[1\].pe__2581_/X VGND VGND VPWR
+ VPWR g_row\[0\].g_col\[1\].pe__2582_/B sky130_fd_sc_hd__clkbuf_2
XFILLER_55_275 VGND VGND VPWR VPWR sky130_fd_sc_hd__decap_3
XFILLER_71_724 VGND VGND VPWR VPWR sky130_fd_sc_hd__decap_3
XFILLER_83_595 VGND VGND VPWR VPWR sky130_fd_sc_hd__decap_3
XTAP_TAPCELL_ROW_26_602 VGND VPWR sky130_fd_sc_hd__tapvpwrvgnd_1
Xg_row\[0\].g_col\[1\].pe__2706_ clkbuf_leaf_94_clk/X g_row\[0\].g_col\[1\].pe__2706_/D
+ VGND VGND VPWR VPWR hold2185/A sky130_fd_sc_hd__dfxtp_2
Xg_row\[0\].g_col\[1\].pe__2637_ place1212/X place1213/X place1207/X place1209/X VGND
+ VGND VPWR VPWR g_row\[0\].g_col\[1\].pe__2637_/X sky130_fd_sc_hd__or4_2
XFILLER_23_172 VGND VGND VPWR VPWR sky130_fd_sc_hd__decap_3
XFILLER_51_481 VGND VGND VPWR VPWR sky130_fd_sc_hd__decap_3
Xg_row\[0\].g_col\[1\].pe__2568_ g_row\[0\].g_col\[1\].pe__2568_/A1 g_row\[0\].g_col\[1\].pe__2587_/A2
+ g_row\[0\].g_col\[1\].pe__2517_/Y g_row\[0\].g_col\[1\].pe__2567_/X VGND VGND VPWR
+ VPWR g_row\[0\].g_col\[1\].pe__2568_/X sky130_fd_sc_hd__a22o_2
Xg_row\[0\].g_col\[1\].pe__1519_ g_row\[0\].g_col\[1\].pe__1707_/A g_row\[0\].g_col\[1\].pe__1519_/B
+ VGND VGND VPWR VPWR g_row\[0\].g_col\[1\].pe__1580_/B sky130_fd_sc_hd__xor2_2
Xg_row\[0\].g_col\[1\].pe_place1235 g_row\[0\].g_col\[1\].pe__2669_/A VGND VGND VPWR
+ VPWR g_row\[0\].g_col\[1\].pe__2661_/A sky130_fd_sc_hd__buf_6
Xg_row\[0\].g_col\[1\].pe__2499_ g_row\[0\].g_col\[1\].pe__2499_/A g_row\[0\].g_col\[1\].pe__2499_/B
+ VGND VGND VPWR VPWR g_row\[0\].g_col\[1\].pe__2501_/C sky130_fd_sc_hd__nor2_2
Xg_row\[0\].g_col\[1\].pe_place1279 _199_/A VGND VGND VPWR VPWR g_row\[0\].g_col\[1\].pe__2405_/A
+ sky130_fd_sc_hd__buf_6
XFILLER_79_802 VGND VGND VPWR VPWR sky130_fd_sc_hd__fill_1
XFILLER_3_599 VGND VGND VPWR VPWR sky130_fd_sc_hd__decap_3
XFILLER_87_98 VGND VGND VPWR VPWR sky130_fd_sc_hd__fill_1
Xg_row\[1\].g_col\[0\].pe_hold1918 g_row\[1\].g_col\[0\].pe__2744_/Q VGND VGND VPWR
+ VPWR g_row\[1\].g_col\[0\].pe__2065_/A sky130_fd_sc_hd__clkbuf_2
XFILLER_66_529 VGND VGND VPWR VPWR sky130_fd_sc_hd__decap_3
XFILLER_19_434 VGND VGND VPWR VPWR sky130_fd_sc_hd__fill_1
XFILLER_47_743 VGND VGND VPWR VPWR sky130_fd_sc_hd__fill_2
XFILLER_47_765 VGND VGND VPWR VPWR sky130_fd_sc_hd__fill_2
Xg_row\[1\].g_col\[0\].pe__2130_ g_row\[1\].g_col\[0\].pe__2030_/A g_row\[1\].g_col\[0\].pe__1471_/X
+ g_row\[1\].g_col\[0\].pe__1474_/Y place1086/X VGND VGND VPWR VPWR g_row\[1\].g_col\[0\].pe__2131_/B
+ sky130_fd_sc_hd__a22o_2
XTAP_TAPCELL_ROW_66_1205 VGND VPWR sky130_fd_sc_hd__tapvpwrvgnd_1
XFILLER_34_426 VGND VGND VPWR VPWR sky130_fd_sc_hd__decap_3
XFILLER_34_448 VGND VGND VPWR VPWR sky130_fd_sc_hd__decap_3
XFILLER_46_286 VGND VGND VPWR VPWR sky130_fd_sc_hd__fill_1
Xg_row\[1\].g_col\[0\].pe__2061_ g_row\[1\].g_col\[0\].pe__2062_/A g_row\[1\].g_col\[0\].pe__2062_/C
+ g_row\[1\].g_col\[0\].pe__2150_/C VGND VGND VPWR VPWR g_row\[1\].g_col\[0\].pe__2061_/Y
+ sky130_fd_sc_hd__o21ai_2
XFILLER_15_673 VGND VGND VPWR VPWR sky130_fd_sc_hd__decap_3
XFILLER_21_109 VGND VGND VPWR VPWR sky130_fd_sc_hd__decap_3
XFILLER_14_150 VGND VGND VPWR VPWR sky130_fd_sc_hd__fill_2
XFILLER_30_643 VGND VGND VPWR VPWR sky130_fd_sc_hd__fill_1
X_319_ _319_/CLK _319_/D VGND VGND VPWR VPWR _319_/Q sky130_fd_sc_hd__dfxtp_2
XTAP_TAPCELL_ROW_12_384 VGND VPWR sky130_fd_sc_hd__tapvpwrvgnd_1
XTAP_TAPCELL_ROW_12_395 VGND VPWR sky130_fd_sc_hd__tapvpwrvgnd_1
Xg_row\[0\].g_col\[0\].pe__2070_ g_row\[0\].g_col\[0\].pe__1961_/A g_row\[0\].g_col\[0\].pe__1961_/B
+ g_row\[0\].g_col\[0\].pe__2024_/B g_row\[0\].g_col\[0\].pe__2023_/B g_row\[0\].g_col\[0\].pe__2023_/A
+ VGND VGND VPWR VPWR g_row\[0\].g_col\[0\].pe__2107_/A sky130_fd_sc_hd__a32o_2
Xg_row\[1\].g_col\[1\].pe__1930_ g_row\[1\].g_col\[1\].pe__1994_/A g_row\[1\].g_col\[1\].pe__1994_/B
+ VGND VGND VPWR VPWR g_row\[1\].g_col\[1\].pe__1931_/B sky130_fd_sc_hd__xor2_2
Xg_row\[1\].g_col\[0\].pe__1914_ g_row\[1\].g_col\[0\].pe__2616_/B g_row\[1\].g_col\[0\].pe__1657_/B
+ g_row\[1\].g_col\[0\].pe__2036_/B1 place1094/X VGND VGND VPWR VPWR g_row\[1\].g_col\[0\].pe__1915_/B
+ sky130_fd_sc_hd__a22o_2
Xg_row\[1\].g_col\[1\].pe__1861_ g_row\[1\].g_col\[1\].pe__2278_/B2 g_row\[1\].g_col\[1\].pe__2026_/B
+ g_row\[1\].g_col\[1\].pe__1449_/Y g_row\[1\].g_col\[1\].pe__2241_/B2 VGND VGND VPWR
+ VPWR g_row\[1\].g_col\[1\].pe__1862_/B sky130_fd_sc_hd__a22o_2
XTAP_TAPCELL_ROW_77_1367 VGND VPWR sky130_fd_sc_hd__tapvpwrvgnd_1
Xg_row\[1\].g_col\[0\].pe__1845_ g_row\[1\].g_col\[0\].pe__1636_/B g_row\[1\].g_col\[0\].pe__1845_/B
+ VGND VGND VPWR VPWR g_row\[1\].g_col\[0\].pe__1888_/A sky130_fd_sc_hd__and2b_2
Xg_row\[1\].g_col\[1\].pe__1792_ g_row\[1\].g_col\[1\].pe__1792_/A VGND VGND VPWR
+ VPWR g_row\[1\].g_col\[1\].pe__1795_/A sky130_fd_sc_hd__inv_2
Xg_row\[1\].g_col\[0\].pe__1776_ g_row\[1\].g_col\[0\].pe__1776_/A g_row\[1\].g_col\[0\].pe__1776_/B
+ VGND VGND VPWR VPWR g_row\[1\].g_col\[0\].pe__1777_/B sky130_fd_sc_hd__xor2_2
XFILLER_69_334 VGND VGND VPWR VPWR sky130_fd_sc_hd__fill_2
XTAP_TAPCELL_ROW_90_1556 VGND VPWR sky130_fd_sc_hd__tapvpwrvgnd_1
XTAP_TAPCELL_ROW_90_1567 VGND VPWR sky130_fd_sc_hd__tapvpwrvgnd_1
Xg_row\[0\].g_col\[0\].pe__1923_ g_row\[0\].g_col\[0\].pe__1424_/A g_row\[0\].g_col\[0\].pe__1424_/B
+ g_row\[0\].g_col\[0\].pe__1922_/Y VGND VGND VPWR VPWR g_row\[0\].g_col\[0\].pe__1924_/C
+ sky130_fd_sc_hd__a21oi_2
Xhold1506 hold2610/X VGND VGND VPWR VPWR hold2611/A sky130_fd_sc_hd__clkbuf_2
Xhold1517 hold3324/X VGND VGND VPWR VPWR hold3325/A sky130_fd_sc_hd__clkbuf_2
Xhold2229 hold2229/A VGND VGND VPWR VPWR hold2229/X sky130_fd_sc_hd__clkbuf_2
Xg_row\[0\].g_col\[0\].pe__1854_ place1214/X g_row\[0\].g_col\[0\].pe__1504_/Y g_row\[0\].g_col\[0\].pe__1541_/X
+ g_row\[0\].g_col\[0\].pe__1957_/B2 VGND VGND VPWR VPWR g_row\[0\].g_col\[0\].pe__1855_/B
+ sky130_fd_sc_hd__a22o_2
Xhold1528 hold3397/X VGND VGND VPWR VPWR hold3398/A sky130_fd_sc_hd__clkbuf_2
Xhold1539 hold2580/X VGND VGND VPWR VPWR hold2581/A sky130_fd_sc_hd__clkbuf_2
Xg_row\[1\].g_col\[1\].pe__2413_ g_row\[1\].g_col\[1\].pe__2450_/A1 g_row\[1\].g_col\[1\].pe__2744_/Q
+ g_row\[1\].g_col\[1\].pe__2445_/B VGND VGND VPWR VPWR g_row\[1\].g_col\[1\].pe__2441_/B
+ sky130_fd_sc_hd__a21oi_2
Xg_row\[0\].g_col\[1\].pe__1870_ g_row\[0\].g_col\[1\].pe__2045_/A g_row\[0\].g_col\[1\].pe__1870_/B
+ VGND VGND VPWR VPWR g_row\[0\].g_col\[1\].pe__1928_/B sky130_fd_sc_hd__xor2_2
XFILLER_38_743 VGND VGND VPWR VPWR sky130_fd_sc_hd__fill_1
Xg_row\[1\].g_col\[1\].pe__2344_ g_row\[1\].g_col\[1\].pe__2368_/A g_row\[1\].g_col\[1\].pe__2345_/B
+ VGND VGND VPWR VPWR g_row\[1\].g_col\[1\].pe__2346_/A sky130_fd_sc_hd__nand2_2
XFILLER_53_702 VGND VGND VPWR VPWR sky130_fd_sc_hd__fill_2
Xg_row\[0\].g_col\[0\].pe__1785_ g_row\[0\].g_col\[0\].pe__1785_/A g_row\[0\].g_col\[0\].pe__1785_/B
+ VGND VGND VPWR VPWR g_row\[0\].g_col\[0\].pe__1796_/B sky130_fd_sc_hd__xor2_2
Xg_row\[1\].g_col\[0\].pe__2328_ g_row\[1\].g_col\[0\].pe__2355_/A g_row\[1\].g_col\[0\].pe__2328_/B
+ VGND VGND VPWR VPWR g_row\[1\].g_col\[0\].pe__2329_/B sky130_fd_sc_hd__or2_2
Xg_row\[1\].g_col\[1\].pe__2275_ g_row\[1\].g_col\[1\].pe__2388_/A g_row\[1\].g_col\[1\].pe__2733_/Q
+ g_row\[1\].g_col\[1\].pe__1673_/A g_row\[1\].g_col\[1\].pe__2368_/A VGND VGND VPWR
+ VPWR g_row\[1\].g_col\[1\].pe__2276_/B sky130_fd_sc_hd__a211o_2
Xg_row\[1\].g_col\[0\].pe__2259_ g_row\[1\].g_col\[0\].pe__2226_/A g_row\[1\].g_col\[0\].pe__2226_/B
+ g_row\[1\].g_col\[0\].pe__2258_/X VGND VGND VPWR VPWR g_row\[1\].g_col\[0\].pe__2330_/B
+ sky130_fd_sc_hd__a21oi_2
XFILLER_25_459 VGND VGND VPWR VPWR sky130_fd_sc_hd__decap_3
XFILLER_52_256 VGND VGND VPWR VPWR sky130_fd_sc_hd__decap_3
XFILLER_80_587 VGND VGND VPWR VPWR sky130_fd_sc_hd__fill_1
Xg_row\[0\].g_col\[0\].pe__2406_ g_row\[0\].g_col\[0\].pe__2594_/A1 _275_/Q place1263/X
+ VGND VGND VPWR VPWR g_row\[0\].g_col\[0\].pe__2406_/Y sky130_fd_sc_hd__o21ai_2
Xg_row\[1\].g_col\[0\].pe_place1077 g_row\[1\].g_col\[0\].pe__2163_/A VGND VGND VPWR
+ VPWR g_row\[1\].g_col\[0\].pe__2388_/A sky130_fd_sc_hd__buf_6
Xg_row\[1\].g_col\[0\].pe_place1066 g_row\[1\].g_col\[0\].pe__2730_/Q VGND VGND VPWR
+ VPWR g_row\[1\].g_col\[0\].pe__1460_/B sky130_fd_sc_hd__buf_6
Xg_row\[0\].g_col\[1\].pe__2422_ g_row\[0\].g_col\[1\].pe__2422_/A g_row\[0\].g_col\[1\].pe__2484_/A
+ VGND VGND VPWR VPWR g_row\[0\].g_col\[1\].pe__2424_/B sky130_fd_sc_hd__xnor2_2
XFILLER_20_131 VGND VGND VPWR VPWR sky130_fd_sc_hd__decap_3
XTAP_TAPCELL_ROW_51_969 VGND VPWR sky130_fd_sc_hd__tapvpwrvgnd_1
Xg_row\[1\].g_col\[0\].pe_place1088 hold3129/A VGND VGND VPWR VPWR g_row\[1\].g_col\[0\].pe__2241_/B2
+ sky130_fd_sc_hd__buf_6
Xg_row\[0\].g_col\[1\].pe__2353_ g_row\[0\].g_col\[1\].pe__2375_/A g_row\[0\].g_col\[1\].pe__2353_/B
+ VGND VGND VPWR VPWR g_row\[0\].g_col\[1\].pe__2355_/B sky130_fd_sc_hd__nor2_2
XTAP_TAPCELL_ROW_31_671 VGND VPWR sky130_fd_sc_hd__tapvpwrvgnd_1
Xg_row\[0\].g_col\[0\].pe__2337_ g_row\[0\].g_col\[0\].pe__2337_/A g_row\[0\].g_col\[0\].pe__2337_/B
+ g_row\[0\].g_col\[0\].pe__2337_/C VGND VGND VPWR VPWR g_row\[0\].g_col\[0\].pe__2352_/A
+ sky130_fd_sc_hd__or3_2
Xg_row\[0\].g_col\[0\].pe_hold2290 _314_/Q VGND VGND VPWR VPWR g_row\[0\].g_col\[0\].pe_hold2290/X
+ sky130_fd_sc_hd__clkbuf_2
Xg_row\[0\].g_col\[1\].pe_place860 g_row\[0\].g_col\[1\].pe__1461_/Y VGND VGND VPWR
+ VPWR g_row\[0\].g_col\[1\].pe__1863_/B1 sky130_fd_sc_hd__buf_6
XFILLER_5_809 VGND VGND VPWR VPWR sky130_fd_sc_hd__fill_2
XTAP_TAPCELL_ROW_31_682 VGND VPWR sky130_fd_sc_hd__tapvpwrvgnd_1
Xg_row\[0\].g_col\[0\].pe__2268_ g_row\[0\].g_col\[0\].pe__2335_/A g_row\[0\].g_col\[0\].pe__2268_/B
+ VGND VGND VPWR VPWR g_row\[0\].g_col\[0\].pe__2748_/D sky130_fd_sc_hd__nor2_2
Xg_row\[0\].g_col\[1\].pe__2284_ g_row\[0\].g_col\[1\].pe__2284_/A g_row\[0\].g_col\[1\].pe__2284_/B
+ VGND VGND VPWR VPWR g_row\[0\].g_col\[1\].pe__2285_/B sky130_fd_sc_hd__nor2_2
Xg_row\[0\].g_col\[0\].pe__2199_ g_row\[0\].g_col\[0\].pe__2335_/A g_row\[0\].g_col\[0\].pe__2199_/B
+ VGND VGND VPWR VPWR g_row\[0\].g_col\[0\].pe__2746_/D sky130_fd_sc_hd__nor2_2
Xoutput1370 output1370/A VGND VGND VPWR VPWR results_flat[23] sky130_fd_sc_hd__buf_2
Xhold3442 hold3442/A VGND VGND VPWR VPWR hold3442/X sky130_fd_sc_hd__clkbuf_2
Xhold3431 a_inputs_flat[19] VGND VGND VPWR VPWR hold3431/X sky130_fd_sc_hd__clkbuf_2
Xhold3420 hold3420/A VGND VGND VPWR VPWR hold3420/X sky130_fd_sc_hd__clkbuf_2
Xhold2730 _193_/Y VGND VGND VPWR VPWR hold2730/X sky130_fd_sc_hd__clkbuf_2
Xhold2741 hold3507/X VGND VGND VPWR VPWR _139_/B_N sky130_fd_sc_hd__clkbuf_2
Xoutput1392 output1392/A VGND VGND VPWR VPWR results_flat[43] sky130_fd_sc_hd__buf_2
Xoutput1381 output1381/A VGND VGND VPWR VPWR results_flat[33] sky130_fd_sc_hd__buf_2
Xhold3475 hold3475/A VGND VGND VPWR VPWR hold3475/X sky130_fd_sc_hd__clkbuf_2
Xhold3464 hold3464/A VGND VGND VPWR VPWR hold3464/X sky130_fd_sc_hd__clkbuf_2
Xhold3453 hold3453/A VGND VGND VPWR VPWR hold3453/X sky130_fd_sc_hd__clkbuf_2
Xhold2752 hold3512/X VGND VGND VPWR VPWR hold3513/A sky130_fd_sc_hd__clkbuf_2
Xhold2763 hold3537/X VGND VGND VPWR VPWR hold3538/A sky130_fd_sc_hd__clkbuf_2
Xhold2774 hold3553/X VGND VGND VPWR VPWR hold3554/A sky130_fd_sc_hd__clkbuf_2
Xhold3497 hold3497/A VGND VGND VPWR VPWR hold3497/X sky130_fd_sc_hd__clkbuf_2
Xhold3486 hold3486/A VGND VGND VPWR VPWR hold3486/X sky130_fd_sc_hd__clkbuf_2
Xhold2785 hold2785/A VGND VGND VPWR VPWR _290_/D sky130_fd_sc_hd__clkbuf_2
Xhold2796 _199_/Y VGND VGND VPWR VPWR hold2796/X sky130_fd_sc_hd__clkbuf_2
XFILLER_28_242 VGND VGND VPWR VPWR sky130_fd_sc_hd__fill_1
XFILLER_28_253 VGND VGND VPWR VPWR sky130_fd_sc_hd__fill_1
XFILLER_90_307 VGND VGND VPWR VPWR sky130_fd_sc_hd__fill_1
Xg_row\[0\].g_col\[1\].pe__1999_ g_row\[0\].g_col\[1\].pe__1999_/A g_row\[0\].g_col\[1\].pe__1999_/B
+ VGND VGND VPWR VPWR g_row\[0\].g_col\[1\].pe__1999_/X sky130_fd_sc_hd__or2_2
XFILLER_56_595 VGND VGND VPWR VPWR sky130_fd_sc_hd__decap_3
XTAP_TAPCELL_ROW_39_793 VGND VPWR sky130_fd_sc_hd__tapvpwrvgnd_1
XFILLER_71_576 VGND VGND VPWR VPWR sky130_fd_sc_hd__fill_2
XFILLER_73_67 VGND VGND VPWR VPWR sky130_fd_sc_hd__fill_1
XFILLER_12_621 VGND VGND VPWR VPWR sky130_fd_sc_hd__decap_3
XFILLER_31_418 VGND VGND VPWR VPWR sky130_fd_sc_hd__decap_3
XTAP_TAPCELL_ROW_61_1124 VGND VPWR sky130_fd_sc_hd__tapvpwrvgnd_1
Xclkbuf_leaf_100_clk clkbuf_4_2_0_clk/X VGND VGND VPWR VPWR _339_/CLK sky130_fd_sc_hd__clkbuf_16
XTAP_TAPCELL_ROW_59_1097 VGND VPWR sky130_fd_sc_hd__tapvpwrvgnd_1
Xg_row\[1\].g_col\[0\].pe__1630_ g_row\[1\].g_col\[0\].pe__1582_/B g_row\[1\].g_col\[0\].pe__1630_/B
+ VGND VGND VPWR VPWR g_row\[1\].g_col\[0\].pe__1630_/X sky130_fd_sc_hd__and2b_2
XFILLER_79_632 VGND VGND VPWR VPWR sky130_fd_sc_hd__fill_1
Xg_row\[1\].g_col\[0\].pe_hold3117 g_row\[1\].g_col\[0\].pe__2742_/Q VGND VGND VPWR
+ VPWR g_row\[1\].g_col\[0\].pe_hold3117/X sky130_fd_sc_hd__clkbuf_2
Xg_row\[1\].g_col\[0\].pe__1561_ g_row\[1\].g_col\[0\].pe__1562_/A g_row\[1\].g_col\[0\].pe__1562_/B
+ g_row\[1\].g_col\[0\].pe__1562_/C VGND VGND VPWR VPWR g_row\[1\].g_col\[0\].pe__1846_/A
+ sky130_fd_sc_hd__o21a_2
XTAP_TAPCELL_ROW_72_1286 VGND VPWR sky130_fd_sc_hd__tapvpwrvgnd_1
XTAP_TAPCELL_ROW_72_1297 VGND VPWR sky130_fd_sc_hd__tapvpwrvgnd_1
Xg_row\[1\].g_col\[0\].pe_hold1726 g_row\[1\].g_col\[0\].pe__2729_/Q VGND VGND VPWR
+ VPWR g_row\[1\].g_col\[0\].pe__1386_/A1 sky130_fd_sc_hd__clkbuf_2
Xg_row\[1\].g_col\[0\].pe__1492_ place1094/X g_row\[1\].g_col\[0\].pe__1748_/B g_row\[1\].g_col\[0\].pe__1738_/B1
+ hold1950/A VGND VGND VPWR VPWR g_row\[1\].g_col\[0\].pe__1493_/B sky130_fd_sc_hd__a22o_2
XFILLER_78_197 VGND VGND VPWR VPWR sky130_fd_sc_hd__fill_2
Xg_row\[1\].g_col\[0\].pe_hold1759 g_row\[1\].g_col\[0\].pe__2765_/Q VGND VGND VPWR
+ VPWR g_row\[1\].g_col\[0\].pe__2568_/A1 sky130_fd_sc_hd__clkbuf_2
XFILLER_19_264 VGND VGND VPWR VPWR sky130_fd_sc_hd__fill_2
XFILLER_47_551 VGND VGND VPWR VPWR sky130_fd_sc_hd__decap_3
XFILLER_35_735 VGND VGND VPWR VPWR sky130_fd_sc_hd__fill_2
Xg_row\[0\].g_col\[0\].pe__1570_ g_row\[0\].g_col\[0\].pe__1676_/A g_row\[0\].g_col\[0\].pe__1570_/B
+ VGND VGND VPWR VPWR g_row\[0\].g_col\[0\].pe__1571_/B sky130_fd_sc_hd__xnor2_2
Xg_row\[1\].g_col\[0\].pe__2113_ g_row\[1\].g_col\[0\].pe__2066_/Y g_row\[1\].g_col\[0\].pe__2061_/Y
+ g_row\[1\].g_col\[0\].pe__2111_/X g_row\[1\].g_col\[0\].pe__2236_/A1 VGND VGND VPWR
+ VPWR g_row\[1\].g_col\[0\].pe__2113_/X sky130_fd_sc_hd__a31o_2
XFILLER_34_256 VGND VGND VPWR VPWR sky130_fd_sc_hd__fill_2
Xg_row\[1\].g_col\[1\].pe__2060_ g_row\[1\].g_col\[1\].pe__2153_/A g_row\[1\].g_col\[1\].pe__2153_/B
+ VGND VGND VPWR VPWR g_row\[1\].g_col\[1\].pe__2150_/C sky130_fd_sc_hd__xor2_2
Xg_row\[1\].g_col\[0\].pe__2044_ g_row\[1\].g_col\[0\].pe__2094_/C g_row\[1\].g_col\[0\].pe__2044_/B
+ VGND VGND VPWR VPWR g_row\[1\].g_col\[0\].pe__2047_/A sky130_fd_sc_hd__and2_2
XFILLER_62_587 VGND VGND VPWR VPWR sky130_fd_sc_hd__fill_1
XFILLER_62_598 VGND VGND VPWR VPWR sky130_fd_sc_hd__decap_3
XTAP_TAPCELL_ROW_17_465 VGND VPWR sky130_fd_sc_hd__tapvpwrvgnd_1
XFILLER_30_495 VGND VGND VPWR VPWR sky130_fd_sc_hd__decap_3
XFILLER_8_73 VGND VGND VPWR VPWR sky130_fd_sc_hd__fill_2
Xg_row\[0\].g_col\[0\].pe__2122_ g_row\[0\].g_col\[0\].pe__1461_/A g_row\[0\].g_col\[0\].pe__1461_/B
+ g_row\[0\].g_col\[0\].pe__1922_/Y VGND VGND VPWR VPWR g_row\[0\].g_col\[0\].pe__2123_/C
+ sky130_fd_sc_hd__a21o_2
Xg_row\[0\].g_col\[0\].pe__2053_ g_row\[0\].g_col\[0\].pe__2052_/B g_row\[0\].g_col\[0\].pe__2052_/C
+ g_row\[0\].g_col\[0\].pe__2052_/A VGND VGND VPWR VPWR g_row\[0\].g_col\[0\].pe__2054_/B
+ sky130_fd_sc_hd__o21ai_2
Xg_row\[1\].g_col\[1\].pe__1913_ g_row\[1\].g_col\[1\].pe__1955_/A g_row\[1\].g_col\[1\].pe__1955_/B
+ VGND VGND VPWR VPWR g_row\[1\].g_col\[1\].pe__1916_/A sky130_fd_sc_hd__xor2_2
Xg_row\[1\].g_col\[1\].pe__1844_ g_row\[1\].g_col\[1\].pe__1844_/A g_row\[1\].g_col\[1\].pe__1844_/B
+ VGND VGND VPWR VPWR g_row\[1\].g_col\[1\].pe__1894_/A sky130_fd_sc_hd__and2_2
Xg_row\[1\].g_col\[0\].pe__1828_ g_row\[1\].g_col\[0\].pe__1828_/A g_row\[1\].g_col\[0\].pe__1828_/B
+ VGND VGND VPWR VPWR g_row\[1\].g_col\[0\].pe__1828_/Y sky130_fd_sc_hd__nand2_2
Xg_row\[1\].g_col\[1\].pe__1775_ g_row\[1\].g_col\[1\].pe__2599_/B g_row\[1\].g_col\[1\].pe__1748_/B
+ g_row\[1\].g_col\[1\].pe__1760_/B g_row\[1\].g_col\[1\].pe__1774_/Y VGND VGND VPWR
+ VPWR g_row\[1\].g_col\[1\].pe__1777_/A sky130_fd_sc_hd__a31o_2
Xhold2015 hold3106/X VGND VGND VPWR VPWR hold2015/X sky130_fd_sc_hd__clkbuf_2
Xg_row\[1\].g_col\[0\].pe__1759_ g_row\[1\].g_col\[0\].pe__1774_/A g_row\[1\].g_col\[0\].pe__1774_/B
+ VGND VGND VPWR VPWR g_row\[1\].g_col\[0\].pe__1760_/B sky130_fd_sc_hd__xor2_2
Xg_row\[0\].g_col\[0\].pe__1906_ g_row\[0\].g_col\[0\].pe__1964_/A g_row\[0\].g_col\[0\].pe__1906_/B
+ VGND VGND VPWR VPWR g_row\[0\].g_col\[0\].pe__1907_/B sky130_fd_sc_hd__and2_2
Xhold2048 hold2048/A VGND VGND VPWR VPWR hold2048/X sky130_fd_sc_hd__clkbuf_2
Xg_row\[0\].g_col\[1\].pe__1922_ g_row\[0\].g_col\[1\].pe__2702_/Q VGND VGND VPWR
+ VPWR g_row\[0\].g_col\[1\].pe__1922_/Y sky130_fd_sc_hd__inv_2
XFILLER_57_337 VGND VGND VPWR VPWR sky130_fd_sc_hd__decap_3
XFILLER_72_307 VGND VGND VPWR VPWR sky130_fd_sc_hd__fill_1
Xg_row\[0\].g_col\[1\].pe__1853_ g_row\[0\].g_col\[1\].pe__2605_/B g_row\[0\].g_col\[1\].pe__2177_/A2
+ g_row\[0\].g_col\[1\].pe__1901_/B1 g_row\[0\].g_col\[1\].pe__2603_/B VGND VGND VPWR
+ VPWR g_row\[0\].g_col\[1\].pe__1857_/A sky130_fd_sc_hd__a22o_2
XFILLER_38_584 VGND VGND VPWR VPWR sky130_fd_sc_hd__decap_3
XFILLER_81_841 VGND VGND VPWR VPWR sky130_fd_sc_hd__fill_1
Xg_row\[0\].g_col\[0\].pe__1768_ g_row\[0\].g_col\[0\].pe__1768_/A g_row\[0\].g_col\[0\].pe__1768_/B
+ VGND VGND VPWR VPWR g_row\[0\].g_col\[0\].pe__1781_/B sky130_fd_sc_hd__xnor2_2
Xg_row\[1\].g_col\[1\].pe__2327_ g_row\[1\].g_col\[1\].pe__2327_/A g_row\[1\].g_col\[1\].pe__2327_/B
+ g_row\[1\].g_col\[1\].pe__2327_/C VGND VGND VPWR VPWR g_row\[1\].g_col\[1\].pe__2328_/B
+ sky130_fd_sc_hd__nor3_2
Xg_row\[0\].g_col\[1\].pe__1784_ g_row\[0\].g_col\[1\].pe__1801_/A g_row\[0\].g_col\[1\].pe__1414_/X
+ g_row\[0\].g_col\[1\].pe__1415_/Y g_row\[0\].g_col\[1\].pe__1801_/B g_row\[0\].g_col\[1\].pe__1805_/A2
+ VGND VGND VPWR VPWR g_row\[0\].g_col\[1\].pe__1785_/B sky130_fd_sc_hd__a32o_2
XTAP_TAPCELL_ROW_36_752 VGND VPWR sky130_fd_sc_hd__tapvpwrvgnd_1
Xg_row\[1\].g_col\[1\].pe__2258_ g_row\[1\].g_col\[1\].pe__2258_/A g_row\[1\].g_col\[1\].pe__2258_/B
+ VGND VGND VPWR VPWR g_row\[1\].g_col\[1\].pe__2258_/X sky130_fd_sc_hd__and2_2
Xg_row\[0\].g_col\[0\].pe__1699_ g_row\[0\].g_col\[0\].pe__1698_/A g_row\[0\].g_col\[0\].pe__1699_/B
+ VGND VGND VPWR VPWR g_row\[0\].g_col\[0\].pe__1699_/X sky130_fd_sc_hd__and2b_2
Xg_row\[1\].g_col\[1\].pe__2189_ g_row\[1\].g_col\[1\].pe__2190_/A g_row\[1\].g_col\[1\].pe__2190_/B
+ VGND VGND VPWR VPWR g_row\[1\].g_col\[1\].pe__2191_/A sky130_fd_sc_hd__and2_4
Xg_row\[0\].g_col\[1\].pe__2405_ g_row\[0\].g_col\[1\].pe__2405_/A g_row\[0\].g_col\[1\].pe__2405_/B
+ VGND VGND VPWR VPWR g_row\[0\].g_col\[1\].pe__2755_/D sky130_fd_sc_hd__nor2_2
XFILLER_21_495 VGND VGND VPWR VPWR sky130_fd_sc_hd__fill_1
Xg_row\[0\].g_col\[1\].pe__2336_ g_row\[0\].g_col\[1\].pe__2336_/A VGND VGND VPWR
+ VPWR g_row\[0\].g_col\[1\].pe__2336_/Y sky130_fd_sc_hd__inv_2
Xg_row\[0\].g_col\[1\].pe__2267_ g_row\[0\].g_col\[1\].pe__2264_/X g_row\[0\].g_col\[1\].pe__2265_/Y
+ g_row\[0\].g_col\[1\].pe__2267_/B1 g_row\[0\].g_col\[1\].pe__2406_/B1 VGND VGND
+ VPWR VPWR g_row\[0\].g_col\[1\].pe__2268_/B sky130_fd_sc_hd__o2bb2a_2
Xg_row\[1\].g_col\[1\].pe_hold1812 g_row\[1\].g_col\[1\].pe__2765_/Q VGND VGND VPWR
+ VPWR g_row\[1\].g_col\[1\].pe__2568_/A1 sky130_fd_sc_hd__clkbuf_2
Xg_row\[0\].g_col\[1\].pe__2198_ place1250/X g_row\[0\].g_col\[1\].pe__2198_/A2 g_row\[0\].g_col\[1\].pe__2196_/X
+ g_row\[0\].g_col\[1\].pe__2197_/Y VGND VGND VPWR VPWR g_row\[0\].g_col\[1\].pe__2198_/X
+ sky130_fd_sc_hd__o22a_2
XFILLER_1_834 VGND VGND VPWR VPWR sky130_fd_sc_hd__decap_3
Xhold3250 hold3250/A VGND VGND VPWR VPWR hold3250/X sky130_fd_sc_hd__clkbuf_2
XFILLER_76_624 VGND VGND VPWR VPWR sky130_fd_sc_hd__decap_3
Xhold3261 hold3261/A VGND VGND VPWR VPWR hold3261/X sky130_fd_sc_hd__clkbuf_2
Xhold3272 hold3272/A VGND VGND VPWR VPWR hold3272/X sky130_fd_sc_hd__clkbuf_2
Xhold3283 hold3283/A VGND VGND VPWR VPWR hold3283/X sky130_fd_sc_hd__clkbuf_2
Xhold3294 hold3294/A VGND VGND VPWR VPWR hold3294/X sky130_fd_sc_hd__clkbuf_2
Xhold2560 hold3330/X VGND VGND VPWR VPWR hold3331/A sky130_fd_sc_hd__clkbuf_2
Xhold2571 hold3265/X VGND VGND VPWR VPWR hold3266/A sky130_fd_sc_hd__clkbuf_2
Xhold2582 hold3354/X VGND VGND VPWR VPWR hold3355/A sky130_fd_sc_hd__clkbuf_2
XFILLER_29_551 VGND VGND VPWR VPWR sky130_fd_sc_hd__decap_3
Xhold2593 hold2593/A VGND VGND VPWR VPWR _335_/D sky130_fd_sc_hd__clkbuf_2
XFILLER_17_735 VGND VGND VPWR VPWR sky130_fd_sc_hd__decap_3
XFILLER_29_595 VGND VGND VPWR VPWR sky130_fd_sc_hd__fill_2
XFILLER_56_370 VGND VGND VPWR VPWR sky130_fd_sc_hd__decap_3
XFILLER_17_779 VGND VGND VPWR VPWR sky130_fd_sc_hd__fill_1
XFILLER_17_82 VGND VGND VPWR VPWR sky130_fd_sc_hd__decap_3
XFILLER_44_598 VGND VGND VPWR VPWR sky130_fd_sc_hd__fill_2
XTAP_TAPCELL_ROW_14_413 VGND VPWR sky130_fd_sc_hd__tapvpwrvgnd_1
XTAP_TAPCELL_ROW_14_424 VGND VPWR sky130_fd_sc_hd__tapvpwrvgnd_1
Xg_row\[1\].g_col\[0\].pe__2731_ clkbuf_leaf_47_clk/X g_row\[1\].g_col\[0\].pe__2731_/D
+ VGND VGND VPWR VPWR g_row\[1\].g_col\[0\].pe__2731_/Q sky130_fd_sc_hd__dfxtp_2
XTAP_TAPCELL_ROW_74_1315 VGND VPWR sky130_fd_sc_hd__tapvpwrvgnd_1
XTAP_TAPCELL_ROW_74_1326 VGND VPWR sky130_fd_sc_hd__tapvpwrvgnd_1
Xg_row\[1\].g_col\[0\].pe__2662_ g_row\[1\].g_col\[0\].pe__2670_/A1 g_row\[1\].g_col\[0\].pe__2662_/A2
+ g_row\[1\].g_col\[0\].pe__2670_/B1 g_row\[1\].g_col\[0\].pe__2662_/C1 VGND VGND
+ VPWR VPWR g_row\[1\].g_col\[0\].pe__2662_/X sky130_fd_sc_hd__o211a_2
Xg_row\[1\].g_col\[0\].pe__1613_ g_row\[1\].g_col\[0\].pe__2612_/B g_row\[1\].g_col\[0\].pe__1657_/B
+ g_row\[1\].g_col\[0\].pe__2036_/B1 g_row\[1\].g_col\[0\].pe__2610_/B VGND VGND VPWR
+ VPWR g_row\[1\].g_col\[0\].pe__1614_/B sky130_fd_sc_hd__a22o_2
Xg_row\[1\].g_col\[1\].pe__1560_ g_row\[1\].g_col\[1\].pe__1607_/A g_row\[1\].g_col\[1\].pe__1560_/B
+ VGND VGND VPWR VPWR g_row\[1\].g_col\[1\].pe__1562_/C sky130_fd_sc_hd__and2_2
Xg_row\[1\].g_col\[1\].pe_place816 g_row\[1\].g_col\[1\].pe__2591_/B1 VGND VGND VPWR
+ VPWR g_row\[1\].g_col\[1\].pe__2568_/B1 sky130_fd_sc_hd__buf_6
Xg_row\[1\].g_col\[0\].pe_hold2235 g_row\[1\].g_col\[0\].pe__2422_/A VGND VGND VPWR
+ VPWR g_row\[1\].g_col\[0\].pe__2395_/A2 sky130_fd_sc_hd__clkbuf_2
Xg_row\[1\].g_col\[0\].pe__1544_ g_row\[1\].g_col\[0\].pe__2021_/A g_row\[1\].g_col\[0\].pe__1544_/B
+ VGND VGND VPWR VPWR g_row\[1\].g_col\[0\].pe__1552_/B sky130_fd_sc_hd__xnor2_2
XFILLER_12_3 VGND VGND VPWR VPWR sky130_fd_sc_hd__fill_2
XFILLER_67_668 VGND VGND VPWR VPWR sky130_fd_sc_hd__decap_3
Xg_row\[0\].g_col\[0\].pe__2740_ _323_/CLK g_row\[0\].g_col\[0\].pe__2740_/D VGND
+ VGND VPWR VPWR g_row\[0\].g_col\[0\].pe__2740_/Q sky130_fd_sc_hd__dfxtp_2
Xg_row\[1\].g_col\[1\].pe_place838 g_row\[1\].g_col\[1\].pe__1449_/Y VGND VGND VPWR
+ VPWR g_row\[1\].g_col\[1\].pe__1738_/B1 sky130_fd_sc_hd__buf_6
Xg_row\[1\].g_col\[1\].pe__1491_ g_row\[1\].g_col\[1\].pe__1512_/A g_row\[1\].g_col\[1\].pe__1512_/B
+ VGND VGND VPWR VPWR g_row\[1\].g_col\[1\].pe__1500_/A sky130_fd_sc_hd__xor2_2
Xg_row\[1\].g_col\[0\].pe_hold2279 g_row\[1\].g_col\[0\].pe__1407_/X VGND VGND VPWR
+ VPWR g_row\[1\].g_col\[0\].pe__1408_/B sky130_fd_sc_hd__clkbuf_2
Xg_row\[1\].g_col\[0\].pe_hold2257 g_row\[1\].g_col\[0\].pe__2430_/A VGND VGND VPWR
+ VPWR g_row\[1\].g_col\[0\].pe__2334_/A2 sky130_fd_sc_hd__clkbuf_2
XFILLER_67_679 VGND VGND VPWR VPWR sky130_fd_sc_hd__fill_1
Xg_row\[0\].g_col\[0\].pe__2671_ _318_/Q _317_/Q _320_/Q _319_/Q VGND VGND VPWR VPWR
+ g_row\[0\].g_col\[0\].pe__2672_/D sky130_fd_sc_hd__or4_2
XFILLER_35_532 VGND VGND VPWR VPWR sky130_fd_sc_hd__decap_3
XFILLER_47_381 VGND VGND VPWR VPWR sky130_fd_sc_hd__decap_3
XFILLER_63_841 VGND VGND VPWR VPWR sky130_fd_sc_hd__fill_1
Xg_row\[0\].g_col\[0\].pe__1622_ g_row\[0\].g_col\[0\].pe__1622_/A g_row\[0\].g_col\[0\].pe__1875_/C
+ VGND VGND VPWR VPWR g_row\[0\].g_col\[0\].pe__1625_/A sky130_fd_sc_hd__xnor2_2
XFILLER_23_705 VGND VGND VPWR VPWR sky130_fd_sc_hd__decap_3
Xg_row\[1\].g_col\[1\].pe__2112_ g_row\[1\].g_col\[1\].pe__2066_/Y g_row\[1\].g_col\[1\].pe__2061_/Y
+ g_row\[1\].g_col\[1\].pe__2111_/X VGND VGND VPWR VPWR g_row\[1\].g_col\[1\].pe__2112_/Y
+ sky130_fd_sc_hd__a21oi_2
XFILLER_50_502 VGND VGND VPWR VPWR sky130_fd_sc_hd__fill_1
XFILLER_50_524 VGND VGND VPWR VPWR sky130_fd_sc_hd__fill_2
XTAP_TAPCELL_ROW_33_700 VGND VPWR sky130_fd_sc_hd__tapvpwrvgnd_1
XTAP_TAPCELL_ROW_33_711 VGND VPWR sky130_fd_sc_hd__tapvpwrvgnd_1
XTAP_TAPCELL_ROW_85_1488 VGND VPWR sky130_fd_sc_hd__tapvpwrvgnd_1
Xg_row\[0\].g_col\[0\].pe__1553_ g_row\[0\].g_col\[0\].pe__2736_/Q g_row\[0\].g_col\[0\].pe__1535_/B
+ g_row\[0\].g_col\[0\].pe__1546_/B g_row\[0\].g_col\[0\].pe__1552_/X VGND VGND VPWR
+ VPWR g_row\[0\].g_col\[0\].pe__1591_/A sky130_fd_sc_hd__a31oi_2
XFILLER_50_546 VGND VGND VPWR VPWR sky130_fd_sc_hd__decap_3
Xg_row\[0\].g_col\[0\].pe__1484_ g_row\[0\].g_col\[0\].pe__1705_/A g_row\[0\].g_col\[0\].pe__1484_/B
+ VGND VGND VPWR VPWR g_row\[0\].g_col\[0\].pe__1514_/A sky130_fd_sc_hd__xnor2_2
Xg_row\[1\].g_col\[1\].pe__2043_ g_row\[1\].g_col\[1\].pe__2043_/A g_row\[1\].g_col\[1\].pe__2043_/B
+ VGND VGND VPWR VPWR g_row\[1\].g_col\[1\].pe__2044_/B sky130_fd_sc_hd__nand2_2
Xg_row\[1\].g_col\[0\].pe__2027_ g_row\[1\].g_col\[0\].pe__1449_/A g_row\[1\].g_col\[0\].pe__1449_/B
+ g_row\[1\].g_col\[0\].pe__1922_/Y VGND VGND VPWR VPWR g_row\[1\].g_col\[0\].pe__2028_/C
+ sky130_fd_sc_hd__a21o_2
Xg_row\[0\].g_col\[0\].pe__2105_ g_row\[0\].g_col\[0\].pe__2104_/A g_row\[0\].g_col\[0\].pe__2104_/B
+ g_row\[0\].g_col\[0\].pe__2104_/C VGND VGND VPWR VPWR g_row\[0\].g_col\[0\].pe__2105_/X
+ sky130_fd_sc_hd__a21o_2
Xg_row\[0\].g_col\[1\].pe__2121_ g_row\[0\].g_col\[1\].pe__2121_/A g_row\[0\].g_col\[1\].pe__2163_/B
+ VGND VGND VPWR VPWR g_row\[0\].g_col\[1\].pe__2123_/B sky130_fd_sc_hd__nand2_2
Xg_row\[0\].g_col\[1\].pe__2052_ g_row\[0\].g_col\[1\].pe__2052_/A g_row\[0\].g_col\[1\].pe__2052_/B
+ g_row\[0\].g_col\[1\].pe__2052_/C VGND VGND VPWR VPWR g_row\[0\].g_col\[1\].pe__2054_/A
+ sky130_fd_sc_hd__or3_4
XFILLER_89_204 VGND VGND VPWR VPWR sky130_fd_sc_hd__fill_2
Xg_row\[0\].g_col\[0\].pe__2036_ g_row\[0\].g_col\[0\].pe__2241_/B2 g_row\[0\].g_col\[0\].pe__1471_/X
+ g_row\[0\].g_col\[0\].pe__1474_/Y g_row\[0\].g_col\[0\].pe__2215_/B2 VGND VGND VPWR
+ VPWR g_row\[0\].g_col\[0\].pe__2037_/B sky130_fd_sc_hd__a22o_2
Xg_row\[1\].g_col\[1\].pe__1827_ g_row\[1\].g_col\[1\].pe__1827_/A g_row\[1\].g_col\[1\].pe__1827_/B
+ VGND VGND VPWR VPWR g_row\[1\].g_col\[1\].pe__1827_/Y sky130_fd_sc_hd__nand2_2
Xplace1198 hold2359/X VGND VGND VPWR VPWR place1198/X sky130_fd_sc_hd__buf_6
XFILLER_58_624 VGND VGND VPWR VPWR sky130_fd_sc_hd__decap_3
Xg_row\[1\].g_col\[1\].pe__1758_ g_row\[1\].g_col\[1\].pe__1758_/A g_row\[1\].g_col\[1\].pe__1758_/B
+ VGND VGND VPWR VPWR g_row\[1\].g_col\[1\].pe__1774_/B sky130_fd_sc_hd__xnor2_2
Xg_row\[1\].g_col\[1\].pe__1689_ g_row\[1\].g_col\[1\].pe__1721_/A g_row\[1\].g_col\[1\].pe__1721_/B
+ VGND VGND VPWR VPWR g_row\[1\].g_col\[1\].pe__1689_/Y sky130_fd_sc_hd__nand2_2
XFILLER_45_307 VGND VGND VPWR VPWR sky130_fd_sc_hd__fill_2
Xg_row\[0\].g_col\[1\].pe__1905_ g_row\[0\].g_col\[1\].pe__1905_/A g_row\[0\].g_col\[1\].pe__1905_/B
+ VGND VGND VPWR VPWR g_row\[0\].g_col\[1\].pe__1906_/B sky130_fd_sc_hd__or2_2
XFILLER_38_381 VGND VGND VPWR VPWR sky130_fd_sc_hd__fill_1
XFILLER_54_841 VGND VGND VPWR VPWR sky130_fd_sc_hd__fill_1
XFILLER_66_690 VGND VGND VPWR VPWR sky130_fd_sc_hd__fill_1
Xg_row\[0\].g_col\[1\].pe__1836_ g_row\[0\].g_col\[1\].pe__1836_/A g_row\[0\].g_col\[1\].pe__1836_/B
+ VGND VGND VPWR VPWR g_row\[0\].g_col\[1\].pe__1836_/X sky130_fd_sc_hd__and2_2
XFILLER_53_340 VGND VGND VPWR VPWR sky130_fd_sc_hd__decap_3
XFILLER_53_384 VGND VGND VPWR VPWR sky130_fd_sc_hd__decap_3
XTAP_TAPCELL_ROW_0_196 VGND VPWR sky130_fd_sc_hd__tapvpwrvgnd_1
Xg_row\[0\].g_col\[1\].pe__1767_ g_row\[0\].g_col\[1\].pe__1801_/A g_row\[0\].g_col\[1\].pe__1982_/B
+ VGND VGND VPWR VPWR g_row\[0\].g_col\[1\].pe__1768_/B sky130_fd_sc_hd__nand2_2
XFILLER_14_749 VGND VGND VPWR VPWR sky130_fd_sc_hd__decap_3
XFILLER_41_557 VGND VGND VPWR VPWR sky130_fd_sc_hd__decap_3
Xg_row\[0\].g_col\[1\].pe__1698_ g_row\[0\].g_col\[1\].pe__1698_/A g_row\[0\].g_col\[1\].pe__1699_/B
+ VGND VGND VPWR VPWR g_row\[0\].g_col\[1\].pe__1823_/B sky130_fd_sc_hd__xnor2_2
Xg_row\[0\].g_col\[1\].pe__2319_ g_row\[0\].g_col\[1\].pe__2319_/A g_row\[0\].g_col\[1\].pe__2319_/B
+ VGND VGND VPWR VPWR g_row\[0\].g_col\[1\].pe__2348_/B sky130_fd_sc_hd__xor2_2
XFILLER_5_447 VGND VGND VPWR VPWR sky130_fd_sc_hd__fill_1
Xg_row\[1\].g_col\[1\].pe_hold3022 g_row\[1\].g_col\[1\].pe_hold3022/A VGND VGND VPWR
+ VPWR g_row\[1\].g_col\[1\].pe__1393_/A1 sky130_fd_sc_hd__clkbuf_2
XFILLER_1_620 VGND VGND VPWR VPWR sky130_fd_sc_hd__fill_2
XTAP_TAPCELL_ROW_56_1045 VGND VPWR sky130_fd_sc_hd__tapvpwrvgnd_1
XTAP_TAPCELL_ROW_56_1056 VGND VPWR sky130_fd_sc_hd__tapvpwrvgnd_1
Xg_row\[1\].g_col\[1\].pe_hold3088 g_row\[1\].g_col\[1\].pe__2727_/Q VGND VGND VPWR
+ VPWR g_row\[1\].g_col\[1\].pe_hold3088/X sky130_fd_sc_hd__clkbuf_2
Xg_row\[1\].g_col\[1\].pe_hold1664 g_row\[1\].g_col\[1\].pe__2755_/Q VGND VGND VPWR
+ VPWR g_row\[1\].g_col\[1\].pe__2403_/A sky130_fd_sc_hd__clkbuf_2
Xg_row\[1\].g_col\[1\].pe_hold1653 g_row\[1\].g_col\[1\].pe_hold3124/X VGND VGND VPWR
+ VPWR g_row\[1\].g_col\[1\].pe__1950_/B sky130_fd_sc_hd__clkbuf_2
Xg_row\[1\].g_col\[1\].pe_hold1642 g_row\[1\].g_col\[1\].pe__1408_/Y VGND VGND VPWR
+ VPWR g_row\[1\].g_col\[1\].pe__2738_/D sky130_fd_sc_hd__clkbuf_2
Xg_row\[1\].g_col\[1\].pe_hold1697 g_row\[1\].g_col\[1\].pe__2198_/X VGND VGND VPWR
+ VPWR g_row\[1\].g_col\[1\].pe__2199_/B sky130_fd_sc_hd__clkbuf_2
Xg_row\[1\].g_col\[1\].pe_hold1675 g_row\[1\].g_col\[1\].pe__2404_/X VGND VGND VPWR
+ VPWR g_row\[1\].g_col\[1\].pe__2405_/B sky130_fd_sc_hd__clkbuf_2
XFILLER_91_446 VGND VGND VPWR VPWR sky130_fd_sc_hd__fill_2
XFILLER_45_841 VGND VGND VPWR VPWR sky130_fd_sc_hd__fill_1
XFILLER_17_576 VGND VGND VPWR VPWR sky130_fd_sc_hd__decap_3
XFILLER_44_362 VGND VGND VPWR VPWR sky130_fd_sc_hd__fill_2
XFILLER_60_811 VGND VGND VPWR VPWR sky130_fd_sc_hd__fill_1
XFILLER_9_720 VGND VGND VPWR VPWR sky130_fd_sc_hd__decap_3
Xg_row\[0\].g_col\[0\].pe_hold2878 g_row\[0\].g_col\[0\].pe_hold2878/A VGND VGND VPWR
+ VPWR g_row\[0\].g_col\[0\].pe__2606_/A2 sky130_fd_sc_hd__clkbuf_2
Xg_row\[0\].g_col\[0\].pe_hold2889 _284_/Q VGND VGND VPWR VPWR g_row\[0\].g_col\[0\].pe_hold2889/X
+ sky130_fd_sc_hd__clkbuf_2
XFILLER_9_764 VGND VGND VPWR VPWR sky130_fd_sc_hd__decap_3
Xg_row\[1\].g_col\[1\].pe__2730_ clkbuf_leaf_82_clk/X g_row\[1\].g_col\[1\].pe__2730_/D
+ VGND VGND VPWR VPWR g_row\[1\].g_col\[1\].pe__2730_/Q sky130_fd_sc_hd__dfxtp_2
Xg_row\[1\].g_col\[0\].pe__2714_ clkbuf_leaf_48_clk/X g_row\[1\].g_col\[0\].pe__2714_/D
+ VGND VGND VPWR VPWR g_row\[1\].g_col\[0\].pe__2714_/Q sky130_fd_sc_hd__dfxtp_2
Xg_row\[1\].g_col\[1\].pe__2661_ g_row\[1\].g_col\[1\].pe__2669_/A g_row\[1\].g_col\[1\].pe__2661_/B
+ VGND VGND VPWR VPWR g_row\[1\].g_col\[1\].pe__2661_/X sky130_fd_sc_hd__or2_2
Xg_row\[1\].g_col\[0\].pe__2645_ g_row\[1\].g_col\[0\].pe__2676_/A g_row\[1\].g_col\[0\].pe__2645_/B
+ VGND VGND VPWR VPWR g_row\[1\].g_col\[0\].pe__2645_/X sky130_fd_sc_hd__or2_2
Xg_row\[1\].g_col\[1\].pe__2592_ g_row\[1\].g_col\[1\].pe__2592_/A g_row\[1\].g_col\[1\].pe__2592_/B
+ VGND VGND VPWR VPWR g_row\[1\].g_col\[1\].pe__2592_/X sky130_fd_sc_hd__and2_2
Xg_row\[1\].g_col\[1\].pe__1612_ g_row\[1\].g_col\[1\].pe__1851_/A g_row\[1\].g_col\[1\].pe__1851_/B
+ VGND VGND VPWR VPWR g_row\[1\].g_col\[1\].pe__1615_/A sky130_fd_sc_hd__xor2_2
Xg_row\[1\].g_col\[0\].pe__2576_ g_row\[1\].g_col\[0\].pe__2576_/A1 g_row\[1\].g_col\[0\].pe__2591_/A2
+ g_row\[1\].g_col\[0\].pe__2591_/B1 g_row\[1\].g_col\[0\].pe__2575_/X VGND VGND VPWR
+ VPWR g_row\[1\].g_col\[0\].pe__2576_/X sky130_fd_sc_hd__a22o_2
XFILLER_79_281 VGND VGND VPWR VPWR sky130_fd_sc_hd__fill_2
Xg_row\[1\].g_col\[1\].pe__1543_ g_row\[1\].g_col\[1\].pe__1853_/B2 g_row\[1\].g_col\[1\].pe__1549_/B
+ g_row\[1\].g_col\[1\].pe__1541_/X g_row\[1\].g_col\[1\].pe__1657_/A VGND VGND VPWR
+ VPWR g_row\[1\].g_col\[1\].pe__1544_/B sky130_fd_sc_hd__a22o_2
Xg_row\[1\].g_col\[0\].pe_hold2054 g_row\[1\].g_col\[0\].pe_hold3098/X VGND VGND VPWR
+ VPWR g_row\[1\].g_col\[0\].pe__1380_/A1 sky130_fd_sc_hd__clkbuf_2
Xg_row\[1\].g_col\[0\].pe__1527_ g_row\[1\].g_col\[0\].pe__2612_/B g_row\[1\].g_col\[0\].pe__1715_/B
+ g_row\[1\].g_col\[0\].pe__1863_/B1 g_row\[1\].g_col\[0\].pe__2610_/B VGND VGND VPWR
+ VPWR g_row\[1\].g_col\[0\].pe__1528_/B sky130_fd_sc_hd__a22o_2
Xg_row\[0\].g_col\[1\].pe_hold3109 g_row\[0\].g_col\[1\].pe__2683_/X VGND VGND VPWR
+ VPWR g_row\[0\].g_col\[1\].pe_hold3109/X sky130_fd_sc_hd__clkbuf_2
XPHY_EDGE_ROW_19_Left_113 VGND VGND VPWR VPWR sky130_fd_sc_hd__decap_3
XTAP_TAPCELL_ROW_87_1517 VGND VPWR sky130_fd_sc_hd__tapvpwrvgnd_1
Xg_row\[0\].g_col\[0\].pe__2723_ clkload12/A g_row\[0\].g_col\[0\].pe__2723_/D VGND
+ VGND VPWR VPWR g_row\[0\].g_col\[0\].pe__2723_/Q sky130_fd_sc_hd__dfxtp_2
Xg_row\[1\].g_col\[1\].pe__1474_ g_row\[1\].g_col\[1\].pe__1540_/C g_row\[1\].g_col\[1\].pe__1471_/A
+ g_row\[1\].g_col\[1\].pe__1473_/X VGND VGND VPWR VPWR g_row\[1\].g_col\[1\].pe__1474_/Y
+ sky130_fd_sc_hd__o21ai_2
Xg_row\[1\].g_col\[0\].pe_hold2076 g_row\[1\].g_col\[0\].pe__2716_/Q VGND VGND VPWR
+ VPWR g_row\[1\].g_col\[0\].pe__2661_/B sky130_fd_sc_hd__clkbuf_2
Xg_row\[1\].g_col\[0\].pe_hold2065 g_row\[1\].g_col\[0\].pe_hold3025/X VGND VGND VPWR
+ VPWR g_row\[1\].g_col\[0\].pe__2714_/D sky130_fd_sc_hd__clkbuf_2
Xg_row\[0\].g_col\[1\].pe__2670_ g_row\[0\].g_col\[1\].pe__2670_/A1 g_row\[0\].g_col\[1\].pe__2670_/A2
+ g_row\[0\].g_col\[1\].pe__2670_/B1 g_row\[0\].g_col\[1\].pe__2669_/X VGND VGND VPWR
+ VPWR g_row\[0\].g_col\[1\].pe__2670_/X sky130_fd_sc_hd__o211a_2
XFILLER_70_608 VGND VGND VPWR VPWR sky130_fd_sc_hd__fill_2
Xg_row\[0\].g_col\[0\].pe__2654_ g_row\[0\].g_col\[0\].pe__2656_/A1 g_row\[0\].g_col\[0\].pe__2654_/A2
+ g_row\[0\].g_col\[0\].pe__2677_/B1 g_row\[0\].g_col\[0\].pe__2653_/X VGND VGND VPWR
+ VPWR g_row\[0\].g_col\[0\].pe__2654_/X sky130_fd_sc_hd__o211a_2
Xg_row\[0\].g_col\[1\].pe__1621_ g_row\[0\].g_col\[1\].pe__2045_/A g_row\[0\].g_col\[1\].pe__1621_/B
+ VGND VGND VPWR VPWR g_row\[0\].g_col\[1\].pe__1875_/C sky130_fd_sc_hd__xor2_2
Xg_row\[1\].g_col\[0\].pe__1389_ hold1876/X g_row\[1\].g_col\[0\].pe__1402_/B VGND
+ VGND VPWR VPWR g_row\[1\].g_col\[0\].pe__1389_/X sky130_fd_sc_hd__or2_2
XFILLER_63_671 VGND VGND VPWR VPWR sky130_fd_sc_hd__fill_1
Xg_row\[0\].g_col\[0\].pe__1605_ g_row\[0\].g_col\[0\].pe__1860_/A g_row\[0\].g_col\[0\].pe__1605_/B
+ VGND VGND VPWR VPWR g_row\[0\].g_col\[0\].pe__1848_/B sky130_fd_sc_hd__and2_2
Xg_row\[0\].g_col\[0\].pe__2585_ g_row\[0\].g_col\[0\].pe__2585_/A g_row\[0\].g_col\[0\].pe__2585_/B
+ VGND VGND VPWR VPWR g_row\[0\].g_col\[0\].pe__2586_/C sky130_fd_sc_hd__and2_2
Xg_row\[0\].g_col\[0\].pe__1536_ g_row\[0\].g_col\[0\].pe__1536_/A g_row\[0\].g_col\[0\].pe__1536_/B
+ VGND VGND VPWR VPWR g_row\[0\].g_col\[0\].pe__1536_/X sky130_fd_sc_hd__and2_2
Xg_row\[0\].g_col\[1\].pe__1552_ g_row\[0\].g_col\[1\].pe__1545_/A g_row\[0\].g_col\[1\].pe__1552_/B
+ VGND VGND VPWR VPWR g_row\[0\].g_col\[1\].pe__1552_/X sky130_fd_sc_hd__and2b_2
XFILLER_50_365 VGND VGND VPWR VPWR sky130_fd_sc_hd__decap_3
Xg_row\[0\].g_col\[1\].pe__1483_ g_row\[0\].g_col\[1\].pe__1704_/A1 g_row\[0\].g_col\[1\].pe__1965_/A
+ g_row\[0\].g_col\[1\].pe__2030_/A g_row\[0\].g_col\[1\].pe__1704_/B2 VGND VGND VPWR
+ VPWR g_row\[0\].g_col\[1\].pe__1484_/B sky130_fd_sc_hd__a22o_2
Xg_row\[1\].g_col\[1\].pe__2026_ g_row\[1\].g_col\[1\].pe__2121_/A g_row\[1\].g_col\[1\].pe__2026_/B
+ VGND VGND VPWR VPWR g_row\[1\].g_col\[1\].pe__2028_/B sky130_fd_sc_hd__nand2_2
XPHY_EDGE_ROW_28_Left_122 VGND VGND VPWR VPWR sky130_fd_sc_hd__decap_3
Xg_row\[0\].g_col\[0\].pe__1398_ g_row\[0\].g_col\[0\].pe__1398_/A g_row\[0\].g_col\[0\].pe__1402_/B
+ VGND VGND VPWR VPWR g_row\[0\].g_col\[0\].pe__1398_/X sky130_fd_sc_hd__or2_2
Xg_row\[0\].g_col\[1\].pe__2104_ g_row\[0\].g_col\[1\].pe__2104_/A g_row\[0\].g_col\[1\].pe__2104_/B
+ g_row\[0\].g_col\[1\].pe__2104_/C VGND VGND VPWR VPWR g_row\[0\].g_col\[1\].pe__2106_/A
+ sky130_fd_sc_hd__and3_4
Xg_row\[0\].g_col\[0\].pe__2019_ place1212/A g_row\[0\].g_col\[0\].pe__2278_/A2 g_row\[0\].g_col\[0\].pe__2278_/B1
+ place1214/X VGND VGND VPWR VPWR g_row\[0\].g_col\[0\].pe__2071_/A sky130_fd_sc_hd__a22o_2
Xg_row\[0\].g_col\[1\].pe__2035_ g_row\[0\].g_col\[1\].pe__2034_/A g_row\[0\].g_col\[1\].pe__2034_/B
+ g_row\[0\].g_col\[1\].pe__2034_/C g_row\[0\].g_col\[1\].pe__2034_/D VGND VGND VPWR
+ VPWR g_row\[0\].g_col\[1\].pe__2038_/B sky130_fd_sc_hd__a22o_2
XFILLER_86_741 VGND VGND VPWR VPWR sky130_fd_sc_hd__decap_3
XPHY_EDGE_ROW_37_Left_131 VGND VGND VPWR VPWR sky130_fd_sc_hd__decap_3
XTAP_TAPCELL_ROW_5_288 VGND VPWR sky130_fd_sc_hd__tapvpwrvgnd_1
XFILLER_18_318 VGND VGND VPWR VPWR sky130_fd_sc_hd__decap_3
XFILLER_45_126 VGND VGND VPWR VPWR sky130_fd_sc_hd__fill_2
XFILLER_65_35 VGND VGND VPWR VPWR sky130_fd_sc_hd__fill_2
XANTENNA_103 load_weights VGND VGND VPWR VPWR sky130_fd_sc_hd__diode_2
XANTENNA_114 hold3464/A VGND VGND VPWR VPWR sky130_fd_sc_hd__diode_2
XANTENNA_125 hold3537/X VGND VGND VPWR VPWR sky130_fd_sc_hd__diode_2
XFILLER_27_841 VGND VGND VPWR VPWR sky130_fd_sc_hd__fill_1
Xg_row\[0\].g_col\[1\].pe_hold2953 g_row\[0\].g_col\[1\].pe__2689_/A VGND VGND VPWR
+ VPWR g_row\[0\].g_col\[1\].pe__2680_/A sky130_fd_sc_hd__clkbuf_2
XANTENNA_136 b_inputs_flat[23] VGND VGND VPWR VPWR sky130_fd_sc_hd__diode_2
XANTENNA_147 a_inputs_flat[2] VGND VGND VPWR VPWR sky130_fd_sc_hd__diode_2
XANTENNA_158 hold3250/A VGND VGND VPWR VPWR sky130_fd_sc_hd__diode_2
XFILLER_42_811 VGND VGND VPWR VPWR sky130_fd_sc_hd__fill_1
XFILLER_54_660 VGND VGND VPWR VPWR sky130_fd_sc_hd__fill_1
Xg_row\[0\].g_col\[1\].pe__1819_ g_row\[0\].g_col\[1\].pe__1819_/A g_row\[0\].g_col\[1\].pe__1819_/B
+ VGND VGND VPWR VPWR g_row\[0\].g_col\[1\].pe__1820_/A sky130_fd_sc_hd__and2_2
XANTENNA_169 ANTENNA_169/DIODE VGND VGND VPWR VPWR sky130_fd_sc_hd__diode_2
XFILLER_41_321 VGND VGND VPWR VPWR sky130_fd_sc_hd__fill_1
Xclkbuf_leaf_80_clk clkbuf_4_8_0_clk/X VGND VGND VPWR VPWR clkbuf_leaf_80_clk/X sky130_fd_sc_hd__clkbuf_16
Xg_row\[0\].g_col\[0\].pe_hold2108 g_row\[0\].g_col\[0\].pe__2767_/Q VGND VGND VPWR
+ VPWR g_row\[0\].g_col\[0\].pe__2576_/A1 sky130_fd_sc_hd__clkbuf_2
XFILLER_14_568 VGND VGND VPWR VPWR sky130_fd_sc_hd__decap_3
XPHY_EDGE_ROW_46_Left_140 VGND VGND VPWR VPWR sky130_fd_sc_hd__decap_3
XTAP_TAPCELL_ROW_24_563 VGND VPWR sky130_fd_sc_hd__tapvpwrvgnd_1
XTAP_TAPCELL_ROW_24_574 VGND VPWR sky130_fd_sc_hd__tapvpwrvgnd_1
X_283_ _291_/CLK _283_/D VGND VGND VPWR VPWR _283_/Q sky130_fd_sc_hd__dfxtp_2
XFILLER_10_752 VGND VGND VPWR VPWR sky130_fd_sc_hd__decap_3
XFILLER_5_255 VGND VGND VPWR VPWR sky130_fd_sc_hd__fill_1
Xg_row\[1\].g_col\[1\].pe_hold2140 g_row\[1\].g_col\[1\].pe__2687_/X VGND VGND VPWR
+ VPWR g_row\[1\].g_col\[1\].pe__2726_/D sky130_fd_sc_hd__clkbuf_2
Xg_row\[1\].g_col\[1\].pe_hold2195 g_row\[1\].g_col\[1\].pe_hold2992/X VGND VGND VPWR
+ VPWR g_row\[1\].g_col\[1\].pe__2711_/D sky130_fd_sc_hd__clkbuf_2
Xg_row\[1\].g_col\[0\].pe__2430_ g_row\[1\].g_col\[0\].pe__2430_/A g_row\[1\].g_col\[0\].pe__2430_/B
+ VGND VGND VPWR VPWR g_row\[1\].g_col\[0\].pe__2476_/B sky130_fd_sc_hd__xnor2_2
XFILLER_49_476 VGND VGND VPWR VPWR sky130_fd_sc_hd__fill_2
XFILLER_77_763 VGND VGND VPWR VPWR sky130_fd_sc_hd__decap_3
Xg_row\[1\].g_col\[0\].pe__2361_ place1268/X g_row\[1\].g_col\[0\].pe__2361_/B VGND
+ VGND VPWR VPWR g_row\[1\].g_col\[0\].pe__2751_/D sky130_fd_sc_hd__nor2_2
Xg_row\[1\].g_col\[0\].pe__2292_ g_row\[1\].g_col\[0\].pe__2292_/A g_row\[1\].g_col\[0\].pe__2327_/B
+ VGND VGND VPWR VPWR g_row\[1\].g_col\[0\].pe__2292_/X sky130_fd_sc_hd__or2_2
XTAP_TAPCELL_ROW_69_1247 VGND VPWR sky130_fd_sc_hd__tapvpwrvgnd_1
XFILLER_51_118 VGND VGND VPWR VPWR sky130_fd_sc_hd__fill_2
XFILLER_32_321 VGND VGND VPWR VPWR sky130_fd_sc_hd__decap_3
XTAP_TAPCELL_ROW_82_1436 VGND VPWR sky130_fd_sc_hd__tapvpwrvgnd_1
XTAP_TAPCELL_ROW_82_1447 VGND VPWR sky130_fd_sc_hd__tapvpwrvgnd_1
Xclkbuf_leaf_71_clk clkload8/A VGND VGND VPWR VPWR clkload17/A sky130_fd_sc_hd__clkbuf_16
Xg_row\[0\].g_col\[0\].pe__2370_ g_row\[0\].g_col\[0\].pe__2387_/A g_row\[0\].g_col\[0\].pe__2370_/B
+ VGND VGND VPWR VPWR g_row\[0\].g_col\[0\].pe__2372_/A sky130_fd_sc_hd__and2_2
XFILLER_20_505 VGND VGND VPWR VPWR sky130_fd_sc_hd__decap_3
XFILLER_32_365 VGND VGND VPWR VPWR sky130_fd_sc_hd__fill_1
XTAP_TAPCELL_ROW_43_850 VGND VPWR sky130_fd_sc_hd__tapvpwrvgnd_1
XTAP_TAPCELL_ROW_43_861 VGND VPWR sky130_fd_sc_hd__tapvpwrvgnd_1
Xg_row\[0\].g_col\[0\].pe_hold1930 g_row\[0\].g_col\[0\].pe__2397_/Y VGND VGND VPWR
+ VPWR g_row\[0\].g_col\[0\].pe__2401_/A2 sky130_fd_sc_hd__clkbuf_2
XFILLER_9_572 VGND VGND VPWR VPWR sky130_fd_sc_hd__decap_3
Xg_row\[0\].g_col\[0\].pe_hold1996 g_row\[0\].g_col\[0\].pe__2594_/X VGND VGND VPWR
+ VPWR g_row\[0\].g_col\[0\].pe__2595_/B sky130_fd_sc_hd__clkbuf_2
Xg_row\[1\].g_col\[1\].pe__2713_ clkbuf_leaf_85_clk/X g_row\[1\].g_col\[1\].pe__2713_/D
+ VGND VGND VPWR VPWR g_row\[1\].g_col\[1\].pe__2713_/Q sky130_fd_sc_hd__dfxtp_2
XTAP_TAPCELL_ROW_93_1598 VGND VPWR sky130_fd_sc_hd__tapvpwrvgnd_1
Xg_row\[1\].g_col\[1\].pe__2644_ g_row\[1\].g_col\[1\].pe__2656_/A1 g_row\[1\].g_col\[1\].pe__2683_/A1
+ g_row\[1\].g_col\[1\].pe__2683_/C1 g_row\[1\].g_col\[1\].pe__2644_/C1 VGND VGND
+ VPWR VPWR g_row\[1\].g_col\[1\].pe__2644_/X sky130_fd_sc_hd__o211a_2
Xg_row\[1\].g_col\[0\].pe__2628_ g_row\[1\].g_col\[0\].pe__2652_/A1 g_row\[1\].g_col\[0\].pe__2628_/A2
+ g_row\[1\].g_col\[0\].pe__2687_/C1 g_row\[1\].g_col\[0\].pe__2627_/X VGND VGND VPWR
+ VPWR g_row\[1\].g_col\[0\].pe__2628_/X sky130_fd_sc_hd__o211a_2
XFILLER_28_605 VGND VGND VPWR VPWR sky130_fd_sc_hd__fill_2
XFILLER_67_240 VGND VGND VPWR VPWR sky130_fd_sc_hd__fill_1
Xg_row\[1\].g_col\[1\].pe__2575_ g_row\[1\].g_col\[1\].pe__2575_/A g_row\[1\].g_col\[1\].pe__2590_/A
+ VGND VGND VPWR VPWR g_row\[1\].g_col\[1\].pe__2575_/X sky130_fd_sc_hd__or2_2
Xg_row\[1\].g_col\[0\].pe__2559_ g_row\[1\].g_col\[0\].pe__2559_/A g_row\[1\].g_col\[0\].pe__2559_/B
+ VGND VGND VPWR VPWR g_row\[1\].g_col\[0\].pe__2559_/X sky130_fd_sc_hd__or2_2
XFILLER_27_104 VGND VGND VPWR VPWR sky130_fd_sc_hd__fill_1
XFILLER_27_126 VGND VGND VPWR VPWR sky130_fd_sc_hd__fill_1
XFILLER_28_627 VGND VGND VPWR VPWR sky130_fd_sc_hd__decap_3
XFILLER_28_638 VGND VGND VPWR VPWR sky130_fd_sc_hd__decap_3
XFILLER_55_413 VGND VGND VPWR VPWR sky130_fd_sc_hd__fill_2
XFILLER_82_210 VGND VGND VPWR VPWR sky130_fd_sc_hd__fill_1
XTAP_TAPCELL_ROW_2_236 VGND VPWR sky130_fd_sc_hd__tapvpwrvgnd_1
XTAP_TAPCELL_ROW_2_247 VGND VPWR sky130_fd_sc_hd__tapvpwrvgnd_1
Xg_row\[1\].g_col\[1\].pe__1526_ g_row\[1\].g_col\[1\].pe__1739_/A g_row\[1\].g_col\[1\].pe__1526_/B
+ VGND VGND VPWR VPWR g_row\[1\].g_col\[1\].pe__1554_/A sky130_fd_sc_hd__xor2_2
Xg_row\[0\].g_col\[1\].pe_hold2216 g_row\[0\].g_col\[1\].pe__2695_/Q VGND VGND VPWR
+ VPWR g_row\[0\].g_col\[1\].pe__2612_/B sky130_fd_sc_hd__clkbuf_2
Xg_row\[0\].g_col\[1\].pe_hold2205 g_row\[0\].g_col\[1\].pe__2697_/Q VGND VGND VPWR
+ VPWR g_row\[0\].g_col\[1\].pe_hold2205/X sky130_fd_sc_hd__clkbuf_2
Xg_row\[0\].g_col\[1\].pe__2722_ clkbuf_leaf_91_clk/X g_row\[0\].g_col\[1\].pe__2722_/D
+ VGND VGND VPWR VPWR g_row\[0\].g_col\[1\].pe__2722_/Q sky130_fd_sc_hd__dfxtp_2
Xg_row\[0\].g_col\[0\].pe__2706_ clkbuf_leaf_41_clk/X g_row\[0\].g_col\[0\].pe__2706_/D
+ VGND VGND VPWR VPWR hold3003/A sky130_fd_sc_hd__dfxtp_2
Xg_row\[1\].g_col\[1\].pe__1457_ g_row\[1\].g_col\[1\].pe__2731_/Q g_row\[1\].g_col\[1\].pe__1816_/A
+ VGND VGND VPWR VPWR g_row\[1\].g_col\[1\].pe__2163_/B sky130_fd_sc_hd__xor2_2
Xg_row\[0\].g_col\[1\].pe_hold2238 g_row\[0\].g_col\[1\].pe__2727_/Q VGND VGND VPWR
+ VPWR g_row\[0\].g_col\[1\].pe__1380_/A1 sky130_fd_sc_hd__clkbuf_2
XFILLER_24_811 VGND VGND VPWR VPWR sky130_fd_sc_hd__fill_1
Xg_row\[0\].g_col\[0\].pe__2637_ _282_/Q _281_/Q _284_/Q _283_/Q VGND VGND VPWR VPWR
+ g_row\[0\].g_col\[0\].pe__2637_/X sky130_fd_sc_hd__or4_2
Xg_row\[1\].g_col\[1\].pe__1388_ g_row\[1\].g_col\[1\].pe__1816_/A g_row\[1\].g_col\[1\].pe__1403_/A2
+ g_row\[1\].g_col\[1\].pe__1388_/B1 g_row\[1\].g_col\[1\].pe__2640_/C1 VGND VGND
+ VPWR VPWR g_row\[1\].g_col\[1\].pe__1388_/X sky130_fd_sc_hd__o211a_2
Xg_row\[0\].g_col\[1\].pe__2653_ g_row\[0\].g_col\[1\].pe__2661_/A hold2176/X VGND
+ VGND VPWR VPWR g_row\[0\].g_col\[1\].pe__2653_/X sky130_fd_sc_hd__or2_2
Xclkbuf_leaf_62_clk clkload5/A VGND VGND VPWR VPWR _294_/CLK sky130_fd_sc_hd__clkbuf_16
Xg_row\[0\].g_col\[1\].pe__1604_ g_row\[0\].g_col\[1\].pe__1604_/A g_row\[0\].g_col\[1\].pe__1604_/B
+ VGND VGND VPWR VPWR g_row\[0\].g_col\[1\].pe__1605_/B sky130_fd_sc_hd__or2_2
Xg_row\[0\].g_col\[1\].pe__2584_ g_row\[0\].g_col\[1\].pe__2585_/A g_row\[0\].g_col\[1\].pe__2585_/B
+ VGND VGND VPWR VPWR g_row\[0\].g_col\[1\].pe__2586_/B sky130_fd_sc_hd__nor2_2
XFILLER_51_663 VGND VGND VPWR VPWR sky130_fd_sc_hd__fill_1
Xg_row\[0\].g_col\[0\].pe__2568_ g_row\[0\].g_col\[0\].pe__2568_/A1 g_row\[0\].g_col\[0\].pe__2591_/A2
+ g_row\[0\].g_col\[0\].pe__2591_/B1 g_row\[0\].g_col\[0\].pe__2567_/X VGND VGND VPWR
+ VPWR g_row\[0\].g_col\[0\].pe__2568_/X sky130_fd_sc_hd__a22o_2
Xg_row\[0\].g_col\[1\].pe__1535_ g_row\[0\].g_col\[1\].pe__2736_/Q g_row\[0\].g_col\[1\].pe__1535_/B
+ VGND VGND VPWR VPWR g_row\[0\].g_col\[1\].pe__1546_/A sky130_fd_sc_hd__nand2_2
Xg_row\[0\].g_col\[0\].pe__1519_ g_row\[0\].g_col\[0\].pe__1785_/A g_row\[0\].g_col\[0\].pe__1519_/B
+ VGND VGND VPWR VPWR g_row\[0\].g_col\[0\].pe__1580_/B sky130_fd_sc_hd__xor2_2
Xg_row\[0\].g_col\[0\].pe__2499_ g_row\[0\].g_col\[0\].pe__2499_/A g_row\[0\].g_col\[0\].pe__2499_/B
+ VGND VGND VPWR VPWR g_row\[0\].g_col\[0\].pe__2501_/C sky130_fd_sc_hd__nor2_2
XTAP_TAPCELL_ROW_21_522 VGND VPWR sky130_fd_sc_hd__tapvpwrvgnd_1
Xg_row\[0\].g_col\[1\].pe__1466_ g_row\[0\].g_col\[1\].pe__1977_/A VGND VGND VPWR
+ VPWR g_row\[0\].g_col\[1\].pe__2348_/A sky130_fd_sc_hd__inv_2
Xg_row\[1\].g_col\[1\].pe__2009_ g_row\[1\].g_col\[1\].pe__2006_/A g_row\[1\].g_col\[1\].pe__2009_/B
+ g_row\[1\].g_col\[1\].pe__2009_/C VGND VGND VPWR VPWR g_row\[1\].g_col\[1\].pe__2010_/D
+ sky130_fd_sc_hd__and3b_2
Xg_row\[0\].g_col\[1\].pe__1397_ g_row\[0\].g_col\[1\].pe__1977_/A g_row\[0\].g_col\[1\].pe__2678_/A
+ g_row\[0\].g_col\[1\].pe__1396_/X g_row\[0\].g_col\[1\].pe__2679_/C1 VGND VGND VPWR
+ VPWR g_row\[0\].g_col\[1\].pe__1397_/X sky130_fd_sc_hd__o211a_2
XFILLER_3_726 VGND VGND VPWR VPWR sky130_fd_sc_hd__fill_2
Xg_row\[0\].g_col\[0\].pe_place978 g_row\[0\].g_col\[0\].pe__2348_/A VGND VGND VPWR
+ VPWR g_row\[0\].g_col\[0\].pe__1676_/A sky130_fd_sc_hd__buf_6
Xg_row\[0\].g_col\[0\].pe_place989 g_row\[0\].g_col\[0\].pe__1415_/Y VGND VGND VPWR
+ VPWR g_row\[0\].g_col\[0\].pe__1784_/A3 sky130_fd_sc_hd__buf_6
XTAP_TAPCELL_ROW_53_1004 VGND VPWR sky130_fd_sc_hd__tapvpwrvgnd_1
Xg_row\[0\].g_col\[1\].pe__2018_ g_row\[0\].g_col\[1\].pe__1978_/B g_row\[0\].g_col\[1\].pe__1978_/C
+ g_row\[0\].g_col\[1\].pe__1978_/A VGND VGND VPWR VPWR g_row\[0\].g_col\[1\].pe__2023_/A
+ sky130_fd_sc_hd__o21bai_2
XFILLER_59_741 VGND VGND VPWR VPWR sky130_fd_sc_hd__decap_3
XFILLER_58_251 VGND VGND VPWR VPWR sky130_fd_sc_hd__fill_1
XFILLER_76_67 VGND VGND VPWR VPWR sky130_fd_sc_hd__fill_1
XFILLER_59_785 VGND VGND VPWR VPWR sky130_fd_sc_hd__fill_2
XFILLER_46_457 VGND VGND VPWR VPWR sky130_fd_sc_hd__decap_3
XTAP_TAPCELL_ROW_29_644 VGND VPWR sky130_fd_sc_hd__tapvpwrvgnd_1
XFILLER_27_682 VGND VGND VPWR VPWR sky130_fd_sc_hd__decap_3
Xclkbuf_leaf_53_clk clkload8/A VGND VGND VPWR VPWR clkbuf_leaf_53_clk/X sky130_fd_sc_hd__clkbuf_16
XFILLER_42_652 VGND VGND VPWR VPWR sky130_fd_sc_hd__fill_2
XFILLER_42_663 VGND VGND VPWR VPWR sky130_fd_sc_hd__decap_3
XTAP_TAPCELL_ROW_64_1166 VGND VPWR sky130_fd_sc_hd__tapvpwrvgnd_1
XTAP_TAPCELL_ROW_64_1177 VGND VPWR sky130_fd_sc_hd__tapvpwrvgnd_1
X_335_ _339_/CLK _335_/D VGND VGND VPWR VPWR _335_/Q sky130_fd_sc_hd__dfxtp_2
Xclkbuf_4_6_0_clk clkbuf_0_clk/X VGND VGND VPWR VPWR clkbuf_4_6_0_clk/X sky130_fd_sc_hd__clkbuf_16
Xg_row\[1\].g_col\[0\].pe__1930_ g_row\[1\].g_col\[0\].pe__1994_/A g_row\[1\].g_col\[0\].pe__1994_/B
+ VGND VGND VPWR VPWR g_row\[1\].g_col\[0\].pe__1931_/B sky130_fd_sc_hd__xor2_2
X_197_ _205_/A _197_/B_N VGND VGND VPWR VPWR _197_/Y sky130_fd_sc_hd__nor2b_4
Xg_row\[1\].g_col\[0\].pe__1861_ place1086/X g_row\[1\].g_col\[0\].pe__2026_/B g_row\[1\].g_col\[0\].pe__1449_/Y
+ g_row\[1\].g_col\[0\].pe__2241_/B2 VGND VGND VPWR VPWR g_row\[1\].g_col\[0\].pe__1862_/B
+ sky130_fd_sc_hd__a22o_2
Xg_row\[1\].g_col\[0\].pe__1792_ g_row\[1\].g_col\[0\].pe__1792_/A VGND VGND VPWR
+ VPWR g_row\[1\].g_col\[0\].pe__1795_/A sky130_fd_sc_hd__inv_2
XFILLER_69_549 VGND VGND VPWR VPWR sky130_fd_sc_hd__decap_3
XFILLER_49_240 VGND VGND VPWR VPWR sky130_fd_sc_hd__decap_3
XPHY_EDGE_ROW_10_Right_10 VGND VGND VPWR VPWR sky130_fd_sc_hd__decap_3
Xg_row\[0\].g_col\[0\].pe__1870_ g_row\[0\].g_col\[0\].pe__2726_/Q g_row\[0\].g_col\[0\].pe__1870_/B
+ VGND VGND VPWR VPWR g_row\[0\].g_col\[0\].pe__1928_/B sky130_fd_sc_hd__xor2_2
Xg_row\[1\].g_col\[0\].pe__2413_ g_row\[1\].g_col\[0\].pe__2421_/A1 g_row\[1\].g_col\[0\].pe__2744_/Q
+ g_row\[1\].g_col\[0\].pe__2445_/B VGND VGND VPWR VPWR g_row\[1\].g_col\[0\].pe__2441_/B
+ sky130_fd_sc_hd__a21oi_2
Xg_row\[1\].g_col\[1\].pe__2360_ g_row\[1\].g_col\[1\].pe__2404_/A1 g_row\[1\].g_col\[1\].pe__2360_/A2
+ g_row\[1\].g_col\[1\].pe__2394_/B1 g_row\[1\].g_col\[1\].pe__2359_/Y VGND VGND VPWR
+ VPWR g_row\[1\].g_col\[1\].pe__2360_/X sky130_fd_sc_hd__o22a_2
Xg_row\[1\].g_col\[0\].pe__2344_ g_row\[1\].g_col\[0\].pe__2368_/A g_row\[1\].g_col\[0\].pe__2345_/B
+ VGND VGND VPWR VPWR g_row\[1\].g_col\[0\].pe__2346_/A sky130_fd_sc_hd__nand2_2
XFILLER_37_446 VGND VGND VPWR VPWR sky130_fd_sc_hd__fill_2
XTAP_TAPCELL_ROW_48_931 VGND VPWR sky130_fd_sc_hd__tapvpwrvgnd_1
Xg_row\[1\].g_col\[1\].pe__2291_ g_row\[1\].g_col\[1\].pe__2291_/A g_row\[1\].g_col\[1\].pe__2291_/B
+ VGND VGND VPWR VPWR g_row\[1\].g_col\[1\].pe__2327_/B sky130_fd_sc_hd__and2_2
XFILLER_24_107 VGND VGND VPWR VPWR sky130_fd_sc_hd__fill_2
XFILLER_80_725 VGND VGND VPWR VPWR sky130_fd_sc_hd__fill_2
Xg_row\[1\].g_col\[0\].pe__2275_ g_row\[1\].g_col\[0\].pe__2388_/A g_row\[1\].g_col\[0\].pe__2733_/Q
+ g_row\[1\].g_col\[0\].pe__2165_/A g_row\[1\].g_col\[0\].pe__2321_/A VGND VGND VPWR
+ VPWR g_row\[1\].g_col\[0\].pe__2276_/B sky130_fd_sc_hd__a211o_2
XFILLER_80_769 VGND VGND VPWR VPWR sky130_fd_sc_hd__fill_1
Xclkbuf_leaf_44_clk clkbuf_4_12_0_clk/X VGND VGND VPWR VPWR clkbuf_leaf_44_clk/X sky130_fd_sc_hd__clkbuf_16
Xg_row\[0\].g_col\[0\].pe__2422_ g_row\[0\].g_col\[0\].pe__2422_/A g_row\[0\].g_col\[0\].pe__2484_/A
+ VGND VGND VPWR VPWR g_row\[0\].g_col\[0\].pe__2424_/B sky130_fd_sc_hd__xnor2_2
Xg_row\[1\].g_col\[0\].pe_place1259 g_row\[1\].g_col\[0\].pe__2663_/A VGND VGND VPWR
+ VPWR g_row\[1\].g_col\[0\].pe__2404_/A1 sky130_fd_sc_hd__buf_6
XANTENNA_14 b_inputs_flat[10] VGND VGND VPWR VPWR sky130_fd_sc_hd__diode_2
Xg_row\[0\].g_col\[0\].pe__2353_ g_row\[0\].g_col\[0\].pe__2375_/A g_row\[0\].g_col\[0\].pe__2353_/B
+ VGND VGND VPWR VPWR g_row\[0\].g_col\[0\].pe__2355_/B sky130_fd_sc_hd__nor2_2
XANTENNA_25 b_inputs_flat[29] VGND VGND VPWR VPWR sky130_fd_sc_hd__diode_2
XANTENNA_36 hold3288/A VGND VGND VPWR VPWR sky130_fd_sc_hd__diode_2
XANTENNA_47 hold3143/A VGND VGND VPWR VPWR sky130_fd_sc_hd__diode_2
Xg_row\[0\].g_col\[0\].pe__2284_ g_row\[0\].g_col\[0\].pe__2284_/A g_row\[0\].g_col\[0\].pe__2284_/B
+ VGND VGND VPWR VPWR g_row\[0\].g_col\[0\].pe__2285_/B sky130_fd_sc_hd__nor2_2
XANTENNA_58 hold3168/A VGND VGND VPWR VPWR sky130_fd_sc_hd__diode_2
XANTENNA_69 hold3460/A VGND VGND VPWR VPWR sky130_fd_sc_hd__diode_2
XFILLER_0_729 VGND VGND VPWR VPWR sky130_fd_sc_hd__decap_3
XTAP_TAPCELL_ROW_7_317 VGND VPWR sky130_fd_sc_hd__tapvpwrvgnd_1
Xg_row\[1\].g_col\[1\].pe__2627_ place1247/X g_row\[1\].g_col\[1\].pe__2627_/B VGND
+ VGND VPWR VPWR g_row\[1\].g_col\[1\].pe__2627_/X sky130_fd_sc_hd__or2_2
Xg_row\[0\].g_col\[0\].pe__1999_ g_row\[0\].g_col\[0\].pe__1999_/A g_row\[0\].g_col\[0\].pe__1999_/B
+ VGND VGND VPWR VPWR g_row\[0\].g_col\[0\].pe__1999_/X sky130_fd_sc_hd__or2_2
Xhold2978 hold2978/A VGND VGND VPWR VPWR hold2978/X sky130_fd_sc_hd__clkbuf_2
Xg_row\[1\].g_col\[1\].pe__2558_ g_row\[1\].g_col\[1\].pe__2558_/A g_row\[1\].g_col\[1\].pe__2558_/B
+ VGND VGND VPWR VPWR g_row\[1\].g_col\[1\].pe__2559_/B sky130_fd_sc_hd__xor2_2
XFILLER_83_530 VGND VGND VPWR VPWR sky130_fd_sc_hd__fill_1
XFILLER_83_541 VGND VGND VPWR VPWR sky130_fd_sc_hd__fill_1
Xg_row\[1\].g_col\[1\].pe__1509_ g_row\[1\].g_col\[1\].pe__1535_/B g_row\[1\].g_col\[1\].pe__1549_/C
+ VGND VGND VPWR VPWR g_row\[1\].g_col\[1\].pe__1640_/B sky130_fd_sc_hd__xnor2_2
Xg_row\[0\].g_col\[1\].pe_hold2035 g_row\[0\].g_col\[1\].pe_hold2383/X VGND VGND VPWR
+ VPWR g_row\[0\].g_col\[1\].pe__2403_/A sky130_fd_sc_hd__clkbuf_2
XTAP_TAPCELL_ROW_26_603 VGND VPWR sky130_fd_sc_hd__tapvpwrvgnd_1
Xg_row\[1\].g_col\[1\].pe__2489_ g_row\[1\].g_col\[1\].pe__2474_/Y g_row\[1\].g_col\[1\].pe__2489_/B
+ g_row\[1\].g_col\[1\].pe__2492_/A VGND VGND VPWR VPWR g_row\[1\].g_col\[1\].pe__2490_/B
+ sky130_fd_sc_hd__and3b_2
Xg_row\[0\].g_col\[1\].pe__2705_ _307_/CLK g_row\[0\].g_col\[1\].pe__2705_/D VGND
+ VGND VPWR VPWR g_row\[0\].g_col\[1\].pe__2774_/A sky130_fd_sc_hd__dfxtp_2
XFILLER_43_427 VGND VGND VPWR VPWR sky130_fd_sc_hd__decap_3
XFILLER_43_449 VGND VGND VPWR VPWR sky130_fd_sc_hd__fill_2
Xg_row\[0\].g_col\[1\].pe__2636_ place1220/X place1221/X place1216/X place1217/X VGND
+ VGND VPWR VPWR g_row\[0\].g_col\[1\].pe__2636_/X sky130_fd_sc_hd__or4_2
Xclkbuf_leaf_35_clk clkload6/A VGND VGND VPWR VPWR clkbuf_leaf_35_clk/X sky130_fd_sc_hd__clkbuf_16
XFILLER_12_836 VGND VGND VPWR VPWR sky130_fd_sc_hd__fill_2
XFILLER_62_69 VGND VGND VPWR VPWR sky130_fd_sc_hd__fill_1
Xg_row\[0\].g_col\[1\].pe__2567_ g_row\[0\].g_col\[1\].pe__2567_/A g_row\[0\].g_col\[1\].pe__2586_/A
+ VGND VGND VPWR VPWR g_row\[0\].g_col\[1\].pe__2567_/X sky130_fd_sc_hd__or2_2
XFILLER_8_807 VGND VGND VPWR VPWR sky130_fd_sc_hd__decap_3
Xg_row\[0\].g_col\[1\].pe__1518_ g_row\[0\].g_col\[1\].pe__1970_/A g_row\[0\].g_col\[1\].pe__1729_/A2
+ g_row\[0\].g_col\[1\].pe__1729_/A3 g_row\[0\].g_col\[1\].pe__1729_/B1 g_row\[0\].g_col\[1\].pe__2030_/A
+ VGND VGND VPWR VPWR g_row\[0\].g_col\[1\].pe__1519_/B sky130_fd_sc_hd__a32o_2
Xg_row\[0\].g_col\[1\].pe_place1236 g_row\[0\].g_col\[1\].pe__2663_/A VGND VGND VPWR
+ VPWR g_row\[0\].g_col\[1\].pe__2669_/A sky130_fd_sc_hd__buf_6
Xg_row\[0\].g_col\[1\].pe__2498_ g_row\[0\].g_col\[1\].pe__2519_/A g_row\[0\].g_col\[1\].pe__2519_/B
+ VGND VGND VPWR VPWR g_row\[0\].g_col\[1\].pe__2499_/B sky130_fd_sc_hd__or2_2
Xg_row\[0\].g_col\[1\].pe__1449_ g_row\[0\].g_col\[1\].pe__1449_/A g_row\[0\].g_col\[1\].pe__1449_/B
+ VGND VGND VPWR VPWR g_row\[0\].g_col\[1\].pe__1449_/Y sky130_fd_sc_hd__nand2_2
XFILLER_78_324 VGND VGND VPWR VPWR sky130_fd_sc_hd__fill_1
Xg_row\[1\].g_col\[0\].pe_hold1919 g_row\[1\].g_col\[0\].pe__2445_/A VGND VGND VPWR
+ VPWR g_row\[1\].g_col\[0\].pe__2114_/A2 sky130_fd_sc_hd__clkbuf_2
XFILLER_19_446 VGND VGND VPWR VPWR sky130_fd_sc_hd__fill_2
XFILLER_34_405 VGND VGND VPWR VPWR sky130_fd_sc_hd__decap_3
XFILLER_74_552 VGND VGND VPWR VPWR sky130_fd_sc_hd__decap_3
XTAP_TAPCELL_ROW_66_1206 VGND VPWR sky130_fd_sc_hd__tapvpwrvgnd_1
XFILLER_15_630 VGND VGND VPWR VPWR sky130_fd_sc_hd__decap_3
XFILLER_27_490 VGND VGND VPWR VPWR sky130_fd_sc_hd__decap_3
Xg_row\[1\].g_col\[0\].pe__2060_ g_row\[1\].g_col\[0\].pe__2153_/A g_row\[1\].g_col\[0\].pe__2153_/B
+ VGND VGND VPWR VPWR g_row\[1\].g_col\[0\].pe__2150_/C sky130_fd_sc_hd__xor2_2
XFILLER_62_769 VGND VGND VPWR VPWR sky130_fd_sc_hd__fill_1
Xclkbuf_leaf_26_clk clkload3/A VGND VGND VPWR VPWR _277_/CLK sky130_fd_sc_hd__clkbuf_16
XFILLER_30_655 VGND VGND VPWR VPWR sky130_fd_sc_hd__decap_3
XFILLER_30_688 VGND VGND VPWR VPWR sky130_fd_sc_hd__decap_3
X_318_ _318_/CLK _318_/D VGND VGND VPWR VPWR _318_/Q sky130_fd_sc_hd__dfxtp_2
XTAP_TAPCELL_ROW_12_385 VGND VPWR sky130_fd_sc_hd__tapvpwrvgnd_1
XTAP_TAPCELL_ROW_12_396 VGND VPWR sky130_fd_sc_hd__tapvpwrvgnd_1
X_249_ _269_/A _249_/B_N VGND VGND VPWR VPWR _249_/Y sky130_fd_sc_hd__nor2b_4
Xg_row\[1\].g_col\[0\].pe__1913_ g_row\[1\].g_col\[0\].pe__1955_/A g_row\[1\].g_col\[0\].pe__1955_/B
+ VGND VGND VPWR VPWR g_row\[1\].g_col\[0\].pe__1916_/A sky130_fd_sc_hd__xor2_2
Xg_row\[1\].g_col\[1\].pe__1860_ g_row\[1\].g_col\[1\].pe__1860_/A g_row\[1\].g_col\[1\].pe__1860_/B
+ VGND VGND VPWR VPWR g_row\[1\].g_col\[1\].pe__1882_/A sky130_fd_sc_hd__xor2_2
Xg_row\[1\].g_col\[0\].pe__1844_ g_row\[1\].g_col\[0\].pe__1844_/A g_row\[1\].g_col\[0\].pe__1844_/B
+ VGND VGND VPWR VPWR g_row\[1\].g_col\[0\].pe__1894_/A sky130_fd_sc_hd__and2_2
XTAP_TAPCELL_ROW_77_1368 VGND VPWR sky130_fd_sc_hd__tapvpwrvgnd_1
XFILLER_42_3 VGND VGND VPWR VPWR sky130_fd_sc_hd__fill_1
Xg_row\[1\].g_col\[1\].pe__1791_ g_row\[1\].g_col\[1\].pe__1791_/A g_row\[1\].g_col\[1\].pe__1797_/A
+ VGND VGND VPWR VPWR g_row\[1\].g_col\[1\].pe__1792_/A sky130_fd_sc_hd__nor2_2
Xg_row\[1\].g_col\[0\].pe__1775_ place1106/X g_row\[1\].g_col\[0\].pe__1748_/B g_row\[1\].g_col\[0\].pe__1760_/B
+ g_row\[1\].g_col\[0\].pe__1774_/Y VGND VGND VPWR VPWR g_row\[1\].g_col\[0\].pe__1777_/A
+ sky130_fd_sc_hd__a31o_2
XTAP_TAPCELL_ROW_90_1557 VGND VPWR sky130_fd_sc_hd__tapvpwrvgnd_1
XFILLER_57_508 VGND VGND VPWR VPWR sky130_fd_sc_hd__fill_1
Xg_row\[0\].g_col\[0\].pe__1922_ g_row\[0\].g_col\[0\].pe__2083_/A VGND VGND VPWR
+ VPWR g_row\[0\].g_col\[0\].pe__1922_/Y sky130_fd_sc_hd__inv_2
Xhold1507 hold3313/X VGND VGND VPWR VPWR hold3314/A sky130_fd_sc_hd__clkbuf_2
XFILLER_85_839 VGND VGND VPWR VPWR sky130_fd_sc_hd__fill_1
Xg_row\[0\].g_col\[0\].pe__1853_ place1218/A g_row\[0\].g_col\[0\].pe__2363_/A2 g_row\[0\].g_col\[0\].pe__2388_/B
+ hold2363/A VGND VGND VPWR VPWR g_row\[0\].g_col\[0\].pe__1857_/A sky130_fd_sc_hd__a22o_2
Xhold1518 hold2568/X VGND VGND VPWR VPWR hold2569/A sky130_fd_sc_hd__clkbuf_2
Xhold1529 hold3401/X VGND VGND VPWR VPWR hold3402/A sky130_fd_sc_hd__clkbuf_2
Xg_row\[1\].g_col\[1\].pe__2412_ g_row\[1\].g_col\[1\].pe__2743_/Q g_row\[1\].g_col\[1\].pe__2742_/Q
+ g_row\[1\].g_col\[1\].pe__2741_/Q g_row\[1\].g_col\[1\].pe__2455_/B g_row\[1\].g_col\[1\].pe__2450_/A1
+ VGND VGND VPWR VPWR g_row\[1\].g_col\[1\].pe__2445_/B sky130_fd_sc_hd__o41a_2
XFILLER_65_541 VGND VGND VPWR VPWR sky130_fd_sc_hd__decap_3
Xg_row\[1\].g_col\[1\].pe__2343_ g_row\[1\].g_col\[1\].pe__2343_/A g_row\[1\].g_col\[1\].pe__2365_/A
+ VGND VGND VPWR VPWR g_row\[1\].g_col\[1\].pe__2345_/B sky130_fd_sc_hd__xor2_2
XFILLER_53_725 VGND VGND VPWR VPWR sky130_fd_sc_hd__decap_3
Xg_row\[0\].g_col\[0\].pe__1784_ place1223/A g_row\[0\].g_col\[0\].pe__1784_/A2 g_row\[0\].g_col\[0\].pe__1784_/A3
+ g_row\[0\].g_col\[0\].pe__1784_/B1 hold2363/A VGND VGND VPWR VPWR g_row\[0\].g_col\[0\].pe__1785_/B
+ sky130_fd_sc_hd__a32o_2
Xg_row\[1\].g_col\[0\].pe__2327_ g_row\[1\].g_col\[0\].pe__2327_/A g_row\[1\].g_col\[0\].pe__2327_/B
+ g_row\[1\].g_col\[0\].pe__2327_/C VGND VGND VPWR VPWR g_row\[1\].g_col\[0\].pe__2328_/B
+ sky130_fd_sc_hd__nor3_2
XFILLER_16_29 VGND VGND VPWR VPWR sky130_fd_sc_hd__fill_2
XFILLER_65_585 VGND VGND VPWR VPWR sky130_fd_sc_hd__decap_3
Xg_row\[1\].g_col\[1\].pe__2274_ g_row\[1\].g_col\[1\].pe__2125_/A g_row\[1\].g_col\[1\].pe__2733_/Q
+ g_row\[1\].g_col\[1\].pe__1673_/A g_row\[1\].g_col\[1\].pe__2734_/Q VGND VGND VPWR
+ VPWR g_row\[1\].g_col\[1\].pe__2318_/A sky130_fd_sc_hd__o211a_2
Xg_row\[1\].g_col\[0\].pe__2258_ g_row\[1\].g_col\[0\].pe__2258_/A g_row\[1\].g_col\[0\].pe__2258_/B
+ VGND VGND VPWR VPWR g_row\[1\].g_col\[0\].pe__2258_/X sky130_fd_sc_hd__and2_2
Xclkbuf_leaf_17_clk clkbuf_4_4_0_clk/X VGND VGND VPWR VPWR _291_/CLK sky130_fd_sc_hd__clkbuf_16
Xg_row\[0\].g_col\[0\].pe__2405_ place1268/X g_row\[0\].g_col\[0\].pe__2405_/B VGND
+ VGND VPWR VPWR g_row\[0\].g_col\[0\].pe__2755_/D sky130_fd_sc_hd__nor2_2
Xg_row\[1\].g_col\[0\].pe_place1078 hold1989/A VGND VGND VPWR VPWR g_row\[1\].g_col\[0\].pe__2163_/A
+ sky130_fd_sc_hd__buf_6
Xg_row\[1\].g_col\[0\].pe_place1067 g_row\[1\].g_col\[0\].pe__1924_/A VGND VGND VPWR
+ VPWR g_row\[1\].g_col\[0\].pe__1789_/A sky130_fd_sc_hd__buf_6
Xg_row\[1\].g_col\[0\].pe__2189_ g_row\[1\].g_col\[0\].pe__2190_/A g_row\[1\].g_col\[0\].pe__2190_/B
+ VGND VGND VPWR VPWR g_row\[1\].g_col\[0\].pe__2191_/A sky130_fd_sc_hd__and2_4
Xg_row\[0\].g_col\[1\].pe__2421_ g_row\[0\].g_col\[1\].pe__2421_/A1 g_row\[0\].g_col\[1\].pe__2752_/Q
+ g_row\[0\].g_col\[1\].pe__2426_/B VGND VGND VPWR VPWR g_row\[0\].g_col\[1\].pe__2484_/A
+ sky130_fd_sc_hd__a21o_2
Xg_row\[0\].g_col\[0\].pe__2336_ g_row\[0\].g_col\[0\].pe__2336_/A VGND VGND VPWR
+ VPWR g_row\[0\].g_col\[0\].pe__2336_/Y sky130_fd_sc_hd__inv_2
Xg_row\[0\].g_col\[0\].pe_hold2280 _311_/Q VGND VGND VPWR VPWR g_row\[0\].g_col\[0\].pe_hold2280/X
+ sky130_fd_sc_hd__clkbuf_2
Xg_row\[0\].g_col\[1\].pe__2352_ g_row\[0\].g_col\[1\].pe__2352_/A g_row\[0\].g_col\[1\].pe__2352_/B
+ g_row\[0\].g_col\[1\].pe__2352_/C VGND VGND VPWR VPWR g_row\[0\].g_col\[1\].pe__2353_/B
+ sky130_fd_sc_hd__and3_2
XFILLER_21_666 VGND VGND VPWR VPWR sky130_fd_sc_hd__decap_3
Xg_row\[0\].g_col\[0\].pe_hold2291 g_row\[0\].g_col\[0\].pe__1383_/A VGND VGND VPWR
+ VPWR g_row\[0\].g_col\[0\].pe__2652_/A2 sky130_fd_sc_hd__clkbuf_2
Xg_row\[0\].g_col\[1\].pe_place861 g_row\[0\].g_col\[1\].pe__1449_/Y VGND VGND VPWR
+ VPWR g_row\[0\].g_col\[1\].pe__1738_/B1 sky130_fd_sc_hd__buf_6
XTAP_TAPCELL_ROW_31_672 VGND VPWR sky130_fd_sc_hd__tapvpwrvgnd_1
Xg_row\[0\].g_col\[0\].pe__2267_ g_row\[0\].g_col\[0\].pe__2264_/X g_row\[0\].g_col\[0\].pe__2265_/Y
+ g_row\[0\].g_col\[0\].pe__2267_/B1 g_row\[0\].g_col\[0\].pe__2599_/A VGND VGND VPWR
+ VPWR g_row\[0\].g_col\[0\].pe__2268_/B sky130_fd_sc_hd__o2bb2a_2
Xg_row\[0\].g_col\[1\].pe__2283_ g_row\[0\].g_col\[1\].pe__2283_/A g_row\[0\].g_col\[1\].pe__2283_/B
+ VGND VGND VPWR VPWR g_row\[0\].g_col\[1\].pe__2284_/B sky130_fd_sc_hd__and2_2
Xg_row\[0\].g_col\[0\].pe__2198_ g_row\[0\].g_col\[0\].pe__2599_/A ANTENNA_153/DIODE
+ g_row\[0\].g_col\[0\].pe__2196_/X g_row\[0\].g_col\[0\].pe__2197_/Y VGND VGND VPWR
+ VPWR g_row\[0\].g_col\[0\].pe__2198_/X sky130_fd_sc_hd__o22a_2
XFILLER_88_600 VGND VGND VPWR VPWR sky130_fd_sc_hd__fill_2
Xg_row\[1\].g_col\[1\].pe__1989_ g_row\[1\].g_col\[1\].pe__1919_/B g_row\[1\].g_col\[1\].pe__1980_/X
+ g_row\[1\].g_col\[1\].pe__1981_/Y g_row\[1\].g_col\[1\].pe__1987_/Y g_row\[1\].g_col\[1\].pe__1988_/X
+ VGND VGND VPWR VPWR g_row\[1\].g_col\[1\].pe__1991_/C sky130_fd_sc_hd__a311o_2
Xhold3410 a_inputs_flat[5] VGND VGND VPWR VPWR hold3410/X sky130_fd_sc_hd__clkbuf_2
Xoutput1360 output1360/A VGND VGND VPWR VPWR results_flat[14] sky130_fd_sc_hd__buf_2
Xhold3443 hold3443/A VGND VGND VPWR VPWR hold3443/X sky130_fd_sc_hd__clkbuf_2
Xhold3432 hold3432/A VGND VGND VPWR VPWR hold3432/X sky130_fd_sc_hd__clkbuf_2
Xhold3421 hold3421/A VGND VGND VPWR VPWR hold3421/X sky130_fd_sc_hd__clkbuf_2
Xhold2720 hold3515/X VGND VGND VPWR VPWR hold3516/A sky130_fd_sc_hd__clkbuf_2
Xhold2731 hold2731/A VGND VGND VPWR VPWR _302_/D sky130_fd_sc_hd__clkbuf_2
Xoutput1393 output1393/A VGND VGND VPWR VPWR results_flat[44] sky130_fd_sc_hd__buf_2
Xoutput1382 output1382/A VGND VGND VPWR VPWR results_flat[34] sky130_fd_sc_hd__buf_2
Xoutput1371 output1371/A VGND VGND VPWR VPWR results_flat[24] sky130_fd_sc_hd__buf_2
Xhold3476 hold3476/A VGND VGND VPWR VPWR hold3476/X sky130_fd_sc_hd__clkbuf_2
Xhold3465 hold3465/A VGND VGND VPWR VPWR hold3465/X sky130_fd_sc_hd__clkbuf_2
Xhold3454 hold3454/A VGND VGND VPWR VPWR hold3454/X sky130_fd_sc_hd__clkbuf_2
Xhold2742 _139_/Y VGND VGND VPWR VPWR hold2742/X sky130_fd_sc_hd__clkbuf_2
Xhold2753 hold3514/X VGND VGND VPWR VPWR _145_/B_N sky130_fd_sc_hd__clkbuf_2
Xhold2764 hold3539/X VGND VGND VPWR VPWR hold3540/A sky130_fd_sc_hd__clkbuf_2
Xhold3498 hold3498/A VGND VGND VPWR VPWR hold3498/X sky130_fd_sc_hd__clkbuf_2
Xhold3487 b_inputs_flat[13] VGND VGND VPWR VPWR hold3487/X sky130_fd_sc_hd__clkbuf_2
XFILLER_29_733 VGND VGND VPWR VPWR sky130_fd_sc_hd__fill_1
Xhold2775 hold3555/X VGND VGND VPWR VPWR hold3556/A sky130_fd_sc_hd__clkbuf_2
Xhold2786 hold3565/X VGND VGND VPWR VPWR hold3566/A sky130_fd_sc_hd__clkbuf_2
Xhold2797 hold2797/A VGND VGND VPWR VPWR _305_/D sky130_fd_sc_hd__clkbuf_2
XFILLER_56_552 VGND VGND VPWR VPWR sky130_fd_sc_hd__fill_1
Xg_row\[0\].g_col\[1\].pe__1998_ g_row\[0\].g_col\[1\].pe__1999_/A g_row\[0\].g_col\[1\].pe__1999_/B
+ VGND VGND VPWR VPWR g_row\[0\].g_col\[1\].pe__1998_/X sky130_fd_sc_hd__and2_2
XFILLER_83_393 VGND VGND VPWR VPWR sky130_fd_sc_hd__decap_3
XTAP_TAPCELL_ROW_39_794 VGND VPWR sky130_fd_sc_hd__tapvpwrvgnd_1
XFILLER_73_57 VGND VGND VPWR VPWR sky130_fd_sc_hd__fill_2
Xg_row\[0\].g_col\[1\].pe__2619_ g_row\[0\].g_col\[1\].pe__2633_/A1 place1205/X g_row\[0\].g_col\[1\].pe__2626_/B1
+ g_row\[0\].g_col\[1\].pe__2619_/C1 VGND VGND VPWR VPWR g_row\[0\].g_col\[1\].pe__2619_/X
+ sky130_fd_sc_hd__o211a_2
XTAP_TAPCELL_ROW_61_1125 VGND VPWR sky130_fd_sc_hd__tapvpwrvgnd_1
XFILLER_8_626 VGND VGND VPWR VPWR sky130_fd_sc_hd__decap_3
XFILLER_12_699 VGND VGND VPWR VPWR sky130_fd_sc_hd__fill_1
XFILLER_7_169 VGND VGND VPWR VPWR sky130_fd_sc_hd__fill_2
XTAP_TAPCELL_ROW_59_1098 VGND VPWR sky130_fd_sc_hd__tapvpwrvgnd_1
Xg_row\[1\].g_col\[0\].pe_hold3107 g_row\[1\].g_col\[0\].pe__2743_/Q VGND VGND VPWR
+ VPWR g_row\[1\].g_col\[0\].pe_hold3107/X sky130_fd_sc_hd__clkbuf_2
XFILLER_3_364 VGND VGND VPWR VPWR sky130_fd_sc_hd__fill_1
Xg_row\[1\].g_col\[0\].pe__1560_ g_row\[1\].g_col\[0\].pe__1607_/A g_row\[1\].g_col\[0\].pe__1560_/B
+ VGND VGND VPWR VPWR g_row\[1\].g_col\[0\].pe__1562_/C sky130_fd_sc_hd__and2_2
XFILLER_39_519 VGND VGND VPWR VPWR sky130_fd_sc_hd__fill_2
XFILLER_93_113 VGND VGND VPWR VPWR sky130_fd_sc_hd__fill_2
XTAP_TAPCELL_ROW_72_1287 VGND VPWR sky130_fd_sc_hd__tapvpwrvgnd_1
Xg_row\[1\].g_col\[0\].pe_hold1727 g_row\[1\].g_col\[0\].pe_hold3086/X VGND VGND VPWR
+ VPWR g_row\[1\].g_col\[0\].pe__2729_/D sky130_fd_sc_hd__clkbuf_2
Xg_row\[1\].g_col\[0\].pe__1491_ g_row\[1\].g_col\[0\].pe__1512_/A g_row\[1\].g_col\[0\].pe__1512_/B
+ VGND VGND VPWR VPWR g_row\[1\].g_col\[0\].pe__1500_/A sky130_fd_sc_hd__xor2_2
XFILLER_47_574 VGND VGND VPWR VPWR sky130_fd_sc_hd__decap_3
XFILLER_34_224 VGND VGND VPWR VPWR sky130_fd_sc_hd__decap_3
XFILLER_62_533 VGND VGND VPWR VPWR sky130_fd_sc_hd__decap_3
Xg_row\[1\].g_col\[0\].pe__2112_ g_row\[1\].g_col\[0\].pe__2066_/Y g_row\[1\].g_col\[0\].pe__2061_/Y
+ g_row\[1\].g_col\[0\].pe__2111_/X VGND VGND VPWR VPWR g_row\[1\].g_col\[0\].pe__2112_/Y
+ sky130_fd_sc_hd__a21oi_2
XFILLER_62_555 VGND VGND VPWR VPWR sky130_fd_sc_hd__decap_3
Xg_row\[1\].g_col\[0\].pe__2043_ g_row\[1\].g_col\[0\].pe__2043_/A g_row\[1\].g_col\[0\].pe__2043_/B
+ VGND VGND VPWR VPWR g_row\[1\].g_col\[0\].pe__2044_/B sky130_fd_sc_hd__nand2_2
XTAP_TAPCELL_ROW_17_466 VGND VPWR sky130_fd_sc_hd__tapvpwrvgnd_1
XFILLER_30_474 VGND VGND VPWR VPWR sky130_fd_sc_hd__fill_2
XFILLER_8_85 VGND VGND VPWR VPWR sky130_fd_sc_hd__decap_3
Xg_row\[0\].g_col\[0\].pe__2121_ g_row\[0\].g_col\[0\].pe__2121_/A g_row\[0\].g_col\[0\].pe__2163_/B
+ VGND VGND VPWR VPWR g_row\[0\].g_col\[0\].pe__2123_/B sky130_fd_sc_hd__nand2_2
Xg_row\[0\].g_col\[0\].pe__2052_ g_row\[0\].g_col\[0\].pe__2052_/A g_row\[0\].g_col\[0\].pe__2052_/B
+ g_row\[0\].g_col\[0\].pe__2052_/C VGND VGND VPWR VPWR g_row\[0\].g_col\[0\].pe__2054_/A
+ sky130_fd_sc_hd__or3_4
Xg_row\[1\].g_col\[1\].pe__1912_ g_row\[1\].g_col\[1\].pe__2165_/A g_row\[1\].g_col\[1\].pe__1912_/B
+ VGND VGND VPWR VPWR g_row\[1\].g_col\[1\].pe__1955_/B sky130_fd_sc_hd__xnor2_2
Xclkbuf_leaf_6_clk clkload0/A VGND VGND VPWR VPWR clkbuf_leaf_6_clk/X sky130_fd_sc_hd__clkbuf_16
Xg_row\[1\].g_col\[1\].pe__1843_ g_row\[1\].g_col\[1\].pe__1843_/A g_row\[1\].g_col\[1\].pe__1843_/B
+ VGND VGND VPWR VPWR g_row\[1\].g_col\[1\].pe__1891_/A sky130_fd_sc_hd__nand2_2
Xg_row\[1\].g_col\[0\].pe__1827_ g_row\[1\].g_col\[0\].pe__1827_/A g_row\[1\].g_col\[0\].pe__1827_/B
+ VGND VGND VPWR VPWR g_row\[1\].g_col\[0\].pe__1827_/Y sky130_fd_sc_hd__nand2_2
Xg_row\[1\].g_col\[1\].pe__1774_ g_row\[1\].g_col\[1\].pe__1774_/A g_row\[1\].g_col\[1\].pe__1774_/B
+ VGND VGND VPWR VPWR g_row\[1\].g_col\[1\].pe__1774_/Y sky130_fd_sc_hd__nor2_2
Xg_row\[1\].g_col\[0\].pe__1758_ g_row\[1\].g_col\[0\].pe__1758_/A g_row\[1\].g_col\[0\].pe__1758_/B
+ VGND VGND VPWR VPWR g_row\[1\].g_col\[0\].pe__1774_/B sky130_fd_sc_hd__xnor2_2
XFILLER_58_817 VGND VGND VPWR VPWR sky130_fd_sc_hd__fill_2
XFILLER_57_327 VGND VGND VPWR VPWR sky130_fd_sc_hd__fill_1
XFILLER_69_165 VGND VGND VPWR VPWR sky130_fd_sc_hd__decap_3
Xg_row\[0\].g_col\[0\].pe__1905_ g_row\[0\].g_col\[0\].pe__1905_/A g_row\[0\].g_col\[0\].pe__1905_/B
+ VGND VGND VPWR VPWR g_row\[0\].g_col\[0\].pe__1906_/B sky130_fd_sc_hd__or2_2
Xg_row\[1\].g_col\[0\].pe__1689_ g_row\[1\].g_col\[0\].pe__1721_/A g_row\[1\].g_col\[0\].pe__1721_/B
+ VGND VGND VPWR VPWR g_row\[1\].g_col\[0\].pe__1689_/Y sky130_fd_sc_hd__nand2_2
Xg_row\[0\].g_col\[1\].pe__1921_ g_row\[0\].g_col\[1\].pe__2121_/A g_row\[0\].g_col\[1\].pe__1982_/B
+ VGND VGND VPWR VPWR g_row\[0\].g_col\[1\].pe__1924_/B sky130_fd_sc_hd__and2_2
XFILLER_85_658 VGND VGND VPWR VPWR sky130_fd_sc_hd__decap_3
Xg_row\[1\].g_col\[0\].pe_hold2973 _297_/Q VGND VGND VPWR VPWR g_row\[1\].g_col\[0\].pe_hold2973/X
+ sky130_fd_sc_hd__clkbuf_2
Xg_row\[0\].g_col\[1\].pe__1852_ g_row\[0\].g_col\[1\].pe__1615_/A g_row\[0\].g_col\[1\].pe__1615_/B
+ g_row\[0\].g_col\[1\].pe__1851_/X VGND VGND VPWR VPWR g_row\[0\].g_col\[1\].pe__1859_/A
+ sky130_fd_sc_hd__a21o_2
Xg_row\[0\].g_col\[0\].pe__1836_ g_row\[0\].g_col\[0\].pe__2595_/A g_row\[0\].g_col\[0\].pe__1836_/B
+ VGND VGND VPWR VPWR g_row\[0\].g_col\[0\].pe__1836_/X sky130_fd_sc_hd__and2_2
XFILLER_38_596 VGND VGND VPWR VPWR sky130_fd_sc_hd__fill_2
XFILLER_65_393 VGND VGND VPWR VPWR sky130_fd_sc_hd__fill_2
Xg_row\[0\].g_col\[0\].pe__1767_ place1223/X g_row\[0\].g_col\[0\].pe__1982_/B VGND
+ VGND VPWR VPWR g_row\[0\].g_col\[0\].pe__1768_/B sky130_fd_sc_hd__nand2_2
Xg_row\[1\].g_col\[1\].pe__2326_ g_row\[1\].g_col\[1\].pe__2327_/A g_row\[1\].g_col\[1\].pe__2327_/B
+ g_row\[1\].g_col\[1\].pe__2327_/C VGND VGND VPWR VPWR g_row\[1\].g_col\[1\].pe__2355_/A
+ sky130_fd_sc_hd__o21a_2
Xg_row\[0\].g_col\[1\].pe__1783_ g_row\[0\].g_col\[1\].pe__1808_/A g_row\[0\].g_col\[1\].pe__1783_/B
+ VGND VGND VPWR VPWR g_row\[0\].g_col\[1\].pe__1796_/A sky130_fd_sc_hd__xnor2_2
XTAP_TAPCELL_ROW_36_753 VGND VPWR sky130_fd_sc_hd__tapvpwrvgnd_1
Xg_row\[1\].g_col\[1\].pe__2257_ g_row\[1\].g_col\[1\].pe__2257_/A g_row\[1\].g_col\[1\].pe__2272_/B
+ VGND VGND VPWR VPWR g_row\[1\].g_col\[1\].pe__2330_/A sky130_fd_sc_hd__xor2_2
XFILLER_80_363 VGND VGND VPWR VPWR sky130_fd_sc_hd__fill_1
Xg_row\[0\].g_col\[0\].pe__1698_ g_row\[0\].g_col\[0\].pe__1698_/A g_row\[0\].g_col\[0\].pe__1699_/B
+ VGND VGND VPWR VPWR g_row\[0\].g_col\[0\].pe__1823_/B sky130_fd_sc_hd__xnor2_2
Xg_row\[1\].g_col\[1\].pe__2188_ g_row\[1\].g_col\[1\].pe__2143_/A g_row\[1\].g_col\[1\].pe__2143_/B
+ g_row\[1\].g_col\[1\].pe__2187_/X VGND VGND VPWR VPWR g_row\[1\].g_col\[1\].pe__2190_/B
+ sky130_fd_sc_hd__a21oi_2
Xg_row\[0\].g_col\[1\].pe__2404_ g_row\[0\].g_col\[1\].pe__2406_/B1 g_row\[0\].g_col\[1\].pe__2403_/Y
+ g_row\[0\].g_col\[1\].pe__2404_/B1 g_row\[0\].g_col\[1\].pe__2404_/B2 VGND VGND
+ VPWR VPWR g_row\[0\].g_col\[1\].pe__2404_/X sky130_fd_sc_hd__o22a_2
Xg_row\[0\].g_col\[0\].pe__2319_ g_row\[0\].g_col\[0\].pe__2319_/A g_row\[0\].g_col\[0\].pe__2319_/B
+ VGND VGND VPWR VPWR g_row\[0\].g_col\[0\].pe__2348_/B sky130_fd_sc_hd__xor2_2
Xg_row\[0\].g_col\[1\].pe__2335_ g_row\[0\].g_col\[1\].pe__2405_/A g_row\[0\].g_col\[1\].pe__2335_/B
+ VGND VGND VPWR VPWR g_row\[0\].g_col\[1\].pe__2750_/D sky130_fd_sc_hd__nor2_2
Xg_row\[0\].g_col\[1\].pe__2266_ g_row\[0\].g_col\[1\].pe__2266_/A VGND VGND VPWR
+ VPWR g_row\[0\].g_col\[1\].pe__2266_/Y sky130_fd_sc_hd__inv_2
Xg_row\[1\].g_col\[1\].pe_hold1813 g_row\[1\].g_col\[1\].pe__2568_/X VGND VGND VPWR
+ VPWR g_row\[1\].g_col\[1\].pe__2569_/B sky130_fd_sc_hd__clkbuf_2
Xg_row\[0\].g_col\[1\].pe__2197_ g_row\[0\].g_col\[1\].pe__2161_/Y g_row\[0\].g_col\[1\].pe__2157_/B
+ g_row\[0\].g_col\[1\].pe__2200_/B VGND VGND VPWR VPWR g_row\[0\].g_col\[1\].pe__2197_/Y
+ sky130_fd_sc_hd__a21oi_2
XFILLER_88_452 VGND VGND VPWR VPWR sky130_fd_sc_hd__fill_2
Xhold3240 hold3240/A VGND VGND VPWR VPWR hold3240/X sky130_fd_sc_hd__clkbuf_2
Xhold3251 hold3251/A VGND VGND VPWR VPWR hold3251/X sky130_fd_sc_hd__clkbuf_2
XFILLER_49_839 VGND VGND VPWR VPWR sky130_fd_sc_hd__fill_1
XFILLER_76_614 VGND VGND VPWR VPWR sky130_fd_sc_hd__fill_1
Xhold3262 hold3262/A VGND VGND VPWR VPWR hold3262/X sky130_fd_sc_hd__clkbuf_2
Xhold3273 hold3273/A VGND VGND VPWR VPWR hold3273/X sky130_fd_sc_hd__clkbuf_2
Xhold3284 b_inputs_flat[15] VGND VGND VPWR VPWR hold3284/X sky130_fd_sc_hd__clkbuf_2
XFILLER_76_636 VGND VGND VPWR VPWR sky130_fd_sc_hd__decap_3
Xhold2550 _271_/Y VGND VGND VPWR VPWR hold2550/X sky130_fd_sc_hd__clkbuf_2
Xhold2561 hold3332/X VGND VGND VPWR VPWR _207_/B_N sky130_fd_sc_hd__clkbuf_2
Xhold2572 hold3267/X VGND VGND VPWR VPWR hold3268/A sky130_fd_sc_hd__clkbuf_2
Xhold2583 hold3356/X VGND VGND VPWR VPWR hold3357/A sky130_fd_sc_hd__clkbuf_2
Xhold3295 hold3295/A VGND VGND VPWR VPWR hold3295/X sky130_fd_sc_hd__clkbuf_2
Xhold2594 hold3389/X VGND VGND VPWR VPWR hold3390/A sky130_fd_sc_hd__clkbuf_2
XFILLER_17_50 VGND VGND VPWR VPWR sky130_fd_sc_hd__fill_2
XFILLER_17_725 VGND VGND VPWR VPWR sky130_fd_sc_hd__decap_3
XFILLER_29_574 VGND VGND VPWR VPWR sky130_fd_sc_hd__decap_3
XFILLER_90_127 VGND VGND VPWR VPWR sky130_fd_sc_hd__decap_3
XFILLER_16_235 VGND VGND VPWR VPWR sky130_fd_sc_hd__fill_1
XFILLER_16_268 VGND VGND VPWR VPWR sky130_fd_sc_hd__decap_3
XFILLER_32_717 VGND VGND VPWR VPWR sky130_fd_sc_hd__decap_3
XFILLER_31_249 VGND VGND VPWR VPWR sky130_fd_sc_hd__decap_3
XTAP_TAPCELL_ROW_14_414 VGND VPWR sky130_fd_sc_hd__tapvpwrvgnd_1
XTAP_TAPCELL_ROW_14_425 VGND VPWR sky130_fd_sc_hd__tapvpwrvgnd_1
XFILLER_40_761 VGND VGND VPWR VPWR sky130_fd_sc_hd__fill_2
XFILLER_12_474 VGND VGND VPWR VPWR sky130_fd_sc_hd__fill_2
XFILLER_33_82 VGND VGND VPWR VPWR sky130_fd_sc_hd__fill_2
XFILLER_40_794 VGND VGND VPWR VPWR sky130_fd_sc_hd__fill_1
Xg_row\[1\].g_col\[0\].pe__2730_ clkbuf_leaf_46_clk/X g_row\[1\].g_col\[0\].pe__2730_/D
+ VGND VGND VPWR VPWR g_row\[1\].g_col\[0\].pe__2730_/Q sky130_fd_sc_hd__dfxtp_2
XFILLER_4_640 VGND VGND VPWR VPWR sky130_fd_sc_hd__decap_3
XTAP_TAPCELL_ROW_74_1316 VGND VPWR sky130_fd_sc_hd__tapvpwrvgnd_1
XTAP_TAPCELL_ROW_74_1327 VGND VPWR sky130_fd_sc_hd__tapvpwrvgnd_1
Xg_row\[1\].g_col\[0\].pe__2661_ g_row\[1\].g_col\[0\].pe__2669_/A g_row\[1\].g_col\[0\].pe__2661_/B
+ VGND VGND VPWR VPWR g_row\[1\].g_col\[0\].pe__2661_/X sky130_fd_sc_hd__or2_2
Xg_row\[1\].g_col\[0\].pe__1612_ g_row\[1\].g_col\[0\].pe__1851_/A g_row\[1\].g_col\[0\].pe__1851_/B
+ VGND VGND VPWR VPWR g_row\[1\].g_col\[0\].pe__1615_/A sky130_fd_sc_hd__xor2_2
Xg_row\[1\].g_col\[0\].pe__2592_ g_row\[1\].g_col\[0\].pe__2592_/A g_row\[1\].g_col\[0\].pe__2592_/B
+ VGND VGND VPWR VPWR g_row\[1\].g_col\[0\].pe__2592_/X sky130_fd_sc_hd__and2_2
Xg_row\[1\].g_col\[0\].pe__1543_ g_row\[1\].g_col\[0\].pe__2603_/B g_row\[1\].g_col\[0\].pe__1549_/B
+ g_row\[1\].g_col\[0\].pe__2074_/B1 g_row\[1\].g_col\[0\].pe__2599_/B VGND VGND VPWR
+ VPWR g_row\[1\].g_col\[0\].pe__1544_/B sky130_fd_sc_hd__a22o_2
Xg_row\[1\].g_col\[1\].pe_place828 g_row\[1\].g_col\[1\].pe__1804_/B VGND VGND VPWR
+ VPWR g_row\[1\].g_col\[1\].pe__1727_/B2 sky130_fd_sc_hd__buf_6
Xg_row\[1\].g_col\[1\].pe_place839 g_row\[1\].g_col\[1\].pe__1424_/Y VGND VGND VPWR
+ VPWR g_row\[1\].g_col\[1\].pe__1732_/B1 sky130_fd_sc_hd__buf_6
Xg_row\[1\].g_col\[1\].pe__1490_ g_row\[1\].g_col\[1\].pe__1490_/A g_row\[1\].g_col\[1\].pe__1490_/B
+ VGND VGND VPWR VPWR g_row\[1\].g_col\[1\].pe__1512_/B sky130_fd_sc_hd__xnor2_2
Xg_row\[1\].g_col\[0\].pe_hold2258 g_row\[1\].g_col\[0\].pe__2334_/X VGND VGND VPWR
+ VPWR g_row\[1\].g_col\[0\].pe__2335_/B sky130_fd_sc_hd__clkbuf_2
Xg_row\[1\].g_col\[0\].pe__1474_ g_row\[1\].g_col\[0\].pe__2368_/A g_row\[1\].g_col\[0\].pe__1471_/A
+ g_row\[1\].g_col\[0\].pe__1473_/X VGND VGND VPWR VPWR g_row\[1\].g_col\[0\].pe__1474_/Y
+ sky130_fd_sc_hd__o21ai_2
Xg_row\[0\].g_col\[0\].pe__2670_ g_row\[0\].g_col\[0\].pe__2670_/A1 g_row\[0\].g_col\[0\].pe__2670_/A2
+ g_row\[0\].g_col\[0\].pe__2677_/B1 g_row\[0\].g_col\[0\].pe__2669_/X VGND VGND VPWR
+ VPWR g_row\[0\].g_col\[0\].pe__2670_/X sky130_fd_sc_hd__o211a_2
XFILLER_47_371 VGND VGND VPWR VPWR sky130_fd_sc_hd__fill_2
Xg_row\[0\].g_col\[0\].pe__1621_ g_row\[0\].g_col\[0\].pe__2726_/Q g_row\[0\].g_col\[0\].pe__1621_/B
+ VGND VGND VPWR VPWR g_row\[0\].g_col\[0\].pe__1875_/C sky130_fd_sc_hd__xor2_2
Xg_row\[0\].g_col\[0\].pe__1552_ g_row\[0\].g_col\[0\].pe__1545_/A g_row\[0\].g_col\[0\].pe__1552_/B
+ VGND VGND VPWR VPWR g_row\[0\].g_col\[0\].pe__1552_/X sky130_fd_sc_hd__and2b_2
Xg_row\[1\].g_col\[1\].pe__2111_ g_row\[1\].g_col\[1\].pe__2111_/A g_row\[1\].g_col\[1\].pe__2153_/C
+ VGND VGND VPWR VPWR g_row\[1\].g_col\[1\].pe__2111_/X sky130_fd_sc_hd__or2b_2
XFILLER_35_577 VGND VGND VPWR VPWR sky130_fd_sc_hd__decap_3
XPHY_EDGE_ROW_8_Right_8 VGND VGND VPWR VPWR sky130_fd_sc_hd__decap_3
XTAP_TAPCELL_ROW_33_701 VGND VPWR sky130_fd_sc_hd__tapvpwrvgnd_1
XTAP_TAPCELL_ROW_33_712 VGND VPWR sky130_fd_sc_hd__tapvpwrvgnd_1
XTAP_TAPCELL_ROW_85_1478 VGND VPWR sky130_fd_sc_hd__tapvpwrvgnd_1
XTAP_TAPCELL_ROW_85_1489 VGND VPWR sky130_fd_sc_hd__tapvpwrvgnd_1
XFILLER_22_238 VGND VGND VPWR VPWR sky130_fd_sc_hd__fill_1
Xg_row\[0\].g_col\[0\].pe__1483_ g_row\[0\].g_col\[0\].pe__1761_/A1 place1198/X place1199/X
+ g_row\[0\].g_col\[0\].pe__1804_/B VGND VGND VPWR VPWR g_row\[0\].g_col\[0\].pe__1484_/B
+ sky130_fd_sc_hd__a22o_2
Xg_row\[1\].g_col\[1\].pe__2042_ g_row\[1\].g_col\[1\].pe__2043_/A g_row\[1\].g_col\[1\].pe__2043_/B
+ VGND VGND VPWR VPWR g_row\[1\].g_col\[1\].pe__2094_/C sky130_fd_sc_hd__or2_2
Xg_row\[1\].g_col\[0\].pe__2026_ g_row\[1\].g_col\[0\].pe__2121_/A g_row\[1\].g_col\[0\].pe__2026_/B
+ VGND VGND VPWR VPWR g_row\[1\].g_col\[0\].pe__2028_/B sky130_fd_sc_hd__nand2_2
Xg_row\[0\].g_col\[0\].pe__2104_ g_row\[0\].g_col\[0\].pe__2104_/A g_row\[0\].g_col\[0\].pe__2104_/B
+ g_row\[0\].g_col\[0\].pe__2104_/C VGND VGND VPWR VPWR g_row\[0\].g_col\[0\].pe__2106_/A
+ sky130_fd_sc_hd__and3_4
Xg_row\[0\].g_col\[1\].pe__2120_ g_row\[0\].g_col\[1\].pe__2078_/A g_row\[0\].g_col\[1\].pe__2078_/B
+ g_row\[0\].g_col\[1\].pe__2119_/X VGND VGND VPWR VPWR g_row\[0\].g_col\[1\].pe__2147_/A
+ sky130_fd_sc_hd__a21o_2
Xplace1100 place1100/A VGND VGND VPWR VPWR place1100/X sky130_fd_sc_hd__buf_6
Xg_row\[0\].g_col\[1\].pe__2051_ g_row\[0\].g_col\[1\].pe__2048_/Y g_row\[0\].g_col\[1\].pe__2049_/X
+ g_row\[0\].g_col\[1\].pe__2025_/Y g_row\[0\].g_col\[1\].pe__1991_/X VGND VGND VPWR
+ VPWR g_row\[0\].g_col\[1\].pe__2052_/C sky130_fd_sc_hd__a211oi_2
Xg_row\[0\].g_col\[0\].pe__2035_ g_row\[0\].g_col\[0\].pe__2034_/A g_row\[0\].g_col\[0\].pe__2034_/B
+ g_row\[0\].g_col\[0\].pe__2034_/C g_row\[0\].g_col\[0\].pe__2034_/D VGND VGND VPWR
+ VPWR g_row\[0\].g_col\[0\].pe__2038_/B sky130_fd_sc_hd__a22o_2
Xg_row\[1\].g_col\[1\].pe__1826_ g_row\[1\].g_col\[1\].pe__1828_/A g_row\[1\].g_col\[1\].pe__1828_/B
+ VGND VGND VPWR VPWR g_row\[1\].g_col\[1\].pe__1826_/Y sky130_fd_sc_hd__nor2_2
XPHY_EDGE_ROW_39_Right_39 VGND VGND VPWR VPWR sky130_fd_sc_hd__decap_3
Xplace1199 hold2229/X VGND VGND VPWR VPWR place1199/X sky130_fd_sc_hd__buf_6
XFILLER_38_27 VGND VGND VPWR VPWR sky130_fd_sc_hd__fill_1
Xg_row\[1\].g_col\[1\].pe__1757_ g_row\[1\].g_col\[1\].pe__1770_/A g_row\[1\].g_col\[1\].pe__1770_/B
+ g_row\[1\].g_col\[1\].pe__1756_/X VGND VGND VPWR VPWR g_row\[1\].g_col\[1\].pe__1774_/A
+ sky130_fd_sc_hd__a21oi_2
Xg_row\[1\].g_col\[1\].pe__1688_ g_row\[1\].g_col\[1\].pe__1688_/A g_row\[1\].g_col\[1\].pe__1688_/B
+ VGND VGND VPWR VPWR g_row\[1\].g_col\[1\].pe__1721_/B sky130_fd_sc_hd__xnor2_2
Xg_row\[0\].g_col\[1\].pe__1904_ g_row\[0\].g_col\[1\].pe__1905_/A g_row\[0\].g_col\[1\].pe__1905_/B
+ VGND VGND VPWR VPWR g_row\[0\].g_col\[1\].pe__1964_/A sky130_fd_sc_hd__nand2_2
XFILLER_73_606 VGND VGND VPWR VPWR sky130_fd_sc_hd__fill_2
XFILLER_73_617 VGND VGND VPWR VPWR sky130_fd_sc_hd__decap_3
Xg_row\[0\].g_col\[0\].pe__1819_ g_row\[0\].g_col\[0\].pe__1819_/A g_row\[0\].g_col\[0\].pe__1819_/B
+ VGND VGND VPWR VPWR g_row\[0\].g_col\[0\].pe__1820_/A sky130_fd_sc_hd__and2_2
Xg_row\[0\].g_col\[1\].pe__1835_ g_row\[0\].g_col\[1\].pe__1950_/A g_row\[0\].g_col\[1\].pe__1835_/A2
+ g_row\[0\].g_col\[1\].pe__2157_/A g_row\[0\].g_col\[1\].pe__1834_/Y VGND VGND VPWR
+ VPWR g_row\[0\].g_col\[1\].pe__1835_/X sky130_fd_sc_hd__a22o_2
XFILLER_26_533 VGND VGND VPWR VPWR sky130_fd_sc_hd__fill_1
Xg_row\[1\].g_col\[1\].pe__2309_ g_row\[1\].g_col\[1\].pe__2287_/A g_row\[1\].g_col\[1\].pe__2309_/B
+ VGND VGND VPWR VPWR g_row\[1\].g_col\[1\].pe__2327_/A sky130_fd_sc_hd__and2b_2
Xg_row\[0\].g_col\[1\].pe__1766_ g_row\[0\].g_col\[1\].pe__1766_/A g_row\[0\].g_col\[1\].pe__1766_/B
+ VGND VGND VPWR VPWR g_row\[0\].g_col\[1\].pe__1781_/A sky130_fd_sc_hd__xor2_2
XFILLER_53_363 VGND VGND VPWR VPWR sky130_fd_sc_hd__decap_3
XTAP_TAPCELL_ROW_0_197 VGND VPWR sky130_fd_sc_hd__tapvpwrvgnd_1
XPHY_EDGE_ROW_48_Right_48 VGND VGND VPWR VPWR sky130_fd_sc_hd__decap_3
Xg_row\[0\].g_col\[1\].pe__1697_ g_row\[0\].g_col\[1\].pe__1697_/A g_row\[0\].g_col\[1\].pe__1697_/B
+ VGND VGND VPWR VPWR g_row\[0\].g_col\[1\].pe__1699_/B sky130_fd_sc_hd__xnor2_2
XFILLER_22_750 VGND VGND VPWR VPWR sky130_fd_sc_hd__fill_2
XFILLER_41_569 VGND VGND VPWR VPWR sky130_fd_sc_hd__decap_3
XFILLER_70_25 VGND VGND VPWR VPWR sky130_fd_sc_hd__decap_3
Xg_row\[0\].g_col\[1\].pe__2318_ g_row\[0\].g_col\[1\].pe__2318_/A g_row\[0\].g_col\[1\].pe__2318_/B
+ VGND VGND VPWR VPWR g_row\[0\].g_col\[1\].pe__2319_/B sky130_fd_sc_hd__xor2_2
Xg_row\[1\].g_col\[1\].pe_hold3045 g_row\[1\].g_col\[1\].pe__2725_/Q VGND VGND VPWR
+ VPWR g_row\[1\].g_col\[1\].pe__2684_/A sky130_fd_sc_hd__clkbuf_2
Xg_row\[0\].g_col\[1\].pe__2249_ g_row\[0\].g_col\[1\].pe__2250_/A g_row\[0\].g_col\[1\].pe__2250_/B
+ VGND VGND VPWR VPWR g_row\[0\].g_col\[1\].pe__2283_/A sky130_fd_sc_hd__or2_2
XPHY_EDGE_ROW_57_Right_57 VGND VGND VPWR VPWR sky130_fd_sc_hd__decap_3
XTAP_TAPCELL_ROW_56_1046 VGND VPWR sky130_fd_sc_hd__tapvpwrvgnd_1
Xg_row\[1\].g_col\[1\].pe_hold3089 g_row\[1\].g_col\[1\].pe__1380_/X VGND VGND VPWR
+ VPWR g_row\[1\].g_col\[1\].pe_hold3089/X sky130_fd_sc_hd__clkbuf_2
XTAP_TAPCELL_ROW_56_1057 VGND VPWR sky130_fd_sc_hd__tapvpwrvgnd_1
Xg_row\[1\].g_col\[1\].pe_hold1654 g_row\[1\].g_col\[1\].pe__1950_/Y VGND VGND VPWR
+ VPWR g_row\[1\].g_col\[1\].pe__2011_/A1 sky130_fd_sc_hd__clkbuf_2
Xg_row\[1\].g_col\[1\].pe_hold1643 g_row\[1\].g_col\[1\].pe__2741_/Q VGND VGND VPWR
+ VPWR g_row\[1\].g_col\[1\].pe__1946_/A sky130_fd_sc_hd__clkbuf_2
XFILLER_1_676 VGND VGND VPWR VPWR sky130_fd_sc_hd__fill_2
Xg_row\[1\].g_col\[1\].pe_hold1676 g_row\[1\].g_col\[1\].pe__2405_/Y VGND VGND VPWR
+ VPWR g_row\[1\].g_col\[1\].pe__2755_/D sky130_fd_sc_hd__clkbuf_2
Xg_row\[1\].g_col\[1\].pe_hold1665 g_row\[1\].g_col\[1\].pe__2594_/X VGND VGND VPWR
+ VPWR g_row\[1\].g_col\[1\].pe__2595_/B sky130_fd_sc_hd__clkbuf_2
XFILLER_76_444 VGND VGND VPWR VPWR sky130_fd_sc_hd__fill_1
XFILLER_76_477 VGND VGND VPWR VPWR sky130_fd_sc_hd__decap_3
XFILLER_64_639 VGND VGND VPWR VPWR sky130_fd_sc_hd__decap_3
XFILLER_17_544 VGND VGND VPWR VPWR sky130_fd_sc_hd__decap_3
XFILLER_29_393 VGND VGND VPWR VPWR sky130_fd_sc_hd__fill_1
XFILLER_72_650 VGND VGND VPWR VPWR sky130_fd_sc_hd__decap_3
XPHY_EDGE_ROW_66_Right_66 VGND VGND VPWR VPWR sky130_fd_sc_hd__decap_3
XFILLER_17_599 VGND VGND VPWR VPWR sky130_fd_sc_hd__fill_1
Xg_row\[0\].g_col\[0\].pe_hold2879 g_row\[0\].g_col\[0\].pe__2606_/X VGND VGND VPWR
+ VPWR g_row\[0\].g_col\[0\].pe_hold2879/X sky130_fd_sc_hd__clkbuf_2
XFILLER_9_732 VGND VGND VPWR VPWR sky130_fd_sc_hd__decap_3
XFILLER_8_253 VGND VGND VPWR VPWR sky130_fd_sc_hd__fill_2
XFILLER_9_798 VGND VGND VPWR VPWR sky130_fd_sc_hd__fill_2
XFILLER_5_20 VGND VGND VPWR VPWR sky130_fd_sc_hd__decap_3
XPHY_EDGE_ROW_75_Right_75 VGND VGND VPWR VPWR sky130_fd_sc_hd__decap_3
Xg_row\[1\].g_col\[0\].pe__2713_ clkbuf_leaf_48_clk/X g_row\[1\].g_col\[0\].pe__2713_/D
+ VGND VGND VPWR VPWR g_row\[1\].g_col\[0\].pe__2713_/Q sky130_fd_sc_hd__dfxtp_2
Xg_row\[1\].g_col\[1\].pe__2660_ g_row\[1\].g_col\[1\].pe__2670_/A1 hold2099/X g_row\[1\].g_col\[1\].pe__2670_/B1
+ g_row\[1\].g_col\[1\].pe__2660_/C1 VGND VGND VPWR VPWR g_row\[1\].g_col\[1\].pe__2660_/X
+ sky130_fd_sc_hd__o211a_2
Xg_row\[1\].g_col\[1\].pe__1611_ g_row\[1\].g_col\[1\].pe__1611_/A g_row\[1\].g_col\[1\].pe__1611_/B
+ VGND VGND VPWR VPWR g_row\[1\].g_col\[1\].pe__1851_/B sky130_fd_sc_hd__xnor2_2
Xg_row\[1\].g_col\[0\].pe__2644_ g_row\[1\].g_col\[0\].pe__1838_/A hold2045/X g_row\[1\].g_col\[0\].pe__2670_/B1
+ g_row\[1\].g_col\[0\].pe__2644_/C1 VGND VGND VPWR VPWR g_row\[1\].g_col\[0\].pe__2644_/X
+ sky130_fd_sc_hd__o211a_2
Xg_row\[1\].g_col\[1\].pe__2591_ g_row\[1\].g_col\[1\].pe__2591_/A1 g_row\[1\].g_col\[1\].pe__2591_/A2
+ g_row\[1\].g_col\[1\].pe__2591_/B1 g_row\[1\].g_col\[1\].pe__2590_/X VGND VGND VPWR
+ VPWR g_row\[1\].g_col\[1\].pe__2591_/X sky130_fd_sc_hd__a22o_2
Xg_row\[1\].g_col\[0\].pe__2575_ g_row\[1\].g_col\[0\].pe__2575_/A g_row\[1\].g_col\[0\].pe__2590_/A
+ VGND VGND VPWR VPWR g_row\[1\].g_col\[0\].pe__2575_/X sky130_fd_sc_hd__or2_2
Xg_row\[1\].g_col\[0\].pe_hold2055 g_row\[1\].g_col\[0\].pe_hold3099/X VGND VGND VPWR
+ VPWR g_row\[1\].g_col\[0\].pe__2727_/D sky130_fd_sc_hd__clkbuf_2
Xg_row\[1\].g_col\[0\].pe_hold2044 g_row\[1\].g_col\[0\].pe__2687_/X VGND VGND VPWR
+ VPWR g_row\[1\].g_col\[0\].pe__2726_/D sky130_fd_sc_hd__clkbuf_2
Xg_row\[1\].g_col\[0\].pe__1526_ g_row\[1\].g_col\[0\].pe__1910_/A g_row\[1\].g_col\[0\].pe__1526_/B
+ VGND VGND VPWR VPWR g_row\[1\].g_col\[0\].pe__1554_/A sky130_fd_sc_hd__xor2_2
XFILLER_55_617 VGND VGND VPWR VPWR sky130_fd_sc_hd__decap_3
XTAP_TAPCELL_ROW_87_1518 VGND VPWR sky130_fd_sc_hd__tapvpwrvgnd_1
Xg_row\[0\].g_col\[0\].pe__2722_ clkbuf_leaf_24_clk/X g_row\[0\].g_col\[0\].pe__2722_/D
+ VGND VGND VPWR VPWR g_row\[0\].g_col\[0\].pe__2722_/Q sky130_fd_sc_hd__dfxtp_2
Xg_row\[1\].g_col\[1\].pe__1473_ g_row\[1\].g_col\[1\].pe__2733_/Q g_row\[1\].g_col\[1\].pe__2250_/A
+ g_row\[1\].g_col\[1\].pe__1540_/C VGND VGND VPWR VPWR g_row\[1\].g_col\[1\].pe__1473_/X
+ sky130_fd_sc_hd__or3b_4
Xg_row\[1\].g_col\[0\].pe_hold2077 g_row\[1\].g_col\[0\].pe__2661_/X VGND VGND VPWR
+ VPWR g_row\[1\].g_col\[0\].pe__2662_/C1 sky130_fd_sc_hd__clkbuf_2
Xg_row\[1\].g_col\[0\].pe_hold2066 g_row\[1\].g_col\[0\].pe__2715_/Q VGND VGND VPWR
+ VPWR g_row\[1\].g_col\[0\].pe__2659_/B sky130_fd_sc_hd__clkbuf_2
XPHY_EDGE_ROW_84_Right_84 VGND VGND VPWR VPWR sky130_fd_sc_hd__decap_3
Xg_row\[0\].g_col\[0\].pe__2653_ g_row\[0\].g_col\[0\].pe__2669_/A hold1905/X VGND
+ VGND VPWR VPWR g_row\[0\].g_col\[0\].pe__2653_/X sky130_fd_sc_hd__or2_2
Xg_row\[1\].g_col\[0\].pe__1457_ g_row\[1\].g_col\[0\].pe__2731_/Q g_row\[1\].g_col\[0\].pe__2167_/A
+ VGND VGND VPWR VPWR g_row\[1\].g_col\[0\].pe__2163_/B sky130_fd_sc_hd__xor2_2
Xg_row\[0\].g_col\[0\].pe__1604_ g_row\[0\].g_col\[0\].pe__1604_/A g_row\[0\].g_col\[0\].pe__1604_/B
+ VGND VGND VPWR VPWR g_row\[0\].g_col\[0\].pe__1605_/B sky130_fd_sc_hd__or2_2
Xg_row\[0\].g_col\[1\].pe__1620_ g_row\[0\].g_col\[1\].pe__2702_/Q g_row\[0\].g_col\[1\].pe__1414_/X
+ g_row\[0\].g_col\[1\].pe__1415_/Y g_row\[0\].g_col\[1\].pe__1801_/B g_row\[0\].g_col\[1\].pe__2121_/A
+ VGND VGND VPWR VPWR g_row\[0\].g_col\[1\].pe__1621_/B sky130_fd_sc_hd__a32o_2
Xg_row\[1\].g_col\[0\].pe__1388_ g_row\[1\].g_col\[0\].pe__2167_/A g_row\[1\].g_col\[0\].pe__2686_/B
+ g_row\[1\].g_col\[0\].pe__1388_/B1 g_row\[1\].g_col\[0\].pe__2679_/C1 VGND VGND
+ VPWR VPWR g_row\[1\].g_col\[0\].pe__1388_/X sky130_fd_sc_hd__o211a_2
XFILLER_35_374 VGND VGND VPWR VPWR sky130_fd_sc_hd__fill_2
Xg_row\[0\].g_col\[0\].pe__2584_ g_row\[0\].g_col\[0\].pe__2585_/A g_row\[0\].g_col\[0\].pe__2585_/B
+ VGND VGND VPWR VPWR g_row\[0\].g_col\[0\].pe__2586_/B sky130_fd_sc_hd__nor2_2
XFILLER_24_29 VGND VGND VPWR VPWR sky130_fd_sc_hd__fill_2
XFILLER_50_333 VGND VGND VPWR VPWR sky130_fd_sc_hd__decap_3
XFILLER_62_182 VGND VGND VPWR VPWR sky130_fd_sc_hd__fill_1
Xg_row\[0\].g_col\[0\].pe__1535_ g_row\[0\].g_col\[0\].pe__2736_/Q g_row\[0\].g_col\[0\].pe__1535_/B
+ VGND VGND VPWR VPWR g_row\[0\].g_col\[0\].pe__1546_/A sky130_fd_sc_hd__nand2_2
Xg_row\[0\].g_col\[1\].pe__1551_ g_row\[0\].g_col\[1\].pe__1669_/A g_row\[0\].g_col\[1\].pe__1669_/B
+ VGND VGND VPWR VPWR g_row\[0\].g_col\[1\].pe__1830_/B sky130_fd_sc_hd__and2_2
Xg_row\[0\].g_col\[0\].pe__1466_ g_row\[0\].g_col\[0\].pe__2368_/A VGND VGND VPWR
+ VPWR g_row\[0\].g_col\[0\].pe__2171_/A sky130_fd_sc_hd__inv_2
Xg_row\[0\].g_col\[1\].pe__1482_ g_row\[0\].g_col\[1\].pe__1442_/A g_row\[0\].g_col\[1\].pe__1442_/B
+ g_row\[0\].g_col\[1\].pe__1481_/X VGND VGND VPWR VPWR g_row\[0\].g_col\[1\].pe__1512_/A
+ sky130_fd_sc_hd__a21oi_2
Xg_row\[1\].g_col\[1\].pe__2025_ g_row\[1\].g_col\[1\].pe__1919_/B g_row\[1\].g_col\[1\].pe__1980_/X
+ g_row\[1\].g_col\[1\].pe__1981_/Y g_row\[1\].g_col\[1\].pe__1987_/Y g_row\[1\].g_col\[1\].pe__1988_/X
+ VGND VGND VPWR VPWR g_row\[1\].g_col\[1\].pe__2025_/Y sky130_fd_sc_hd__a311oi_2
Xg_row\[1\].g_col\[0\].pe__2009_ g_row\[1\].g_col\[0\].pe__2006_/A g_row\[1\].g_col\[0\].pe__2009_/B
+ g_row\[1\].g_col\[0\].pe__2009_/C VGND VGND VPWR VPWR g_row\[1\].g_col\[0\].pe__2010_/D
+ sky130_fd_sc_hd__and3b_2
XFILLER_31_580 VGND VGND VPWR VPWR sky130_fd_sc_hd__decap_3
Xg_row\[0\].g_col\[0\].pe__1397_ g_row\[0\].g_col\[0\].pe__1397_/A1 g_row\[0\].g_col\[0\].pe__2686_/B
+ g_row\[0\].g_col\[0\].pe__1396_/X g_row\[0\].g_col\[0\].pe__1377_/Y VGND VGND VPWR
+ VPWR g_row\[0\].g_col\[0\].pe__1397_/X sky130_fd_sc_hd__o211a_2
XPHY_EDGE_ROW_93_Right_93 VGND VGND VPWR VPWR sky130_fd_sc_hd__decap_3
Xg_row\[0\].g_col\[1\].pe__2103_ g_row\[0\].g_col\[1\].pe__2052_/A g_row\[0\].g_col\[1\].pe__2052_/C
+ g_row\[0\].g_col\[1\].pe__2052_/B VGND VGND VPWR VPWR g_row\[0\].g_col\[1\].pe__2104_/C
+ sky130_fd_sc_hd__o21bai_2
Xg_row\[0\].g_col\[0\].pe__2018_ g_row\[0\].g_col\[0\].pe__1978_/B g_row\[0\].g_col\[0\].pe__1978_/C
+ g_row\[0\].g_col\[0\].pe__1978_/A VGND VGND VPWR VPWR g_row\[0\].g_col\[0\].pe__2023_/A
+ sky130_fd_sc_hd__o21bai_2
Xg_row\[0\].g_col\[1\].pe__2034_ g_row\[0\].g_col\[1\].pe__2034_/A g_row\[0\].g_col\[1\].pe__2034_/B
+ g_row\[0\].g_col\[1\].pe__2034_/C g_row\[0\].g_col\[1\].pe__2034_/D VGND VGND VPWR
+ VPWR g_row\[0\].g_col\[1\].pe__2038_/A sky130_fd_sc_hd__nand4_2
Xg_row\[1\].g_col\[1\].pe__1809_ g_row\[1\].g_col\[1\].pe__1795_/A g_row\[1\].g_col\[1\].pe__1795_/B
+ g_row\[1\].g_col\[1\].pe__1795_/C VGND VGND VPWR VPWR g_row\[1\].g_col\[1\].pe__1809_/X
+ sky130_fd_sc_hd__a21o_2
XFILLER_86_720 VGND VGND VPWR VPWR sky130_fd_sc_hd__fill_2
XFILLER_46_606 VGND VGND VPWR VPWR sky130_fd_sc_hd__fill_1
XFILLER_86_764 VGND VGND VPWR VPWR sky130_fd_sc_hd__fill_2
XTAP_TAPCELL_ROW_5_278 VGND VPWR sky130_fd_sc_hd__tapvpwrvgnd_1
XTAP_TAPCELL_ROW_5_289 VGND VPWR sky130_fd_sc_hd__tapvpwrvgnd_1
XFILLER_73_403 VGND VGND VPWR VPWR sky130_fd_sc_hd__fill_1
XANTENNA_104 hold3202/A VGND VGND VPWR VPWR sky130_fd_sc_hd__diode_2
XANTENNA_115 hold2676/X VGND VGND VPWR VPWR sky130_fd_sc_hd__diode_2
Xg_row\[0\].g_col\[1\].pe_hold2954 g_row\[0\].g_col\[1\].pe__2681_/X VGND VGND VPWR
+ VPWR g_row\[0\].g_col\[1\].pe_hold2954/X sky130_fd_sc_hd__clkbuf_2
Xg_row\[0\].g_col\[1\].pe__1818_ g_row\[0\].g_col\[1\].pe__1822_/D g_row\[0\].g_col\[1\].pe__1818_/B
+ VGND VGND VPWR VPWR g_row\[0\].g_col\[1\].pe__1821_/C sky130_fd_sc_hd__xnor2_2
XANTENNA_126 hold3337/A VGND VGND VPWR VPWR sky130_fd_sc_hd__diode_2
XANTENNA_137 b_inputs_flat[31] VGND VGND VPWR VPWR sky130_fd_sc_hd__diode_2
XANTENNA_148 hold2455/A VGND VGND VPWR VPWR sky130_fd_sc_hd__diode_2
XFILLER_54_672 VGND VGND VPWR VPWR sky130_fd_sc_hd__fill_2
Xg_row\[0\].g_col\[1\].pe_hold2998 _335_/Q VGND VGND VPWR VPWR g_row\[0\].g_col\[1\].pe_hold2998/X
+ sky130_fd_sc_hd__clkbuf_2
Xg_row\[0\].g_col\[1\].pe_hold2987 _337_/Q VGND VGND VPWR VPWR ANTENNA_169/DIODE sky130_fd_sc_hd__clkbuf_2
XANTENNA_159 _325_/D VGND VGND VPWR VPWR sky130_fd_sc_hd__diode_2
Xg_row\[0\].g_col\[0\].pe_hold2109 g_row\[0\].g_col\[0\].pe__2576_/X VGND VGND VPWR
+ VPWR g_row\[0\].g_col\[0\].pe__2577_/B sky130_fd_sc_hd__clkbuf_2
Xg_row\[0\].g_col\[1\].pe__1749_ g_row\[0\].g_col\[1\].pe__1804_/A g_row\[0\].g_col\[1\].pe__1749_/A2
+ g_row\[0\].g_col\[1\].pe__1761_/A2 g_row\[0\].g_col\[1\].pe__1804_/B VGND VGND VPWR
+ VPWR g_row\[0\].g_col\[1\].pe__1750_/B sky130_fd_sc_hd__a22o_2
XFILLER_81_57 VGND VGND VPWR VPWR sky130_fd_sc_hd__fill_2
XTAP_TAPCELL_ROW_24_564 VGND VPWR sky130_fd_sc_hd__tapvpwrvgnd_1
XTAP_TAPCELL_ROW_24_575 VGND VPWR sky130_fd_sc_hd__tapvpwrvgnd_1
X_282_ _291_/CLK _282_/D VGND VGND VPWR VPWR _282_/Q sky130_fd_sc_hd__dfxtp_2
XFILLER_10_786 VGND VGND VPWR VPWR sky130_fd_sc_hd__fill_2
XFILLER_6_757 VGND VGND VPWR VPWR sky130_fd_sc_hd__decap_3
XFILLER_6_779 VGND VGND VPWR VPWR sky130_fd_sc_hd__decap_3
XFILLER_30_61 VGND VGND VPWR VPWR sky130_fd_sc_hd__decap_3
Xg_row\[1\].g_col\[1\].pe_hold2152 g_row\[1\].g_col\[1\].pe__2681_/X VGND VGND VPWR
+ VPWR g_row\[1\].g_col\[1\].pe__2723_/D sky130_fd_sc_hd__clkbuf_2
XFILLER_68_219 VGND VGND VPWR VPWR sky130_fd_sc_hd__fill_2
Xg_row\[1\].g_col\[0\].pe__2360_ g_row\[1\].g_col\[0\].pe__2663_/A g_row\[1\].g_col\[0\].pe__2360_/A2
+ g_row\[1\].g_col\[0\].pe__2010_/A g_row\[1\].g_col\[0\].pe__2359_/Y VGND VGND VPWR
+ VPWR g_row\[1\].g_col\[0\].pe__2360_/X sky130_fd_sc_hd__o22a_2
XFILLER_92_701 VGND VGND VPWR VPWR sky130_fd_sc_hd__fill_1
XFILLER_37_617 VGND VGND VPWR VPWR sky130_fd_sc_hd__decap_3
XFILLER_49_499 VGND VGND VPWR VPWR sky130_fd_sc_hd__decap_3
Xg_row\[1\].g_col\[0\].pe__2291_ g_row\[1\].g_col\[0\].pe__2291_/A g_row\[1\].g_col\[0\].pe__2291_/B
+ VGND VGND VPWR VPWR g_row\[1\].g_col\[0\].pe__2327_/B sky130_fd_sc_hd__and2_2
XFILLER_18_831 VGND VGND VPWR VPWR sky130_fd_sc_hd__decap_3
XFILLER_91_222 VGND VGND VPWR VPWR sky130_fd_sc_hd__fill_2
XTAP_TAPCELL_ROW_69_1248 VGND VPWR sky130_fd_sc_hd__tapvpwrvgnd_1
XTAP_TAPCELL_ROW_82_1437 VGND VPWR sky130_fd_sc_hd__tapvpwrvgnd_1
XTAP_TAPCELL_ROW_43_851 VGND VPWR sky130_fd_sc_hd__tapvpwrvgnd_1
XTAP_TAPCELL_ROW_43_862 VGND VPWR sky130_fd_sc_hd__tapvpwrvgnd_1
XFILLER_60_697 VGND VGND VPWR VPWR sky130_fd_sc_hd__decap_3
Xg_row\[0\].g_col\[0\].pe_hold1931 g_row\[0\].g_col\[0\].pe__2401_/X VGND VGND VPWR
+ VPWR g_row\[0\].g_col\[0\].pe__2402_/B sky130_fd_sc_hd__clkbuf_2
XFILLER_9_595 VGND VGND VPWR VPWR sky130_fd_sc_hd__decap_3
Xg_row\[0\].g_col\[0\].pe_hold1997 g_row\[0\].g_col\[0\].pe__2758_/Q VGND VGND VPWR
+ VPWR g_row\[0\].g_col\[0\].pe__2528_/A1 sky130_fd_sc_hd__clkbuf_2
Xg_row\[1\].g_col\[1\].pe__2712_ clkbuf_leaf_81_clk/X g_row\[1\].g_col\[1\].pe__2712_/D
+ VGND VGND VPWR VPWR g_row\[1\].g_col\[1\].pe__2712_/Q sky130_fd_sc_hd__dfxtp_2
XTAP_TAPCELL_ROW_93_1599 VGND VPWR sky130_fd_sc_hd__tapvpwrvgnd_1
Xg_row\[1\].g_col\[1\].pe__2643_ g_row\[1\].g_col\[1\].pe__2676_/A g_row\[1\].g_col\[1\].pe__2643_/B
+ VGND VGND VPWR VPWR g_row\[1\].g_col\[1\].pe__2643_/X sky130_fd_sc_hd__or2_2
Xg_row\[1\].g_col\[0\].pe__2627_ place1257/X hold1795/X VGND VGND VPWR VPWR g_row\[1\].g_col\[0\].pe__2627_/X
+ sky130_fd_sc_hd__or2_2
XFILLER_68_742 VGND VGND VPWR VPWR sky130_fd_sc_hd__fill_2
XFILLER_68_753 VGND VGND VPWR VPWR sky130_fd_sc_hd__decap_3
XFILLER_68_775 VGND VGND VPWR VPWR sky130_fd_sc_hd__decap_3
Xg_row\[1\].g_col\[1\].pe__1525_ g_row\[1\].g_col\[1\].pe__1704_/A2 g_row\[1\].g_col\[1\].pe__2026_/B
+ g_row\[1\].g_col\[1\].pe__1738_/B1 g_row\[1\].g_col\[1\].pe__2138_/B2 VGND VGND
+ VPWR VPWR g_row\[1\].g_col\[1\].pe__1526_/B sky130_fd_sc_hd__a22o_2
Xg_row\[1\].g_col\[0\].pe__2558_ g_row\[1\].g_col\[0\].pe__2558_/A g_row\[1\].g_col\[0\].pe__2558_/B
+ VGND VGND VPWR VPWR g_row\[1\].g_col\[0\].pe__2559_/B sky130_fd_sc_hd__xor2_2
XTAP_TAPCELL_ROW_2_237 VGND VPWR sky130_fd_sc_hd__tapvpwrvgnd_1
Xg_row\[1\].g_col\[0\].pe__2489_ g_row\[1\].g_col\[0\].pe__2474_/Y g_row\[1\].g_col\[0\].pe__2489_/B
+ g_row\[1\].g_col\[0\].pe__2492_/A VGND VGND VPWR VPWR g_row\[1\].g_col\[0\].pe__2490_/B
+ sky130_fd_sc_hd__and3b_2
Xg_row\[1\].g_col\[0\].pe__1509_ g_row\[1\].g_col\[0\].pe__1535_/B g_row\[1\].g_col\[0\].pe__1549_/C
+ VGND VGND VPWR VPWR g_row\[1\].g_col\[0\].pe__1640_/B sky130_fd_sc_hd__xnor2_2
Xg_row\[0\].g_col\[1\].pe_hold2217 g_row\[0\].g_col\[1\].pe__2612_/X VGND VGND VPWR
+ VPWR g_row\[0\].g_col\[1\].pe__2613_/C1 sky130_fd_sc_hd__clkbuf_2
Xg_row\[0\].g_col\[1\].pe__2721_ clkbuf_leaf_93_clk/X g_row\[0\].g_col\[1\].pe__2721_/D
+ VGND VGND VPWR VPWR hold2149/A sky130_fd_sc_hd__dfxtp_2
XFILLER_55_458 VGND VGND VPWR VPWR sky130_fd_sc_hd__decap_3
XFILLER_67_296 VGND VGND VPWR VPWR sky130_fd_sc_hd__fill_2
XFILLER_82_222 VGND VGND VPWR VPWR sky130_fd_sc_hd__fill_2
XFILLER_83_767 VGND VGND VPWR VPWR sky130_fd_sc_hd__fill_2
Xg_row\[0\].g_col\[0\].pe__2705_ clkbuf_leaf_14_clk/X g_row\[0\].g_col\[0\].pe__2705_/D
+ VGND VGND VPWR VPWR hold1929/A sky130_fd_sc_hd__dfxtp_2
Xg_row\[0\].g_col\[1\].pe_hold2239 g_row\[0\].g_col\[1\].pe__1380_/X VGND VGND VPWR
+ VPWR g_row\[0\].g_col\[1\].pe__2727_/D sky130_fd_sc_hd__clkbuf_2
Xg_row\[0\].g_col\[0\].pe__2636_ _278_/Q g_row\[0\].g_col\[0\].pe__2636_/B _280_/Q
+ _279_/Q VGND VGND VPWR VPWR g_row\[0\].g_col\[0\].pe__2636_/X sky130_fd_sc_hd__or4_2
Xg_row\[1\].g_col\[1\].pe__1387_ hold1778/X g_row\[1\].g_col\[1\].pe__1398_/B VGND
+ VGND VPWR VPWR g_row\[1\].g_col\[1\].pe__1387_/X sky130_fd_sc_hd__or2_2
Xg_row\[0\].g_col\[1\].pe__2652_ g_row\[0\].g_col\[1\].pe__2666_/A1 g_row\[0\].g_col\[1\].pe__2652_/A2
+ g_row\[0\].g_col\[1\].pe__2677_/B1 g_row\[0\].g_col\[1\].pe__2651_/X VGND VGND VPWR
+ VPWR g_row\[0\].g_col\[1\].pe__2652_/X sky130_fd_sc_hd__o211a_2
Xg_row\[0\].g_col\[0\].pe__2567_ g_row\[0\].g_col\[0\].pe__2567_/A g_row\[0\].g_col\[0\].pe__2590_/A
+ VGND VGND VPWR VPWR g_row\[0\].g_col\[0\].pe__2567_/X sky130_fd_sc_hd__or2_2
Xg_row\[0\].g_col\[1\].pe__1603_ g_row\[0\].g_col\[1\].pe__1604_/A g_row\[0\].g_col\[1\].pe__1604_/B
+ VGND VGND VPWR VPWR g_row\[0\].g_col\[1\].pe__1860_/A sky130_fd_sc_hd__nand2_2
XFILLER_51_642 VGND VGND VPWR VPWR sky130_fd_sc_hd__fill_1
Xg_row\[0\].g_col\[1\].pe__1534_ g_row\[0\].g_col\[1\].pe__1588_/A g_row\[0\].g_col\[1\].pe__1588_/B
+ VGND VGND VPWR VPWR g_row\[0\].g_col\[1\].pe__1547_/A sky130_fd_sc_hd__xor2_2
XFILLER_51_686 VGND VGND VPWR VPWR sky130_fd_sc_hd__decap_3
Xg_row\[0\].g_col\[0\].pe__1518_ place1201/X g_row\[0\].g_col\[0\].pe__1414_/X g_row\[0\].g_col\[0\].pe__1415_/Y
+ g_row\[0\].g_col\[0\].pe__1784_/B1 place1199/X VGND VGND VPWR VPWR g_row\[0\].g_col\[0\].pe__1519_/B
+ sky130_fd_sc_hd__a32o_2
Xg_row\[0\].g_col\[0\].pe__2498_ g_row\[0\].g_col\[0\].pe__2519_/A g_row\[0\].g_col\[0\].pe__2519_/B
+ VGND VGND VPWR VPWR g_row\[0\].g_col\[0\].pe__2499_/B sky130_fd_sc_hd__or2_2
XFILLER_51_49 VGND VGND VPWR VPWR sky130_fd_sc_hd__decap_3
XTAP_TAPCELL_ROW_21_523 VGND VPWR sky130_fd_sc_hd__tapvpwrvgnd_1
Xg_row\[0\].g_col\[0\].pe__1449_ g_row\[0\].g_col\[0\].pe__1449_/A g_row\[0\].g_col\[0\].pe__1449_/B
+ VGND VGND VPWR VPWR g_row\[0\].g_col\[0\].pe__1449_/Y sky130_fd_sc_hd__nand2_2
Xg_row\[0\].g_col\[1\].pe__1465_ g_row\[0\].g_col\[1\].pe__1507_/A g_row\[0\].g_col\[1\].pe__1507_/B
+ VGND VGND VPWR VPWR g_row\[0\].g_col\[1\].pe__1478_/A sky130_fd_sc_hd__xor2_2
Xg_row\[1\].g_col\[1\].pe__2008_ g_row\[1\].g_col\[1\].pe__2008_/A g_row\[1\].g_col\[1\].pe__2151_/B
+ VGND VGND VPWR VPWR g_row\[1\].g_col\[1\].pe__2062_/A sky130_fd_sc_hd__nor2_2
Xg_row\[0\].g_col\[1\].pe__1396_ g_row\[0\].g_col\[1\].pe__1396_/A g_row\[0\].g_col\[1\].pe__1402_/B
+ VGND VGND VPWR VPWR g_row\[0\].g_col\[1\].pe__1396_/X sky130_fd_sc_hd__or2_2
Xg_row\[0\].g_col\[0\].pe_place979 g_row\[0\].g_col\[0\].pe__2171_/A VGND VGND VPWR
+ VPWR g_row\[0\].g_col\[0\].pe__2348_/A sky130_fd_sc_hd__buf_6
Xg_row\[0\].g_col\[1\].pe__2017_ g_row\[0\].g_col\[1\].pe__2017_/A VGND VGND VPWR
+ VPWR g_row\[0\].g_col\[1\].pe__2058_/A sky130_fd_sc_hd__inv_2
XTAP_TAPCELL_ROW_53_1005 VGND VPWR sky130_fd_sc_hd__tapvpwrvgnd_1
XFILLER_59_720 VGND VGND VPWR VPWR sky130_fd_sc_hd__decap_3
XFILLER_19_617 VGND VGND VPWR VPWR sky130_fd_sc_hd__fill_1
XFILLER_46_414 VGND VGND VPWR VPWR sky130_fd_sc_hd__decap_3
XFILLER_74_734 VGND VGND VPWR VPWR sky130_fd_sc_hd__decap_3
XTAP_TAPCELL_ROW_29_645 VGND VPWR sky130_fd_sc_hd__tapvpwrvgnd_1
XFILLER_27_661 VGND VGND VPWR VPWR sky130_fd_sc_hd__fill_1
XFILLER_74_778 VGND VGND VPWR VPWR sky130_fd_sc_hd__decap_3
XFILLER_27_694 VGND VGND VPWR VPWR sky130_fd_sc_hd__decap_3
XFILLER_26_193 VGND VGND VPWR VPWR sky130_fd_sc_hd__decap_3
XTAP_TAPCELL_ROW_64_1167 VGND VPWR sky130_fd_sc_hd__tapvpwrvgnd_1
XTAP_TAPCELL_ROW_40_810 VGND VPWR sky130_fd_sc_hd__tapvpwrvgnd_1
X_334_ _339_/CLK _334_/D VGND VGND VPWR VPWR _334_/Q sky130_fd_sc_hd__dfxtp_2
X_265_ _271_/A _265_/B_N VGND VGND VPWR VPWR _265_/Y sky130_fd_sc_hd__nor2b_4
Xg_row\[1\].g_col\[0\].pe__1860_ g_row\[1\].g_col\[0\].pe__1860_/A g_row\[1\].g_col\[0\].pe__1860_/B
+ VGND VGND VPWR VPWR g_row\[1\].g_col\[0\].pe__1882_/A sky130_fd_sc_hd__xor2_2
XFILLER_6_587 VGND VGND VPWR VPWR sky130_fd_sc_hd__fill_1
Xg_row\[1\].g_col\[0\].pe__1791_ g_row\[1\].g_col\[0\].pe__1791_/A g_row\[1\].g_col\[0\].pe__1797_/A
+ VGND VGND VPWR VPWR g_row\[1\].g_col\[0\].pe__1792_/A sky130_fd_sc_hd__nor2_2
Xg_row\[1\].g_col\[0\].pe__2412_ g_row\[1\].g_col\[0\].pe__2743_/Q g_row\[1\].g_col\[0\].pe__2742_/Q
+ g_row\[1\].g_col\[0\].pe__2741_/Q g_row\[1\].g_col\[0\].pe__2455_/B g_row\[1\].g_col\[0\].pe__2421_/A1
+ VGND VGND VPWR VPWR g_row\[1\].g_col\[0\].pe__2445_/B sky130_fd_sc_hd__o41a_2
XFILLER_1_281 VGND VGND VPWR VPWR sky130_fd_sc_hd__fill_1
XFILLER_65_701 VGND VGND VPWR VPWR sky130_fd_sc_hd__fill_1
Xg_row\[1\].g_col\[0\].pe__2343_ g_row\[1\].g_col\[0\].pe__2343_/A g_row\[1\].g_col\[0\].pe__2365_/A
+ VGND VGND VPWR VPWR g_row\[1\].g_col\[0\].pe__2345_/B sky130_fd_sc_hd__xor2_2
XFILLER_49_296 VGND VGND VPWR VPWR sky130_fd_sc_hd__decap_3
XFILLER_65_756 VGND VGND VPWR VPWR sky130_fd_sc_hd__fill_1
XTAP_TAPCELL_ROW_48_932 VGND VPWR sky130_fd_sc_hd__tapvpwrvgnd_1
Xg_row\[1\].g_col\[1\].pe__2290_ g_row\[1\].g_col\[1\].pe__2291_/A g_row\[1\].g_col\[1\].pe__2291_/B
+ VGND VGND VPWR VPWR g_row\[1\].g_col\[1\].pe__2292_/A sky130_fd_sc_hd__nor2_2
Xg_row\[1\].g_col\[0\].pe__2274_ g_row\[1\].g_col\[0\].pe__2125_/A g_row\[1\].g_col\[0\].pe__2733_/Q
+ g_row\[1\].g_col\[0\].pe__2165_/A g_row\[1\].g_col\[0\].pe__2321_/A VGND VGND VPWR
+ VPWR g_row\[1\].g_col\[0\].pe__2318_/A sky130_fd_sc_hd__o211a_2
XFILLER_18_672 VGND VGND VPWR VPWR sky130_fd_sc_hd__fill_1
XFILLER_52_406 VGND VGND VPWR VPWR sky130_fd_sc_hd__fill_2
XFILLER_18_694 VGND VGND VPWR VPWR sky130_fd_sc_hd__decap_3
XFILLER_33_620 VGND VGND VPWR VPWR sky130_fd_sc_hd__decap_3
XFILLER_45_480 VGND VGND VPWR VPWR sky130_fd_sc_hd__decap_3
Xg_row\[0\].g_col\[0\].pe__2421_ g_row\[0\].g_col\[0\].pe__2450_/A1 g_row\[0\].g_col\[0\].pe__2752_/Q
+ g_row\[0\].g_col\[0\].pe__2426_/B VGND VGND VPWR VPWR g_row\[0\].g_col\[0\].pe__2484_/A
+ sky130_fd_sc_hd__a21o_2
Xg_row\[0\].g_col\[0\].pe__2352_ g_row\[0\].g_col\[0\].pe__2352_/A g_row\[0\].g_col\[0\].pe__2352_/B
+ g_row\[0\].g_col\[0\].pe__2352_/C VGND VGND VPWR VPWR g_row\[0\].g_col\[0\].pe__2353_/B
+ sky130_fd_sc_hd__and3_2
XANTENNA_15 b_inputs_flat[14] VGND VGND VPWR VPWR sky130_fd_sc_hd__diode_2
XANTENNA_26 b_inputs_flat[3] VGND VGND VPWR VPWR sky130_fd_sc_hd__diode_2
XANTENNA_37 _274_/Q VGND VGND VPWR VPWR sky130_fd_sc_hd__diode_2
XANTENNA_48 hold3230/A VGND VGND VPWR VPWR sky130_fd_sc_hd__diode_2
XFILLER_32_185 VGND VGND VPWR VPWR sky130_fd_sc_hd__decap_3
Xg_row\[0\].g_col\[0\].pe__2283_ g_row\[0\].g_col\[0\].pe__2283_/A g_row\[0\].g_col\[0\].pe__2283_/B
+ VGND VGND VPWR VPWR g_row\[0\].g_col\[0\].pe__2284_/B sky130_fd_sc_hd__and2_2
Xg_row\[0\].g_col\[0\].pe_hold1750 g_row\[0\].g_col\[0\].pe__2306_/X VGND VGND VPWR
+ VPWR g_row\[0\].g_col\[0\].pe__2307_/B sky130_fd_sc_hd__clkbuf_2
XANTENNA_59 hold2460/X VGND VGND VPWR VPWR sky130_fd_sc_hd__diode_2
XPHY_EDGE_ROW_65_Left_159 VGND VGND VPWR VPWR sky130_fd_sc_hd__decap_3
Xg_row\[1\].g_col\[0\].pe__1989_ g_row\[1\].g_col\[0\].pe__1919_/B g_row\[1\].g_col\[0\].pe__1980_/X
+ g_row\[1\].g_col\[0\].pe__1981_/Y g_row\[1\].g_col\[0\].pe__1987_/Y g_row\[1\].g_col\[0\].pe__1988_/X
+ VGND VGND VPWR VPWR g_row\[1\].g_col\[0\].pe__1991_/C sky130_fd_sc_hd__a311o_2
XFILLER_0_708 VGND VGND VPWR VPWR sky130_fd_sc_hd__decap_3
XFILLER_0_719 VGND VGND VPWR VPWR sky130_fd_sc_hd__fill_2
XTAP_TAPCELL_ROW_7_318 VGND VPWR sky130_fd_sc_hd__tapvpwrvgnd_1
Xg_row\[1\].g_col\[1\].pe__2626_ g_row\[1\].g_col\[1\].pe__2626_/A1 hold1938/X g_row\[1\].g_col\[1\].pe__2626_/B1
+ g_row\[1\].g_col\[1\].pe__2625_/X VGND VGND VPWR VPWR g_row\[1\].g_col\[1\].pe__2626_/X
+ sky130_fd_sc_hd__o211a_2
XFILLER_75_509 VGND VGND VPWR VPWR sky130_fd_sc_hd__decap_3
XFILLER_28_414 VGND VGND VPWR VPWR sky130_fd_sc_hd__fill_1
Xg_row\[0\].g_col\[0\].pe__1998_ g_row\[0\].g_col\[0\].pe__1999_/A g_row\[0\].g_col\[0\].pe__1999_/B
+ VGND VGND VPWR VPWR g_row\[0\].g_col\[0\].pe__1998_/X sky130_fd_sc_hd__and2_2
Xg_row\[1\].g_col\[1\].pe__2557_ g_row\[1\].g_col\[1\].pe__2551_/A g_row\[1\].g_col\[1\].pe__2551_/B
+ g_row\[1\].g_col\[1\].pe__2551_/C g_row\[1\].g_col\[1\].pe__2444_/A VGND VGND VPWR
+ VPWR g_row\[1\].g_col\[1\].pe__2558_/A sky130_fd_sc_hd__a31o_2
XFILLER_46_27 VGND VGND VPWR VPWR sky130_fd_sc_hd__fill_1
XFILLER_55_222 VGND VGND VPWR VPWR sky130_fd_sc_hd__fill_2
XFILLER_68_594 VGND VGND VPWR VPWR sky130_fd_sc_hd__decap_3
XPHY_EDGE_ROW_74_Left_168 VGND VGND VPWR VPWR sky130_fd_sc_hd__decap_3
Xg_row\[1\].g_col\[1\].pe__2488_ g_row\[1\].g_col\[1\].pe__2579_/C g_row\[1\].g_col\[1\].pe__2488_/B
+ VGND VGND VPWR VPWR g_row\[1\].g_col\[1\].pe__2575_/A sky130_fd_sc_hd__and2_2
Xg_row\[1\].g_col\[1\].pe__1508_ g_row\[1\].g_col\[1\].pe__1478_/A g_row\[1\].g_col\[1\].pe__1478_/B
+ g_row\[1\].g_col\[1\].pe__1507_/X VGND VGND VPWR VPWR g_row\[1\].g_col\[1\].pe__1549_/C
+ sky130_fd_sc_hd__a21o_2
XFILLER_43_406 VGND VGND VPWR VPWR sky130_fd_sc_hd__decap_3
XFILLER_71_704 VGND VGND VPWR VPWR sky130_fd_sc_hd__decap_3
XTAP_TAPCELL_ROW_26_604 VGND VPWR sky130_fd_sc_hd__tapvpwrvgnd_1
Xg_row\[0\].g_col\[1\].pe_hold2036 g_row\[0\].g_col\[1\].pe__2594_/X VGND VGND VPWR
+ VPWR g_row\[0\].g_col\[1\].pe__2595_/B sky130_fd_sc_hd__clkbuf_2
Xg_row\[0\].g_col\[1\].pe__2704_ _336_/CLK g_row\[0\].g_col\[1\].pe__2704_/D VGND
+ VGND VPWR VPWR g_row\[0\].g_col\[1\].pe__2704_/Q sky130_fd_sc_hd__dfxtp_2
XFILLER_15_119 VGND VGND VPWR VPWR sky130_fd_sc_hd__fill_1
XFILLER_36_480 VGND VGND VPWR VPWR sky130_fd_sc_hd__decap_3
XFILLER_55_288 VGND VGND VPWR VPWR sky130_fd_sc_hd__decap_3
XFILLER_71_737 VGND VGND VPWR VPWR sky130_fd_sc_hd__decap_3
Xg_row\[0\].g_col\[1\].pe__2635_ place1195/X place1198/X g_row\[0\].g_col\[1\].pe__2635_/C
+ g_row\[0\].g_col\[1\].pe__2635_/D VGND VGND VPWR VPWR g_row\[0\].g_col\[1\].pe__2635_/X
+ sky130_fd_sc_hd__or4_2
XFILLER_12_804 VGND VGND VPWR VPWR sky130_fd_sc_hd__decap_3
XFILLER_24_664 VGND VGND VPWR VPWR sky130_fd_sc_hd__decap_3
XFILLER_62_15 VGND VGND VPWR VPWR sky130_fd_sc_hd__fill_1
Xg_row\[0\].g_col\[0\].pe__2619_ g_row\[0\].g_col\[0\].pe__2640_/A1 g_row\[0\].g_col\[0\].pe__2619_/A2
+ g_row\[0\].g_col\[0\].pe__2640_/C1 g_row\[0\].g_col\[0\].pe__2618_/X VGND VGND VPWR
+ VPWR g_row\[0\].g_col\[0\].pe__2619_/X sky130_fd_sc_hd__o211a_2
XFILLER_51_472 VGND VGND VPWR VPWR sky130_fd_sc_hd__decap_3
XFILLER_62_59 VGND VGND VPWR VPWR sky130_fd_sc_hd__fill_1
XFILLER_11_325 VGND VGND VPWR VPWR sky130_fd_sc_hd__decap_3
Xg_row\[0\].g_col\[1\].pe__1517_ g_row\[0\].g_col\[1\].pe__1728_/A g_row\[0\].g_col\[1\].pe__1517_/B
+ VGND VGND VPWR VPWR g_row\[0\].g_col\[1\].pe__1580_/A sky130_fd_sc_hd__xnor2_2
Xg_row\[0\].g_col\[1\].pe_place1237 place1241/X VGND VGND VPWR VPWR g_row\[0\].g_col\[1\].pe__2663_/A
+ sky130_fd_sc_hd__buf_6
Xg_row\[0\].g_col\[1\].pe__2497_ g_row\[0\].g_col\[1\].pe__2497_/A g_row\[0\].g_col\[1\].pe__2497_/B
+ VGND VGND VPWR VPWR g_row\[0\].g_col\[1\].pe__2546_/B sky130_fd_sc_hd__nor2_2
XFILLER_11_369 VGND VGND VPWR VPWR sky130_fd_sc_hd__fill_2
Xg_row\[0\].g_col\[1\].pe__1448_ g_row\[0\].g_col\[1\].pe__2729_/Q g_row\[0\].g_col\[1\].pe__2728_/Q
+ g_row\[0\].g_col\[1\].pe__2730_/Q VGND VGND VPWR VPWR g_row\[0\].g_col\[1\].pe__1449_/B
+ sky130_fd_sc_hd__or3b_4
XPHY_EDGE_ROW_83_Left_177 VGND VGND VPWR VPWR sky130_fd_sc_hd__decap_3
XFILLER_2_3 VGND VGND VPWR VPWR sky130_fd_sc_hd__fill_1
XFILLER_59_561 VGND VGND VPWR VPWR sky130_fd_sc_hd__decap_3
XPHY_EDGE_ROW_92_Left_186 VGND VGND VPWR VPWR sky130_fd_sc_hd__decap_3
XFILLER_74_531 VGND VGND VPWR VPWR sky130_fd_sc_hd__fill_1
XFILLER_74_564 VGND VGND VPWR VPWR sky130_fd_sc_hd__decap_3
XTAP_TAPCELL_ROW_66_1207 VGND VPWR sky130_fd_sc_hd__tapvpwrvgnd_1
XFILLER_34_417 VGND VGND VPWR VPWR sky130_fd_sc_hd__decap_3
XFILLER_46_277 VGND VGND VPWR VPWR sky130_fd_sc_hd__decap_3
XFILLER_15_642 VGND VGND VPWR VPWR sky130_fd_sc_hd__decap_3
XPHY_EDGE_ROW_1_Left_95 VGND VGND VPWR VPWR sky130_fd_sc_hd__decap_3
XFILLER_30_612 VGND VGND VPWR VPWR sky130_fd_sc_hd__decap_3
Xg_row\[0\].g_col\[1\].pe_hold1880 g_row\[0\].g_col\[1\].pe__2560_/X VGND VGND VPWR
+ VPWR g_row\[0\].g_col\[1\].pe__2561_/B sky130_fd_sc_hd__clkbuf_2
XFILLER_30_645 VGND VGND VPWR VPWR sky130_fd_sc_hd__decap_3
X_317_ _324_/CLK _317_/D VGND VGND VPWR VPWR _317_/Q sky130_fd_sc_hd__dfxtp_2
XFILLER_7_841 VGND VGND VPWR VPWR sky130_fd_sc_hd__fill_1
XTAP_TAPCELL_ROW_12_386 VGND VPWR sky130_fd_sc_hd__tapvpwrvgnd_1
Xg_row\[1\].g_col\[0\].pe__1912_ g_row\[1\].g_col\[0\].pe__2085_/A g_row\[1\].g_col\[0\].pe__1912_/B
+ VGND VGND VPWR VPWR g_row\[1\].g_col\[0\].pe__1955_/B sky130_fd_sc_hd__xnor2_2
XTAP_TAPCELL_ROW_12_397 VGND VPWR sky130_fd_sc_hd__tapvpwrvgnd_1
X_179_ _189_/A _179_/B_N VGND VGND VPWR VPWR _179_/Y sky130_fd_sc_hd__nor2b_4
Xg_row\[1\].g_col\[0\].pe__1843_ g_row\[1\].g_col\[0\].pe__1843_/A g_row\[1\].g_col\[0\].pe__1843_/B
+ VGND VGND VPWR VPWR g_row\[1\].g_col\[0\].pe__1891_/A sky130_fd_sc_hd__nand2_2
XTAP_TAPCELL_ROW_77_1358 VGND VPWR sky130_fd_sc_hd__tapvpwrvgnd_1
XTAP_TAPCELL_ROW_77_1369 VGND VPWR sky130_fd_sc_hd__tapvpwrvgnd_1
Xg_row\[1\].g_col\[1\].pe__1790_ g_row\[1\].g_col\[1\].pe__1795_/B g_row\[1\].g_col\[1\].pe__1790_/B
+ VGND VGND VPWR VPWR g_row\[1\].g_col\[1\].pe__1811_/A sky130_fd_sc_hd__nand2_2
Xg_row\[1\].g_col\[0\].pe__1774_ g_row\[1\].g_col\[0\].pe__1774_/A g_row\[1\].g_col\[0\].pe__1774_/B
+ VGND VGND VPWR VPWR g_row\[1\].g_col\[0\].pe__1774_/Y sky130_fd_sc_hd__nor2_2
XFILLER_35_3 VGND VGND VPWR VPWR sky130_fd_sc_hd__fill_1
XFILLER_69_314 VGND VGND VPWR VPWR sky130_fd_sc_hd__fill_2
XTAP_TAPCELL_ROW_90_1558 VGND VPWR sky130_fd_sc_hd__tapvpwrvgnd_1
Xg_row\[0\].g_col\[0\].pe__1921_ hold2340/A g_row\[0\].g_col\[0\].pe__1982_/B VGND
+ VGND VPWR VPWR g_row\[0\].g_col\[0\].pe__1924_/B sky130_fd_sc_hd__and2_2
Xhold1508 hold3317/X VGND VGND VPWR VPWR hold3318/A sky130_fd_sc_hd__clkbuf_2
XFILLER_38_701 VGND VGND VPWR VPWR sky130_fd_sc_hd__fill_1
Xg_row\[0\].g_col\[0\].pe__1852_ g_row\[0\].g_col\[0\].pe__1615_/A g_row\[0\].g_col\[0\].pe__1615_/B
+ g_row\[0\].g_col\[0\].pe__1851_/X VGND VGND VPWR VPWR g_row\[0\].g_col\[0\].pe__1859_/A
+ sky130_fd_sc_hd__a21o_2
Xhold1519 hold3264/X VGND VGND VPWR VPWR hold3265/A sky130_fd_sc_hd__clkbuf_2
Xg_row\[1\].g_col\[1\].pe__2411_ g_row\[1\].g_col\[1\].pe__2740_/Q g_row\[1\].g_col\[1\].pe__2739_/Q
+ g_row\[1\].g_col\[1\].pe__2754_/Q VGND VGND VPWR VPWR g_row\[1\].g_col\[1\].pe__2455_/B
+ sky130_fd_sc_hd__o21ba_2
Xg_row\[0\].g_col\[0\].pe__1783_ g_row\[0\].g_col\[0\].pe__1808_/A g_row\[0\].g_col\[0\].pe__1783_/B
+ VGND VGND VPWR VPWR g_row\[0\].g_col\[0\].pe__1796_/A sky130_fd_sc_hd__xnor2_2
Xg_row\[1\].g_col\[1\].pe__2342_ g_row\[1\].g_col\[1\].pe__2388_/A g_row\[1\].g_col\[1\].pe__1540_/X
+ g_row\[1\].g_col\[1\].pe__2341_/Y g_row\[1\].g_col\[1\].pe__2736_/Q VGND VGND VPWR
+ VPWR g_row\[1\].g_col\[1\].pe__2365_/A sky130_fd_sc_hd__a22o_2
Xg_row\[1\].g_col\[0\].pe__2326_ g_row\[1\].g_col\[0\].pe__2327_/A g_row\[1\].g_col\[0\].pe__2327_/B
+ g_row\[1\].g_col\[0\].pe__2327_/C VGND VGND VPWR VPWR g_row\[1\].g_col\[0\].pe__2355_/A
+ sky130_fd_sc_hd__o21a_2
XFILLER_25_406 VGND VGND VPWR VPWR sky130_fd_sc_hd__fill_1
XFILLER_65_564 VGND VGND VPWR VPWR sky130_fd_sc_hd__decap_3
Xg_row\[1\].g_col\[1\].pe__2273_ g_row\[1\].g_col\[1\].pe__2273_/A g_row\[1\].g_col\[1\].pe__2273_/B
+ VGND VGND VPWR VPWR g_row\[1\].g_col\[1\].pe__2287_/A sky130_fd_sc_hd__or2_2
Xg_row\[1\].g_col\[0\].pe__2257_ g_row\[1\].g_col\[0\].pe__2257_/A g_row\[1\].g_col\[0\].pe__2272_/B
+ VGND VGND VPWR VPWR g_row\[1\].g_col\[0\].pe__2330_/A sky130_fd_sc_hd__xor2_2
XFILLER_52_236 VGND VGND VPWR VPWR sky130_fd_sc_hd__decap_3
Xg_row\[1\].g_col\[0\].pe__2188_ g_row\[1\].g_col\[0\].pe__2143_/A g_row\[1\].g_col\[0\].pe__2143_/B
+ g_row\[1\].g_col\[0\].pe__2187_/X VGND VGND VPWR VPWR g_row\[1\].g_col\[0\].pe__2190_/B
+ sky130_fd_sc_hd__a21oi_2
Xg_row\[0\].g_col\[1\].pe__2420_ g_row\[0\].g_col\[1\].pe__2754_/Q g_row\[0\].g_col\[1\].pe__2336_/Y
+ g_row\[0\].g_col\[1\].pe__2429_/B VGND VGND VPWR VPWR g_row\[0\].g_col\[1\].pe__2426_/B
+ sky130_fd_sc_hd__o21ai_2
Xg_row\[0\].g_col\[0\].pe__2404_ g_row\[0\].g_col\[0\].pe__2676_/A g_row\[0\].g_col\[0\].pe__2403_/Y
+ g_row\[0\].g_col\[0\].pe__2404_/B1 g_row\[0\].g_col\[0\].pe__2010_/A VGND VGND VPWR
+ VPWR g_row\[0\].g_col\[0\].pe__2404_/X sky130_fd_sc_hd__o22a_2
Xg_row\[1\].g_col\[0\].pe_place1068 g_row\[1\].g_col\[0\].pe__2728_/Q VGND VGND VPWR
+ VPWR g_row\[1\].g_col\[0\].pe__1924_/A sky130_fd_sc_hd__buf_6
Xg_row\[0\].g_col\[0\].pe__2335_ g_row\[0\].g_col\[0\].pe__2335_/A g_row\[0\].g_col\[0\].pe__2335_/B
+ VGND VGND VPWR VPWR g_row\[0\].g_col\[0\].pe__2750_/D sky130_fd_sc_hd__nor2_2
Xg_row\[0\].g_col\[0\].pe_hold2270 g_row\[0\].g_col\[0\].pe__2644_/X VGND VGND VPWR
+ VPWR g_row\[0\].g_col\[0\].pe__2707_/D sky130_fd_sc_hd__clkbuf_2
Xg_row\[1\].g_col\[0\].pe_place1079 place1080/X VGND VGND VPWR VPWR g_row\[1\].g_col\[0\].pe__2121_/A
+ sky130_fd_sc_hd__buf_6
Xg_row\[0\].g_col\[1\].pe__2351_ g_row\[0\].g_col\[1\].pe__2352_/A g_row\[0\].g_col\[1\].pe__2352_/B
+ g_row\[0\].g_col\[1\].pe__2352_/C VGND VGND VPWR VPWR g_row\[0\].g_col\[1\].pe__2375_/A
+ sky130_fd_sc_hd__a21oi_2
XFILLER_21_689 VGND VGND VPWR VPWR sky130_fd_sc_hd__decap_3
Xg_row\[0\].g_col\[0\].pe_hold2281 g_row\[0\].g_col\[0\].pe__2685_/A1 VGND VGND VPWR
+ VPWR g_row\[0\].g_col\[0\].pe__2646_/A2 sky130_fd_sc_hd__clkbuf_2
Xg_row\[0\].g_col\[0\].pe_hold2292 g_row\[0\].g_col\[0\].pe__2652_/X VGND VGND VPWR
+ VPWR g_row\[0\].g_col\[0\].pe__2711_/D sky130_fd_sc_hd__clkbuf_2
Xg_row\[0\].g_col\[1\].pe_place862 g_row\[0\].g_col\[1\].pe__1424_/Y VGND VGND VPWR
+ VPWR g_row\[0\].g_col\[1\].pe__1732_/B1 sky130_fd_sc_hd__buf_6
Xg_row\[0\].g_col\[1\].pe__2282_ g_row\[0\].g_col\[1\].pe__2283_/A g_row\[0\].g_col\[1\].pe__2283_/B
+ VGND VGND VPWR VPWR g_row\[0\].g_col\[1\].pe__2284_/A sky130_fd_sc_hd__nor2_2
XFILLER_20_188 VGND VGND VPWR VPWR sky130_fd_sc_hd__decap_3
XTAP_TAPCELL_ROW_31_673 VGND VPWR sky130_fd_sc_hd__tapvpwrvgnd_1
Xg_row\[0\].g_col\[0\].pe__2266_ g_row\[0\].g_col\[0\].pe__2266_/A VGND VGND VPWR
+ VPWR g_row\[0\].g_col\[0\].pe__2266_/Y sky130_fd_sc_hd__inv_2
Xg_row\[0\].g_col\[0\].pe__2197_ g_row\[0\].g_col\[0\].pe__2161_/Y g_row\[0\].g_col\[0\].pe__2157_/B
+ g_row\[0\].g_col\[0\].pe__2200_/B VGND VGND VPWR VPWR g_row\[0\].g_col\[0\].pe__2197_/Y
+ sky130_fd_sc_hd__a21oi_2
Xhold3400 hold3400/A VGND VGND VPWR VPWR hold3400/X sky130_fd_sc_hd__clkbuf_2
Xg_row\[1\].g_col\[1\].pe__1988_ g_row\[1\].g_col\[1\].pe__2043_/A g_row\[1\].g_col\[1\].pe__1988_/B
+ g_row\[1\].g_col\[1\].pe__1988_/C VGND VGND VPWR VPWR g_row\[1\].g_col\[1\].pe__1988_/X
+ sky130_fd_sc_hd__and3b_4
Xoutput1361 output1361/A VGND VGND VPWR VPWR results_flat[15] sky130_fd_sc_hd__buf_2
Xhold3433 hold3433/A VGND VGND VPWR VPWR hold3433/X sky130_fd_sc_hd__clkbuf_2
Xhold3422 hold3422/A VGND VGND VPWR VPWR hold3422/X sky130_fd_sc_hd__clkbuf_2
Xhold3411 hold3411/A VGND VGND VPWR VPWR hold3411/X sky130_fd_sc_hd__clkbuf_2
XFILLER_76_807 VGND VGND VPWR VPWR sky130_fd_sc_hd__fill_1
XFILLER_88_645 VGND VGND VPWR VPWR sky130_fd_sc_hd__decap_3
Xhold2710 hold3414/X VGND VGND VPWR VPWR hold3415/A sky130_fd_sc_hd__clkbuf_2
Xhold2721 hold3517/X VGND VGND VPWR VPWR hold3518/A sky130_fd_sc_hd__clkbuf_2
Xhold2732 hold3494/X VGND VGND VPWR VPWR hold3495/A sky130_fd_sc_hd__clkbuf_2
Xoutput1394 output1394/A VGND VGND VPWR VPWR results_flat[45] sky130_fd_sc_hd__buf_2
Xoutput1383 output1383/A VGND VGND VPWR VPWR results_flat[35] sky130_fd_sc_hd__buf_2
Xoutput1372 output1372/A VGND VGND VPWR VPWR results_flat[25] sky130_fd_sc_hd__buf_2
Xhold3466 a_inputs_flat[15] VGND VGND VPWR VPWR hold3466/X sky130_fd_sc_hd__clkbuf_2
Xhold3455 hold3455/A VGND VGND VPWR VPWR hold3455/X sky130_fd_sc_hd__clkbuf_2
Xhold3444 hold3444/A VGND VGND VPWR VPWR hold3444/X sky130_fd_sc_hd__clkbuf_2
Xclkbuf_4_5_0_clk clkbuf_0_clk/X VGND VGND VPWR VPWR clkload2/A sky130_fd_sc_hd__clkbuf_16
Xhold2743 hold2743/A VGND VGND VPWR VPWR _275_/D sky130_fd_sc_hd__clkbuf_2
Xhold2754 _145_/Y VGND VGND VPWR VPWR hold2754/X sky130_fd_sc_hd__clkbuf_2
Xhold2765 hold2765/A VGND VGND VPWR VPWR _165_/B_N sky130_fd_sc_hd__clkbuf_2
Xhold3499 hold3499/A VGND VGND VPWR VPWR hold3499/X sky130_fd_sc_hd__clkbuf_2
Xhold3488 hold3488/A VGND VGND VPWR VPWR hold3488/X sky130_fd_sc_hd__clkbuf_2
Xhold3477 hold3477/A VGND VGND VPWR VPWR hold3477/X sky130_fd_sc_hd__clkbuf_2
XFILLER_28_200 VGND VGND VPWR VPWR sky130_fd_sc_hd__decap_3
XFILLER_56_520 VGND VGND VPWR VPWR sky130_fd_sc_hd__decap_3
XFILLER_84_840 VGND VGND VPWR VPWR sky130_fd_sc_hd__fill_2
Xhold2776 hold3557/X VGND VGND VPWR VPWR hold3558/A sky130_fd_sc_hd__clkbuf_2
Xhold2787 hold3567/X VGND VGND VPWR VPWR hold3568/A sky130_fd_sc_hd__clkbuf_2
Xhold2798 hold3589/X VGND VGND VPWR VPWR hold3590/A sky130_fd_sc_hd__clkbuf_2
Xg_row\[0\].g_col\[1\].pe__1997_ g_row\[0\].g_col\[1\].pe__1997_/A g_row\[0\].g_col\[1\].pe__1997_/B
+ VGND VGND VPWR VPWR g_row\[0\].g_col\[1\].pe__2014_/B sky130_fd_sc_hd__xor2_2
XFILLER_71_501 VGND VGND VPWR VPWR sky130_fd_sc_hd__decap_3
XFILLER_83_350 VGND VGND VPWR VPWR sky130_fd_sc_hd__fill_2
XFILLER_44_748 VGND VGND VPWR VPWR sky130_fd_sc_hd__fill_1
XTAP_TAPCELL_ROW_39_795 VGND VPWR sky130_fd_sc_hd__tapvpwrvgnd_1
XFILLER_71_556 VGND VGND VPWR VPWR sky130_fd_sc_hd__fill_1
XFILLER_71_567 VGND VGND VPWR VPWR sky130_fd_sc_hd__decap_3
XFILLER_24_472 VGND VGND VPWR VPWR sky130_fd_sc_hd__decap_3
Xg_row\[0\].g_col\[1\].pe__2618_ g_row\[0\].g_col\[1\].pe__2669_/A g_row\[0\].g_col\[1\].pe__2618_/B
+ VGND VGND VPWR VPWR g_row\[0\].g_col\[1\].pe__2618_/X sky130_fd_sc_hd__or2_2
XFILLER_11_100 VGND VGND VPWR VPWR sky130_fd_sc_hd__decap_3
XFILLER_12_645 VGND VGND VPWR VPWR sky130_fd_sc_hd__decap_3
XFILLER_24_483 VGND VGND VPWR VPWR sky130_fd_sc_hd__decap_3
XFILLER_52_792 VGND VGND VPWR VPWR sky130_fd_sc_hd__fill_1
XTAP_TAPCELL_ROW_61_1126 VGND VPWR sky130_fd_sc_hd__tapvpwrvgnd_1
Xg_row\[0\].g_col\[1\].pe__2549_ g_row\[0\].g_col\[1\].pe__2592_/A g_row\[0\].g_col\[1\].pe__2549_/B
+ VGND VGND VPWR VPWR g_row\[0\].g_col\[1\].pe__2761_/D sky130_fd_sc_hd__and2_2
XTAP_TAPCELL_ROW_50_960 VGND VPWR sky130_fd_sc_hd__tapvpwrvgnd_1
XTAP_TAPCELL_ROW_59_1088 VGND VPWR sky130_fd_sc_hd__tapvpwrvgnd_1
XTAP_TAPCELL_ROW_59_1099 VGND VPWR sky130_fd_sc_hd__tapvpwrvgnd_1
XFILLER_78_122 VGND VGND VPWR VPWR sky130_fd_sc_hd__decap_3
XFILLER_79_656 VGND VGND VPWR VPWR sky130_fd_sc_hd__decap_3
Xg_row\[1\].g_col\[0\].pe__1490_ g_row\[1\].g_col\[0\].pe__1490_/A g_row\[1\].g_col\[0\].pe__1490_/B
+ VGND VGND VPWR VPWR g_row\[1\].g_col\[0\].pe__1512_/B sky130_fd_sc_hd__xnor2_2
XTAP_TAPCELL_ROW_72_1288 VGND VPWR sky130_fd_sc_hd__tapvpwrvgnd_1
XFILLER_19_233 VGND VGND VPWR VPWR sky130_fd_sc_hd__fill_2
XFILLER_47_586 VGND VGND VPWR VPWR sky130_fd_sc_hd__decap_3
XFILLER_47_597 VGND VGND VPWR VPWR sky130_fd_sc_hd__decap_3
XFILLER_90_810 VGND VGND VPWR VPWR sky130_fd_sc_hd__fill_2
Xg_row\[1\].g_col\[0\].pe__2111_ g_row\[1\].g_col\[0\].pe__2111_/A g_row\[1\].g_col\[0\].pe__2153_/C
+ VGND VGND VPWR VPWR g_row\[1\].g_col\[0\].pe__2111_/X sky130_fd_sc_hd__or2b_2
XFILLER_34_236 VGND VGND VPWR VPWR sky130_fd_sc_hd__fill_1
Xg_row\[1\].g_col\[0\].pe__2042_ g_row\[1\].g_col\[0\].pe__2043_/A g_row\[1\].g_col\[0\].pe__2043_/B
+ VGND VGND VPWR VPWR g_row\[1\].g_col\[0\].pe__2094_/C sky130_fd_sc_hd__or2_2
XFILLER_62_589 VGND VGND VPWR VPWR sky130_fd_sc_hd__fill_1
XTAP_TAPCELL_ROW_17_467 VGND VPWR sky130_fd_sc_hd__tapvpwrvgnd_1
XFILLER_30_453 VGND VGND VPWR VPWR sky130_fd_sc_hd__decap_3
Xg_row\[0\].g_col\[0\].pe__2120_ g_row\[0\].g_col\[0\].pe__2078_/A g_row\[0\].g_col\[0\].pe__2078_/B
+ g_row\[0\].g_col\[0\].pe__2119_/X VGND VGND VPWR VPWR g_row\[0\].g_col\[0\].pe__2147_/A
+ sky130_fd_sc_hd__a21o_2
XFILLER_8_97 VGND VGND VPWR VPWR sky130_fd_sc_hd__decap_3
Xg_row\[0\].g_col\[0\].pe__2051_ g_row\[0\].g_col\[0\].pe__2048_/Y g_row\[0\].g_col\[0\].pe__2049_/X
+ g_row\[0\].g_col\[0\].pe__2025_/Y g_row\[0\].g_col\[0\].pe__1991_/X VGND VGND VPWR
+ VPWR g_row\[0\].g_col\[0\].pe__2052_/C sky130_fd_sc_hd__a211oi_2
Xg_row\[1\].g_col\[1\].pe__1911_ g_row\[1\].g_col\[1\].pe__2241_/B2 g_row\[1\].g_col\[1\].pe__2163_/B
+ g_row\[1\].g_col\[1\].pe__1461_/Y g_row\[1\].g_col\[1\].pe__2036_/B2 VGND VGND VPWR
+ VPWR g_row\[1\].g_col\[1\].pe__1912_/B sky130_fd_sc_hd__a22o_2
Xg_row\[1\].g_col\[1\].pe__1842_ g_row\[1\].g_col\[1\].pe__1702_/X g_row\[1\].g_col\[1\].pe__1829_/Y
+ g_row\[1\].g_col\[1\].pe__1834_/A g_row\[1\].g_col\[1\].pe__1832_/Y VGND VGND VPWR
+ VPWR g_row\[1\].g_col\[1\].pe__1843_/B sky130_fd_sc_hd__a211o_2
Xg_row\[1\].g_col\[0\].pe__1826_ g_row\[1\].g_col\[0\].pe__1828_/A g_row\[1\].g_col\[0\].pe__1828_/B
+ VGND VGND VPWR VPWR g_row\[1\].g_col\[0\].pe__1826_/Y sky130_fd_sc_hd__nor2_2
Xg_row\[1\].g_col\[1\].pe__1773_ g_row\[1\].g_col\[1\].pe__1816_/A g_row\[1\].g_col\[1\].pe__1816_/B
+ VGND VGND VPWR VPWR g_row\[1\].g_col\[1\].pe__1778_/A sky130_fd_sc_hd__nand2_2
Xg_row\[1\].g_col\[0\].pe__1757_ g_row\[1\].g_col\[0\].pe__1770_/A g_row\[1\].g_col\[0\].pe__1770_/B
+ g_row\[1\].g_col\[0\].pe__1756_/X VGND VGND VPWR VPWR g_row\[1\].g_col\[0\].pe__1774_/A
+ sky130_fd_sc_hd__a21oi_2
Xg_row\[0\].g_col\[0\].pe__1904_ g_row\[0\].g_col\[0\].pe__1905_/A g_row\[0\].g_col\[0\].pe__1905_/B
+ VGND VGND VPWR VPWR g_row\[0\].g_col\[0\].pe__1964_/A sky130_fd_sc_hd__nand2_2
Xg_row\[1\].g_col\[0\].pe_hold2930 _307_/Q VGND VGND VPWR VPWR g_row\[1\].g_col\[0\].pe_hold2930/X
+ sky130_fd_sc_hd__clkbuf_2
Xg_row\[1\].g_col\[0\].pe__1688_ g_row\[1\].g_col\[0\].pe__1688_/A g_row\[1\].g_col\[0\].pe__1688_/B
+ VGND VGND VPWR VPWR g_row\[1\].g_col\[0\].pe__1721_/B sky130_fd_sc_hd__xnor2_2
Xg_row\[0\].g_col\[1\].pe__1920_ g_row\[0\].g_col\[1\].pe__2125_/A g_row\[0\].g_col\[1\].pe__1801_/B
+ g_row\[0\].g_col\[1\].pe__2043_/A VGND VGND VPWR VPWR g_row\[0\].g_col\[1\].pe__1980_/A
+ sky130_fd_sc_hd__o21bai_2
XFILLER_84_125 VGND VGND VPWR VPWR sky130_fd_sc_hd__fill_2
Xg_row\[1\].g_col\[0\].pe_hold2985 hold1884/X VGND VGND VPWR VPWR g_row\[1\].g_col\[0\].pe__2668_/A2
+ sky130_fd_sc_hd__clkbuf_2
Xg_row\[1\].g_col\[0\].pe_hold2974 g_row\[1\].g_col\[0\].pe__2637_/B VGND VGND VPWR
+ VPWR g_row\[1\].g_col\[0\].pe__2611_/A2 sky130_fd_sc_hd__clkbuf_2
Xg_row\[0\].g_col\[1\].pe__1851_ g_row\[0\].g_col\[1\].pe__1851_/A g_row\[0\].g_col\[1\].pe__1851_/B
+ VGND VGND VPWR VPWR g_row\[0\].g_col\[1\].pe__1851_/X sky130_fd_sc_hd__and2_2
Xg_row\[0\].g_col\[0\].pe__1835_ g_row\[0\].g_col\[0\].pe__1950_/A g_row\[0\].g_col\[0\].pe__1835_/A2
+ g_row\[0\].g_col\[0\].pe__2157_/A g_row\[0\].g_col\[0\].pe__1834_/Y VGND VGND VPWR
+ VPWR g_row\[0\].g_col\[0\].pe__1835_/X sky130_fd_sc_hd__a22o_2
Xg_row\[1\].g_col\[0\].pe_hold2996 g_row\[1\].g_col\[0\].pe__2731_/Q VGND VGND VPWR
+ VPWR g_row\[1\].g_col\[0\].pe__1391_/A1 sky130_fd_sc_hd__clkbuf_2
XFILLER_53_512 VGND VGND VPWR VPWR sky130_fd_sc_hd__fill_2
XFILLER_65_372 VGND VGND VPWR VPWR sky130_fd_sc_hd__decap_3
Xg_row\[0\].g_col\[0\].pe__1766_ g_row\[0\].g_col\[0\].pe__1766_/A g_row\[0\].g_col\[0\].pe__1766_/B
+ VGND VGND VPWR VPWR g_row\[0\].g_col\[0\].pe__1781_/A sky130_fd_sc_hd__xor2_2
Xg_row\[1\].g_col\[1\].pe__2325_ g_row\[1\].g_col\[1\].pe__2325_/A g_row\[1\].g_col\[1\].pe__2338_/A
+ VGND VGND VPWR VPWR g_row\[1\].g_col\[1\].pe__2327_/C sky130_fd_sc_hd__xnor2_2
Xg_row\[1\].g_col\[0\].pe__2309_ g_row\[1\].g_col\[0\].pe__2287_/A g_row\[1\].g_col\[0\].pe__2309_/B
+ VGND VGND VPWR VPWR g_row\[1\].g_col\[0\].pe__2327_/A sky130_fd_sc_hd__and2b_2
Xg_row\[0\].g_col\[1\].pe__1782_ g_row\[0\].g_col\[1\].pe__1804_/A g_row\[0\].g_col\[1\].pe__1782_/A2
+ g_row\[0\].g_col\[1\].pe__1799_/A2 g_row\[0\].g_col\[1\].pe__1804_/B VGND VGND VPWR
+ VPWR g_row\[0\].g_col\[1\].pe__1783_/B sky130_fd_sc_hd__a22o_2
XFILLER_25_225 VGND VGND VPWR VPWR sky130_fd_sc_hd__fill_1
XFILLER_25_258 VGND VGND VPWR VPWR sky130_fd_sc_hd__fill_1
XTAP_TAPCELL_ROW_36_743 VGND VPWR sky130_fd_sc_hd__tapvpwrvgnd_1
XTAP_TAPCELL_ROW_36_754 VGND VPWR sky130_fd_sc_hd__tapvpwrvgnd_1
Xg_row\[1\].g_col\[1\].pe__2256_ g_row\[1\].g_col\[1\].pe__2213_/A g_row\[1\].g_col\[1\].pe__2213_/B
+ g_row\[1\].g_col\[1\].pe__2220_/B g_row\[1\].g_col\[1\].pe__2219_/B g_row\[1\].g_col\[1\].pe__2219_/A
+ VGND VGND VPWR VPWR g_row\[1\].g_col\[1\].pe__2272_/B sky130_fd_sc_hd__a32o_2
Xg_row\[0\].g_col\[0\].pe__1697_ g_row\[0\].g_col\[0\].pe__1697_/A g_row\[0\].g_col\[0\].pe__1697_/B
+ VGND VGND VPWR VPWR g_row\[0\].g_col\[0\].pe__1699_/B sky130_fd_sc_hd__xnor2_2
XFILLER_34_792 VGND VGND VPWR VPWR sky130_fd_sc_hd__fill_2
Xg_row\[1\].g_col\[1\].pe__2187_ g_row\[1\].g_col\[1\].pe__2142_/A g_row\[1\].g_col\[1\].pe__2187_/B
+ VGND VGND VPWR VPWR g_row\[1\].g_col\[1\].pe__2187_/X sky130_fd_sc_hd__and2b_2
Xg_row\[0\].g_col\[1\].pe__2403_ g_row\[0\].g_col\[1\].pe__2403_/A VGND VGND VPWR
+ VPWR g_row\[0\].g_col\[1\].pe__2403_/Y sky130_fd_sc_hd__inv_2
XFILLER_33_291 VGND VGND VPWR VPWR sky130_fd_sc_hd__decap_3
Xg_row\[0\].g_col\[1\].pe__2334_ g_row\[0\].g_col\[1\].pe__2406_/B1 g_row\[0\].g_col\[1\].pe__2334_/A2
+ g_row\[0\].g_col\[1\].pe__2331_/X g_row\[0\].g_col\[1\].pe__2333_/Y VGND VGND VPWR
+ VPWR g_row\[0\].g_col\[1\].pe__2334_/X sky130_fd_sc_hd__o22a_2
Xg_row\[0\].g_col\[0\].pe__2318_ g_row\[0\].g_col\[0\].pe__2318_/A g_row\[0\].g_col\[0\].pe__2318_/B
+ VGND VGND VPWR VPWR g_row\[0\].g_col\[0\].pe__2319_/B sky130_fd_sc_hd__xor2_2
Xg_row\[0\].g_col\[0\].pe__2249_ ANTENNA_182/DIODE g_row\[0\].g_col\[0\].pe__2250_/B
+ VGND VGND VPWR VPWR g_row\[0\].g_col\[0\].pe__2283_/A sky130_fd_sc_hd__or2_2
Xg_row\[0\].g_col\[1\].pe__2265_ g_row\[0\].g_col\[1\].pe__2238_/X g_row\[0\].g_col\[1\].pe__2234_/Y
+ g_row\[0\].g_col\[1\].pe__2263_/X VGND VGND VPWR VPWR g_row\[0\].g_col\[1\].pe__2265_/Y
+ sky130_fd_sc_hd__o21ai_2
Xg_row\[0\].g_col\[1\].pe__2196_ g_row\[0\].g_col\[1\].pe__2161_/Y g_row\[0\].g_col\[1\].pe__2157_/B
+ g_row\[0\].g_col\[1\].pe__2200_/B g_row\[0\].g_col\[1\].pe__2010_/A VGND VGND VPWR
+ VPWR g_row\[0\].g_col\[1\].pe__2196_/X sky130_fd_sc_hd__a31o_2
Xg_row\[1\].g_col\[1\].pe_hold1814 g_row\[1\].g_col\[1\].pe__2764_/Q VGND VGND VPWR
+ VPWR g_row\[1\].g_col\[1\].pe__2564_/A1 sky130_fd_sc_hd__clkbuf_2
Xhold3230 hold3230/A VGND VGND VPWR VPWR hold3230/X sky130_fd_sc_hd__clkbuf_2
Xhold3241 hold3241/A VGND VGND VPWR VPWR hold3241/X sky130_fd_sc_hd__clkbuf_2
Xhold2540 hold3284/X VGND VGND VPWR VPWR hold3285/A sky130_fd_sc_hd__clkbuf_2
Xhold3252 hold3252/A VGND VGND VPWR VPWR hold3252/X sky130_fd_sc_hd__clkbuf_2
Xhold3263 a_inputs_flat[3] VGND VGND VPWR VPWR hold3263/X sky130_fd_sc_hd__clkbuf_2
Xhold3274 hold3274/A VGND VGND VPWR VPWR hold3274/X sky130_fd_sc_hd__clkbuf_2
Xhold3285 hold3285/A VGND VGND VPWR VPWR hold3285/X sky130_fd_sc_hd__clkbuf_2
XFILLER_29_531 VGND VGND VPWR VPWR sky130_fd_sc_hd__decap_3
XFILLER_48_328 VGND VGND VPWR VPWR sky130_fd_sc_hd__decap_3
XFILLER_76_659 VGND VGND VPWR VPWR sky130_fd_sc_hd__decap_3
Xhold2551 hold2551/A VGND VGND VPWR VPWR _273_/D sky130_fd_sc_hd__clkbuf_2
Xhold2562 _207_/Y VGND VGND VPWR VPWR hold2562/X sky130_fd_sc_hd__clkbuf_2
Xhold2573 hold3269/X VGND VGND VPWR VPWR _149_/B_N sky130_fd_sc_hd__clkbuf_2
Xhold3296 hold3296/A VGND VGND VPWR VPWR hold3296/X sky130_fd_sc_hd__clkbuf_2
XFILLER_17_704 VGND VGND VPWR VPWR sky130_fd_sc_hd__fill_2
Xhold2584 hold3358/X VGND VGND VPWR VPWR hold3359/A sky130_fd_sc_hd__clkbuf_2
Xhold2595 hold3391/X VGND VGND VPWR VPWR hold3392/A sky130_fd_sc_hd__clkbuf_2
XFILLER_29_586 VGND VGND VPWR VPWR sky130_fd_sc_hd__decap_3
XFILLER_56_383 VGND VGND VPWR VPWR sky130_fd_sc_hd__fill_1
Xhold1894 hold1894/A VGND VGND VPWR VPWR hold1894/X sky130_fd_sc_hd__clkbuf_2
XFILLER_32_707 VGND VGND VPWR VPWR sky130_fd_sc_hd__fill_1
XFILLER_44_556 VGND VGND VPWR VPWR sky130_fd_sc_hd__decap_3
XFILLER_31_217 VGND VGND VPWR VPWR sky130_fd_sc_hd__decap_3
XFILLER_44_589 VGND VGND VPWR VPWR sky130_fd_sc_hd__decap_3
XFILLER_25_792 VGND VGND VPWR VPWR sky130_fd_sc_hd__fill_1
XFILLER_71_386 VGND VGND VPWR VPWR sky130_fd_sc_hd__fill_2
XTAP_TAPCELL_ROW_14_415 VGND VPWR sky130_fd_sc_hd__tapvpwrvgnd_1
XTAP_TAPCELL_ROW_14_426 VGND VPWR sky130_fd_sc_hd__tapvpwrvgnd_1
XTAP_TAPCELL_ROW_74_1317 VGND VPWR sky130_fd_sc_hd__tapvpwrvgnd_1
Xg_row\[1\].g_col\[0\].pe__2660_ g_row\[1\].g_col\[0\].pe__2670_/A1 g_row\[1\].g_col\[0\].pe__2660_/A2
+ g_row\[1\].g_col\[0\].pe__2670_/B1 g_row\[1\].g_col\[0\].pe__2660_/C1 VGND VGND
+ VPWR VPWR g_row\[1\].g_col\[0\].pe__2660_/X sky130_fd_sc_hd__o211a_2
Xg_row\[1\].g_col\[0\].pe__2591_ g_row\[1\].g_col\[0\].pe__2591_/A1 g_row\[1\].g_col\[0\].pe__2591_/A2
+ g_row\[1\].g_col\[0\].pe__2591_/B1 g_row\[1\].g_col\[0\].pe__2590_/X VGND VGND VPWR
+ VPWR g_row\[1\].g_col\[0\].pe__2591_/X sky130_fd_sc_hd__a22o_2
Xg_row\[1\].g_col\[0\].pe__1611_ g_row\[1\].g_col\[0\].pe__1864_/A g_row\[1\].g_col\[0\].pe__1611_/B
+ VGND VGND VPWR VPWR g_row\[1\].g_col\[0\].pe__1851_/B sky130_fd_sc_hd__xnor2_2
XFILLER_67_615 VGND VGND VPWR VPWR sky130_fd_sc_hd__fill_1
XFILLER_67_659 VGND VGND VPWR VPWR sky130_fd_sc_hd__decap_3
Xg_row\[1\].g_col\[1\].pe_place829 g_row\[1\].g_col\[1\].pe__1761_/B2 VGND VGND VPWR
+ VPWR g_row\[1\].g_col\[1\].pe__1804_/B sky130_fd_sc_hd__buf_6
Xg_row\[1\].g_col\[0\].pe_hold2259 g_row\[1\].g_col\[0\].pe_hold2278/X VGND VGND VPWR
+ VPWR g_row\[1\].g_col\[0\].pe__1406_/A sky130_fd_sc_hd__clkbuf_2
Xg_row\[1\].g_col\[0\].pe__1473_ g_row\[1\].g_col\[0\].pe__2733_/Q g_row\[1\].g_col\[0\].pe__2250_/A
+ g_row\[1\].g_col\[0\].pe__2368_/A VGND VGND VPWR VPWR g_row\[1\].g_col\[0\].pe__1473_/X
+ sky130_fd_sc_hd__or3b_4
XFILLER_48_840 VGND VGND VPWR VPWR sky130_fd_sc_hd__fill_2
Xg_row\[0\].g_col\[0\].pe__1620_ place1198/X g_row\[0\].g_col\[0\].pe__1414_/X g_row\[0\].g_col\[0\].pe__1415_/Y
+ g_row\[0\].g_col\[0\].pe__1784_/B1 place1195/X VGND VGND VPWR VPWR g_row\[0\].g_col\[0\].pe__1621_/B
+ sky130_fd_sc_hd__a32o_2
XFILLER_35_556 VGND VGND VPWR VPWR sky130_fd_sc_hd__decap_3
Xg_row\[0\].g_col\[0\].pe__1551_ g_row\[0\].g_col\[0\].pe__1669_/A g_row\[0\].g_col\[0\].pe__1669_/B
+ VGND VGND VPWR VPWR g_row\[0\].g_col\[0\].pe__1830_/B sky130_fd_sc_hd__and2_2
Xg_row\[1\].g_col\[1\].pe__2110_ g_row\[1\].g_col\[1\].pe__2110_/A g_row\[1\].g_col\[1\].pe__2110_/B
+ VGND VGND VPWR VPWR g_row\[1\].g_col\[1\].pe__2153_/C sky130_fd_sc_hd__or2_2
XFILLER_23_729 VGND VGND VPWR VPWR sky130_fd_sc_hd__decap_3
XTAP_TAPCELL_ROW_33_702 VGND VPWR sky130_fd_sc_hd__tapvpwrvgnd_1
XTAP_TAPCELL_ROW_85_1479 VGND VPWR sky130_fd_sc_hd__tapvpwrvgnd_1
Xg_row\[1\].g_col\[1\].pe__2041_ g_row\[1\].g_col\[1\].pe__2125_/C g_row\[1\].g_col\[1\].pe__2040_/X
+ g_row\[1\].g_col\[1\].pe__1424_/A g_row\[1\].g_col\[1\].pe__2125_/A VGND VGND VPWR
+ VPWR g_row\[1\].g_col\[1\].pe__2043_/B sky130_fd_sc_hd__o2bb2a_2
XFILLER_22_228 VGND VGND VPWR VPWR sky130_fd_sc_hd__decap_3
Xg_row\[0\].g_col\[0\].pe__1482_ g_row\[0\].g_col\[0\].pe__1442_/A g_row\[0\].g_col\[0\].pe__1442_/B
+ g_row\[0\].g_col\[0\].pe__1481_/X VGND VGND VPWR VPWR g_row\[0\].g_col\[0\].pe__1512_/A
+ sky130_fd_sc_hd__a21oi_2
Xg_row\[1\].g_col\[0\].pe__2025_ g_row\[1\].g_col\[0\].pe__1919_/B g_row\[1\].g_col\[0\].pe__1980_/X
+ g_row\[1\].g_col\[0\].pe__1981_/Y g_row\[1\].g_col\[0\].pe__1987_/Y g_row\[1\].g_col\[0\].pe__1988_/X
+ VGND VGND VPWR VPWR g_row\[1\].g_col\[0\].pe__2025_/Y sky130_fd_sc_hd__a311oi_2
XFILLER_30_261 VGND VGND VPWR VPWR sky130_fd_sc_hd__fill_1
Xg_row\[0\].g_col\[0\].pe__2103_ g_row\[0\].g_col\[0\].pe__2052_/A g_row\[0\].g_col\[0\].pe__2052_/C
+ g_row\[0\].g_col\[0\].pe__2052_/B VGND VGND VPWR VPWR g_row\[0\].g_col\[0\].pe__2104_/C
+ sky130_fd_sc_hd__o21bai_2
Xg_row\[0\].g_col\[0\].pe__2034_ g_row\[0\].g_col\[0\].pe__2034_/A g_row\[0\].g_col\[0\].pe__2034_/B
+ g_row\[0\].g_col\[0\].pe__2034_/C g_row\[0\].g_col\[0\].pe__2034_/D VGND VGND VPWR
+ VPWR g_row\[0\].g_col\[0\].pe__2038_/A sky130_fd_sc_hd__nand4_2
Xg_row\[0\].g_col\[1\].pe__2050_ g_row\[0\].g_col\[1\].pe__2025_/Y g_row\[0\].g_col\[1\].pe__1991_/X
+ g_row\[0\].g_col\[1\].pe__2048_/Y g_row\[0\].g_col\[1\].pe__2049_/X VGND VGND VPWR
+ VPWR g_row\[0\].g_col\[1\].pe__2052_/B sky130_fd_sc_hd__o211a_4
Xg_row\[1\].g_col\[1\].pe__1825_ g_row\[1\].g_col\[1\].pe__1747_/A g_row\[1\].g_col\[1\].pe__1820_/B
+ g_row\[1\].g_col\[1\].pe__1824_/X VGND VGND VPWR VPWR g_row\[1\].g_col\[1\].pe__1828_/B
+ sky130_fd_sc_hd__a21oi_2
Xg_row\[1\].g_col\[0\].pe__1809_ g_row\[1\].g_col\[0\].pe__1795_/A g_row\[1\].g_col\[0\].pe__1795_/B
+ g_row\[1\].g_col\[0\].pe__1795_/C VGND VGND VPWR VPWR g_row\[1\].g_col\[0\].pe__1809_/X
+ sky130_fd_sc_hd__a21o_2
Xg_row\[1\].g_col\[1\].pe__1756_ g_row\[1\].g_col\[1\].pe__1756_/A g_row\[1\].g_col\[1\].pe__1756_/B
+ VGND VGND VPWR VPWR g_row\[1\].g_col\[1\].pe__1756_/X sky130_fd_sc_hd__and2_2
Xg_row\[1\].g_col\[1\].pe__1687_ g_row\[1\].g_col\[1\].pe__1713_/A g_row\[1\].g_col\[1\].pe__1713_/B
+ g_row\[1\].g_col\[1\].pe__1686_/X VGND VGND VPWR VPWR g_row\[1\].g_col\[1\].pe__1721_/A
+ sky130_fd_sc_hd__a21oi_2
Xg_row\[0\].g_col\[1\].pe__1903_ g_row\[0\].g_col\[1\].pe__2179_/A g_row\[0\].g_col\[1\].pe__1903_/B
+ VGND VGND VPWR VPWR g_row\[0\].g_col\[1\].pe__1905_/B sky130_fd_sc_hd__xnor2_2
XFILLER_57_169 VGND VGND VPWR VPWR sky130_fd_sc_hd__fill_1
XFILLER_26_523 VGND VGND VPWR VPWR sky130_fd_sc_hd__fill_1
XFILLER_72_117 VGND VGND VPWR VPWR sky130_fd_sc_hd__fill_1
Xg_row\[0\].g_col\[0\].pe__1818_ g_row\[0\].g_col\[0\].pe__1822_/D g_row\[0\].g_col\[0\].pe__1818_/B
+ VGND VGND VPWR VPWR g_row\[0\].g_col\[0\].pe__1821_/C sky130_fd_sc_hd__xnor2_2
Xg_row\[0\].g_col\[1\].pe__1834_ g_row\[0\].g_col\[1\].pe__1834_/A g_row\[0\].g_col\[1\].pe__1834_/B
+ VGND VGND VPWR VPWR g_row\[0\].g_col\[1\].pe__1834_/Y sky130_fd_sc_hd__xnor2_2
XFILLER_53_320 VGND VGND VPWR VPWR sky130_fd_sc_hd__fill_1
XFILLER_54_27 VGND VGND VPWR VPWR sky130_fd_sc_hd__fill_1
Xg_row\[1\].g_col\[1\].pe__2308_ g_row\[1\].g_col\[1\].pe__2308_/A VGND VGND VPWR
+ VPWR g_row\[1\].g_col\[1\].pe__2430_/A sky130_fd_sc_hd__inv_2
Xg_row\[0\].g_col\[1\].pe__1765_ g_row\[0\].g_col\[1\].pe__1766_/A g_row\[0\].g_col\[1\].pe__1766_/B
+ VGND VGND VPWR VPWR g_row\[0\].g_col\[1\].pe__1793_/B sky130_fd_sc_hd__nand2_2
XFILLER_26_589 VGND VGND VPWR VPWR sky130_fd_sc_hd__fill_1
Xg_row\[0\].g_col\[0\].pe__1749_ g_row\[0\].g_col\[0\].pe__1761_/A1 place1212/X place1214/A
+ g_row\[0\].g_col\[0\].pe__1761_/B2 VGND VGND VPWR VPWR g_row\[0\].g_col\[0\].pe__1750_/B
+ sky130_fd_sc_hd__a22o_2
XTAP_TAPCELL_ROW_0_198 VGND VPWR sky130_fd_sc_hd__tapvpwrvgnd_1
Xg_row\[0\].g_col\[1\].pe__1696_ g_row\[0\].g_col\[1\].pe__1678_/Y g_row\[0\].g_col\[1\].pe__1703_/B
+ g_row\[0\].g_col\[1\].pe__1695_/X VGND VGND VPWR VPWR g_row\[0\].g_col\[1\].pe__1698_/A
+ sky130_fd_sc_hd__a21oi_2
Xg_row\[1\].g_col\[1\].pe__2239_ g_row\[1\].g_col\[1\].pe__2239_/A g_row\[1\].g_col\[1\].pe__2239_/B
+ VGND VGND VPWR VPWR g_row\[1\].g_col\[1\].pe__2246_/A sky130_fd_sc_hd__nand2_2
Xg_row\[0\].g_col\[1\].pe__2317_ g_row\[0\].g_col\[1\].pe__2347_/A g_row\[0\].g_col\[1\].pe__2317_/B
+ VGND VGND VPWR VPWR g_row\[0\].g_col\[1\].pe__2318_/B sky130_fd_sc_hd__nor2_2
Xg_row\[0\].g_col\[1\].pe__2248_ g_row\[0\].g_col\[1\].pe__2348_/A g_row\[0\].g_col\[1\].pe__2248_/B
+ VGND VGND VPWR VPWR g_row\[0\].g_col\[1\].pe__2250_/B sky130_fd_sc_hd__xnor2_2
XFILLER_5_449 VGND VGND VPWR VPWR sky130_fd_sc_hd__fill_2
XFILLER_1_600 VGND VGND VPWR VPWR sky130_fd_sc_hd__decap_3
XFILLER_79_46 VGND VGND VPWR VPWR sky130_fd_sc_hd__decap_3
XTAP_TAPCELL_ROW_56_1047 VGND VPWR sky130_fd_sc_hd__tapvpwrvgnd_1
Xg_row\[0\].g_col\[1\].pe__2179_ g_row\[0\].g_col\[1\].pe__2179_/A g_row\[0\].g_col\[1\].pe__2179_/B
+ VGND VGND VPWR VPWR g_row\[0\].g_col\[1\].pe__2213_/B sky130_fd_sc_hd__xnor2_2
XFILLER_0_121 VGND VGND VPWR VPWR sky130_fd_sc_hd__fill_2
Xg_row\[1\].g_col\[1\].pe_hold1655 g_row\[1\].g_col\[1\].pe__2011_/Y VGND VGND VPWR
+ VPWR g_row\[1\].g_col\[1\].pe__2742_/D sky130_fd_sc_hd__clkbuf_2
Xg_row\[1\].g_col\[1\].pe_hold1644 g_row\[1\].g_col\[1\].pe__2455_/A VGND VGND VPWR
+ VPWR g_row\[1\].g_col\[1\].pe__1947_/B1 sky130_fd_sc_hd__clkbuf_2
XFILLER_49_615 VGND VGND VPWR VPWR sky130_fd_sc_hd__fill_1
XFILLER_89_773 VGND VGND VPWR VPWR sky130_fd_sc_hd__decap_3
Xhold3060 hold3060/A VGND VGND VPWR VPWR hold3060/X sky130_fd_sc_hd__clkbuf_2
Xg_row\[1\].g_col\[1\].pe_hold1677 g_row\[1\].g_col\[1\].pe__2775_/A VGND VGND VPWR
+ VPWR g_row\[1\].g_col\[1\].pe__2513_/A1 sky130_fd_sc_hd__clkbuf_2
Xg_row\[1\].g_col\[1\].pe_hold1666 g_row\[1\].g_col\[1\].pe__2760_/Q VGND VGND VPWR
+ VPWR g_row\[1\].g_col\[1\].pe__2541_/A1 sky130_fd_sc_hd__clkbuf_2
XFILLER_36_309 VGND VGND VPWR VPWR sky130_fd_sc_hd__decap_3
XFILLER_57_681 VGND VGND VPWR VPWR sky130_fd_sc_hd__decap_3
XFILLER_17_534 VGND VGND VPWR VPWR sky130_fd_sc_hd__fill_2
Xg_row\[0\].g_col\[0\].pe__2689__1421 VGND VGND VPWR VPWR g_row\[0\].g_col\[0\].pe__2689__1421/HI
+ g_row\[0\].g_col\[0\].pe__2689_/CIN sky130_fd_sc_hd__conb_1
XFILLER_9_711 VGND VGND VPWR VPWR sky130_fd_sc_hd__decap_3
XFILLER_9_744 VGND VGND VPWR VPWR sky130_fd_sc_hd__decap_3
XFILLER_9_777 VGND VGND VPWR VPWR sky130_fd_sc_hd__decap_3
Xg_row\[1\].g_col\[0\].pe__2712_ clkbuf_leaf_36_clk/X g_row\[1\].g_col\[0\].pe__2712_/D
+ VGND VGND VPWR VPWR g_row\[1\].g_col\[0\].pe__2712_/Q sky130_fd_sc_hd__dfxtp_2
XFILLER_4_482 VGND VGND VPWR VPWR sky130_fd_sc_hd__fill_1
Xg_row\[1\].g_col\[1\].pe__1610_ g_row\[1\].g_col\[1\].pe__2177_/B2 g_row\[1\].g_col\[1\].pe__1715_/B
+ g_row\[1\].g_col\[1\].pe__1863_/B1 g_row\[1\].g_col\[1\].pe__2696_/Q VGND VGND VPWR
+ VPWR g_row\[1\].g_col\[1\].pe__1611_/B sky130_fd_sc_hd__a22o_2
Xg_row\[1\].g_col\[0\].pe__2643_ g_row\[1\].g_col\[0\].pe__2669_/A g_row\[1\].g_col\[0\].pe__2643_/B
+ VGND VGND VPWR VPWR g_row\[1\].g_col\[0\].pe__2643_/X sky130_fd_sc_hd__or2_2
Xg_row\[1\].g_col\[1\].pe__2590_ g_row\[1\].g_col\[1\].pe__2590_/A g_row\[1\].g_col\[1\].pe__2508_/Y
+ VGND VGND VPWR VPWR g_row\[1\].g_col\[1\].pe__2590_/X sky130_fd_sc_hd__or2b_2
Xg_row\[1\].g_col\[1\].pe__1541_ g_row\[1\].g_col\[1\].pe__2736_/Q g_row\[1\].g_col\[1\].pe__2341_/B
+ g_row\[1\].g_col\[1\].pe__1540_/X VGND VGND VPWR VPWR g_row\[1\].g_col\[1\].pe__1541_/X
+ sky130_fd_sc_hd__a21o_2
Xg_row\[1\].g_col\[0\].pe__1525_ place1092/A g_row\[1\].g_col\[0\].pe__2026_/B g_row\[1\].g_col\[0\].pe__1738_/B1
+ place1094/X VGND VGND VPWR VPWR g_row\[1\].g_col\[0\].pe__1526_/B sky130_fd_sc_hd__a22o_2
XFILLER_39_158 VGND VGND VPWR VPWR sky130_fd_sc_hd__fill_2
XTAP_TAPCELL_ROW_87_1508 VGND VPWR sky130_fd_sc_hd__tapvpwrvgnd_1
Xg_row\[0\].g_col\[0\].pe__2721_ clkbuf_leaf_37_clk/X g_row\[0\].g_col\[0\].pe__2721_/D
+ VGND VGND VPWR VPWR hold3106/A sky130_fd_sc_hd__dfxtp_2
Xg_row\[1\].g_col\[0\].pe_hold2078 g_row\[1\].g_col\[0\].pe_hold3010/X VGND VGND VPWR
+ VPWR g_row\[1\].g_col\[0\].pe__2716_/D sky130_fd_sc_hd__clkbuf_2
Xg_row\[1\].g_col\[0\].pe_hold2067 g_row\[1\].g_col\[0\].pe__2659_/X VGND VGND VPWR
+ VPWR g_row\[1\].g_col\[0\].pe__2660_/C1 sky130_fd_sc_hd__clkbuf_2
Xg_row\[1\].g_col\[0\].pe_hold2056 g_row\[1\].g_col\[0\].pe_hold2892/X VGND VGND VPWR
+ VPWR g_row\[1\].g_col\[0\].pe_hold2893/A sky130_fd_sc_hd__clkbuf_2
XFILLER_36_810 VGND VGND VPWR VPWR sky130_fd_sc_hd__fill_2
XFILLER_82_415 VGND VGND VPWR VPWR sky130_fd_sc_hd__fill_1
XTAP_TAPCELL_ROW_87_1519 VGND VPWR sky130_fd_sc_hd__tapvpwrvgnd_1
Xg_row\[0\].g_col\[0\].pe__2652_ g_row\[0\].g_col\[0\].pe__2656_/A1 g_row\[0\].g_col\[0\].pe__2652_/A2
+ g_row\[0\].g_col\[0\].pe__2687_/C1 g_row\[0\].g_col\[0\].pe__2651_/X VGND VGND VPWR
+ VPWR g_row\[0\].g_col\[0\].pe__2652_/X sky130_fd_sc_hd__o211a_2
XFILLER_54_139 VGND VGND VPWR VPWR sky130_fd_sc_hd__fill_1
Xg_row\[0\].g_col\[0\].pe__1603_ g_row\[0\].g_col\[0\].pe__1604_/A g_row\[0\].g_col\[0\].pe__1604_/B
+ VGND VGND VPWR VPWR g_row\[0\].g_col\[0\].pe__1860_/A sky130_fd_sc_hd__nand2_2
Xg_row\[1\].g_col\[0\].pe__1387_ hold1763/X g_row\[1\].g_col\[0\].pe__1387_/B VGND
+ VGND VPWR VPWR g_row\[1\].g_col\[0\].pe__1387_/X sky130_fd_sc_hd__or2_2
XFILLER_63_673 VGND VGND VPWR VPWR sky130_fd_sc_hd__fill_2
Xg_row\[0\].g_col\[1\].pe__1550_ g_row\[0\].g_col\[1\].pe__1550_/A g_row\[0\].g_col\[1\].pe__1550_/B
+ VGND VGND VPWR VPWR g_row\[0\].g_col\[1\].pe__1669_/B sky130_fd_sc_hd__xnor2_2
XFILLER_50_301 VGND VGND VPWR VPWR sky130_fd_sc_hd__fill_2
XTAP_TAPCELL_ROW_46_893 VGND VPWR sky130_fd_sc_hd__tapvpwrvgnd_1
Xg_row\[0\].g_col\[0\].pe__1534_ g_row\[0\].g_col\[0\].pe__1588_/A g_row\[0\].g_col\[0\].pe__1588_/B
+ VGND VGND VPWR VPWR g_row\[0\].g_col\[0\].pe__1547_/A sky130_fd_sc_hd__xor2_2
Xg_row\[0\].g_col\[0\].pe__1465_ g_row\[0\].g_col\[0\].pe__1507_/A g_row\[0\].g_col\[0\].pe__1507_/B
+ VGND VGND VPWR VPWR g_row\[0\].g_col\[0\].pe__1478_/A sky130_fd_sc_hd__xor2_2
Xg_row\[0\].g_col\[1\].pe__1481_ g_row\[0\].g_col\[1\].pe__1481_/A g_row\[0\].g_col\[1\].pe__1481_/B
+ VGND VGND VPWR VPWR g_row\[0\].g_col\[1\].pe__1481_/X sky130_fd_sc_hd__and2_2
Xg_row\[1\].g_col\[1\].pe__2024_ g_row\[1\].g_col\[1\].pe__2024_/A g_row\[1\].g_col\[1\].pe__2024_/B
+ VGND VGND VPWR VPWR g_row\[1\].g_col\[1\].pe__2052_/A sky130_fd_sc_hd__xor2_2
Xg_row\[1\].g_col\[0\].pe__2008_ g_row\[1\].g_col\[0\].pe__2008_/A g_row\[1\].g_col\[0\].pe__2151_/B
+ VGND VGND VPWR VPWR g_row\[1\].g_col\[0\].pe__2062_/A sky130_fd_sc_hd__nor2_2
Xg_row\[0\].g_col\[0\].pe__1396_ g_row\[0\].g_col\[0\].pe__1396_/A g_row\[0\].g_col\[0\].pe__1402_/B
+ VGND VGND VPWR VPWR g_row\[0\].g_col\[0\].pe__1396_/X sky130_fd_sc_hd__or2_2
Xg_row\[0\].g_col\[1\].pe__2102_ g_row\[0\].g_col\[1\].pe__2145_/A g_row\[0\].g_col\[1\].pe__2101_/C
+ g_row\[0\].g_col\[1\].pe__2101_/A VGND VGND VPWR VPWR g_row\[0\].g_col\[1\].pe__2104_/B
+ sky130_fd_sc_hd__o21ai_2
Xg_row\[0\].g_col\[0\].pe__2017_ g_row\[0\].g_col\[0\].pe__2017_/A VGND VGND VPWR
+ VPWR g_row\[0\].g_col\[0\].pe__2058_/A sky130_fd_sc_hd__inv_2
Xg_row\[0\].g_col\[1\].pe__2033_ g_row\[0\].g_col\[1\].pe__2032_/B g_row\[0\].g_col\[1\].pe__2032_/C
+ g_row\[0\].g_col\[1\].pe__2123_/A VGND VGND VPWR VPWR g_row\[0\].g_col\[1\].pe__2034_/D
+ sky130_fd_sc_hd__a21o_2
Xg_row\[1\].g_col\[1\].pe__1808_ g_row\[1\].g_col\[1\].pe__1808_/A g_row\[1\].g_col\[1\].pe__1808_/B
+ g_row\[1\].g_col\[1\].pe__1808_/C g_row\[1\].g_col\[1\].pe__1811_/C VGND VGND VPWR
+ VPWR g_row\[1\].g_col\[1\].pe__1808_/X sky130_fd_sc_hd__or4b_4
XFILLER_86_710 VGND VGND VPWR VPWR sky130_fd_sc_hd__fill_2
Xg_row\[1\].g_col\[1\].pe__1739_ g_row\[1\].g_col\[1\].pe__1739_/A g_row\[1\].g_col\[1\].pe__1739_/B
+ VGND VGND VPWR VPWR g_row\[1\].g_col\[1\].pe__1776_/B sky130_fd_sc_hd__xor2_2
XTAP_TAPCELL_ROW_5_279 VGND VPWR sky130_fd_sc_hd__tapvpwrvgnd_1
XFILLER_73_415 VGND VGND VPWR VPWR sky130_fd_sc_hd__fill_2
XANTENNA_105 hold3248/A VGND VGND VPWR VPWR sky130_fd_sc_hd__diode_2
XANTENNA_116 hold3478/A VGND VGND VPWR VPWR sky130_fd_sc_hd__diode_2
Xg_row\[0\].g_col\[1\].pe__1817_ g_row\[0\].g_col\[1\].pe__1777_/A g_row\[0\].g_col\[1\].pe__1777_/B
+ g_row\[0\].g_col\[1\].pe__1816_/X VGND VGND VPWR VPWR g_row\[0\].g_col\[1\].pe__1818_/B
+ sky130_fd_sc_hd__a21oi_2
XANTENNA_127 hold3316/A VGND VGND VPWR VPWR sky130_fd_sc_hd__diode_2
XANTENNA_138 _143_/Y VGND VGND VPWR VPWR sky130_fd_sc_hd__diode_2
XANTENNA_149 hold3241/A VGND VGND VPWR VPWR sky130_fd_sc_hd__diode_2
XFILLER_26_342 VGND VGND VPWR VPWR sky130_fd_sc_hd__fill_1
XFILLER_42_813 VGND VGND VPWR VPWR sky130_fd_sc_hd__fill_2
XFILLER_54_651 VGND VGND VPWR VPWR sky130_fd_sc_hd__fill_1
Xg_row\[0\].g_col\[1\].pe_hold2988 g_row\[0\].g_col\[1\].pe__2672_/B VGND VGND VPWR
+ VPWR g_row\[0\].g_col\[1\].pe__2666_/A2 sky130_fd_sc_hd__clkbuf_2
XFILLER_26_375 VGND VGND VPWR VPWR sky130_fd_sc_hd__fill_1
XFILLER_54_695 VGND VGND VPWR VPWR sky130_fd_sc_hd__fill_1
Xg_row\[0\].g_col\[1\].pe__1748_ g_row\[0\].g_col\[1\].pe__1801_/A g_row\[0\].g_col\[1\].pe__1748_/B
+ VGND VGND VPWR VPWR g_row\[0\].g_col\[1\].pe__1816_/B sky130_fd_sc_hd__nand2_2
Xg_row\[0\].g_col\[1\].pe_hold2999 g_row\[0\].g_col\[1\].pe__1394_/A VGND VGND VPWR
+ VPWR g_row\[0\].g_col\[1\].pe__2662_/A2 sky130_fd_sc_hd__clkbuf_2
XFILLER_81_47 VGND VGND VPWR VPWR sky130_fd_sc_hd__fill_1
Xg_row\[0\].g_col\[1\].pe__1679_ g_row\[0\].g_col\[1\].pe__1704_/A1 g_row\[0\].g_col\[1\].pe__2036_/B2
+ g_row\[0\].g_col\[1\].pe__1704_/A2 g_row\[0\].g_col\[1\].pe__1704_/B2 VGND VGND
+ VPWR VPWR g_row\[0\].g_col\[1\].pe__1680_/B sky130_fd_sc_hd__a22o_2
XFILLER_41_389 VGND VGND VPWR VPWR sky130_fd_sc_hd__decap_3
XTAP_TAPCELL_ROW_24_565 VGND VPWR sky130_fd_sc_hd__tapvpwrvgnd_1
XTAP_TAPCELL_ROW_24_576 VGND VPWR sky130_fd_sc_hd__tapvpwrvgnd_1
X_281_ _289_/CLK _281_/D VGND VGND VPWR VPWR _281_/Q sky130_fd_sc_hd__dfxtp_2
XFILLER_10_721 VGND VGND VPWR VPWR sky130_fd_sc_hd__decap_3
XFILLER_14_96 VGND VGND VPWR VPWR sky130_fd_sc_hd__decap_3
XFILLER_22_581 VGND VGND VPWR VPWR sky130_fd_sc_hd__decap_3
XFILLER_5_202 VGND VGND VPWR VPWR sky130_fd_sc_hd__fill_1
XFILLER_6_714 VGND VGND VPWR VPWR sky130_fd_sc_hd__fill_1
Xg_row\[1\].g_col\[1\].pe_hold2120 g_row\[1\].g_col\[1\].pe__2685_/X VGND VGND VPWR
+ VPWR g_row\[1\].g_col\[1\].pe__2725_/D sky130_fd_sc_hd__clkbuf_2
Xg_row\[1\].g_col\[1\].pe_hold2142 g_row\[1\].g_col\[1\].pe__1383_/X VGND VGND VPWR
+ VPWR g_row\[1\].g_col\[1\].pe__1384_/B1 sky130_fd_sc_hd__clkbuf_2
XFILLER_49_434 VGND VGND VPWR VPWR sky130_fd_sc_hd__decap_3
XFILLER_77_754 VGND VGND VPWR VPWR sky130_fd_sc_hd__decap_3
XFILLER_18_810 VGND VGND VPWR VPWR sky130_fd_sc_hd__fill_2
XFILLER_76_253 VGND VGND VPWR VPWR sky130_fd_sc_hd__fill_2
Xg_row\[1\].g_col\[0\].pe__2290_ g_row\[1\].g_col\[0\].pe__2291_/A g_row\[1\].g_col\[0\].pe__2291_/B
+ VGND VGND VPWR VPWR g_row\[1\].g_col\[0\].pe__2292_/A sky130_fd_sc_hd__nor2_2
XFILLER_92_757 VGND VGND VPWR VPWR sky130_fd_sc_hd__fill_2
XTAP_TAPCELL_ROW_69_1238 VGND VPWR sky130_fd_sc_hd__tapvpwrvgnd_1
XTAP_TAPCELL_ROW_69_1249 VGND VPWR sky130_fd_sc_hd__tapvpwrvgnd_1
XFILLER_29_191 VGND VGND VPWR VPWR sky130_fd_sc_hd__fill_2
XFILLER_45_673 VGND VGND VPWR VPWR sky130_fd_sc_hd__decap_3
XFILLER_32_301 VGND VGND VPWR VPWR sky130_fd_sc_hd__fill_2
XFILLER_44_161 VGND VGND VPWR VPWR sky130_fd_sc_hd__fill_2
XFILLER_60_621 VGND VGND VPWR VPWR sky130_fd_sc_hd__decap_3
XTAP_TAPCELL_ROW_82_1438 VGND VPWR sky130_fd_sc_hd__tapvpwrvgnd_1
XTAP_TAPCELL_ROW_43_852 VGND VPWR sky130_fd_sc_hd__tapvpwrvgnd_1
Xg_row\[0\].g_col\[0\].pe_hold1910 g_row\[0\].g_col\[0\].pe__2741_/Q VGND VGND VPWR
+ VPWR g_row\[0\].g_col\[0\].pe__1946_/A sky130_fd_sc_hd__clkbuf_2
Xg_row\[0\].g_col\[0\].pe_hold1932 g_row\[0\].g_col\[0\].pe__2402_/Y VGND VGND VPWR
+ VPWR g_row\[0\].g_col\[0\].pe__2754_/D sky130_fd_sc_hd__clkbuf_2
Xg_row\[0\].g_col\[0\].pe_hold1998 g_row\[0\].g_col\[0\].pe__2528_/X VGND VGND VPWR
+ VPWR g_row\[0\].g_col\[0\].pe__2529_/B sky130_fd_sc_hd__clkbuf_2
XFILLER_65_3 VGND VGND VPWR VPWR sky130_fd_sc_hd__decap_3
Xg_row\[1\].g_col\[1\].pe__2711_ clkbuf_leaf_96_clk/X g_row\[1\].g_col\[1\].pe__2711_/D
+ VGND VGND VPWR VPWR g_row\[1\].g_col\[1\].pe__2711_/Q sky130_fd_sc_hd__dfxtp_2
Xg_row\[1\].g_col\[1\].pe__2642_ g_row\[1\].g_col\[1\].pe__2656_/A1 hold2186/X g_row\[1\].g_col\[1\].pe__2683_/C1
+ g_row\[1\].g_col\[1\].pe__2642_/C1 VGND VGND VPWR VPWR g_row\[1\].g_col\[1\].pe__2642_/X
+ sky130_fd_sc_hd__o211a_2
Xg_row\[1\].g_col\[0\].pe__2626_ g_row\[1\].g_col\[0\].pe__2626_/A1 g_row\[1\].g_col\[0\].pe__2626_/A2
+ g_row\[1\].g_col\[0\].pe__2626_/B1 g_row\[1\].g_col\[0\].pe__2625_/X VGND VGND VPWR
+ VPWR g_row\[1\].g_col\[0\].pe__2626_/X sky130_fd_sc_hd__o211a_2
XFILLER_68_710 VGND VGND VPWR VPWR sky130_fd_sc_hd__decap_3
Xg_row\[1\].g_col\[1\].pe__2573_ g_row\[1\].g_col\[1\].pe__2592_/A g_row\[1\].g_col\[1\].pe__2573_/B
+ VGND VGND VPWR VPWR g_row\[1\].g_col\[1\].pe__2766_/D sky130_fd_sc_hd__and2_2
Xg_row\[1\].g_col\[1\].pe__1524_ g_row\[1\].g_col\[1\].pe__1584_/A g_row\[1\].g_col\[1\].pe__1584_/B
+ VGND VGND VPWR VPWR g_row\[1\].g_col\[1\].pe__1533_/A sky130_fd_sc_hd__xor2_2
Xg_row\[1\].g_col\[0\].pe__2557_ g_row\[1\].g_col\[0\].pe__2551_/A g_row\[1\].g_col\[0\].pe__2551_/B
+ g_row\[1\].g_col\[0\].pe__2551_/C g_row\[1\].g_col\[0\].pe__2444_/A VGND VGND VPWR
+ VPWR g_row\[1\].g_col\[0\].pe__2558_/A sky130_fd_sc_hd__a31o_2
XTAP_TAPCELL_ROW_2_238 VGND VPWR sky130_fd_sc_hd__tapvpwrvgnd_1
Xg_row\[0\].g_col\[0\].pe__2704_ _287_/CLK g_row\[0\].g_col\[0\].pe__2704_/D VGND
+ VGND VPWR VPWR g_row\[0\].g_col\[1\].pe__2635_/C sky130_fd_sc_hd__dfxtp_2
Xg_row\[1\].g_col\[0\].pe__2488_ g_row\[1\].g_col\[0\].pe__2579_/C g_row\[1\].g_col\[0\].pe__2488_/B
+ VGND VGND VPWR VPWR g_row\[1\].g_col\[0\].pe__2575_/A sky130_fd_sc_hd__and2_2
Xg_row\[1\].g_col\[0\].pe__1508_ g_row\[1\].g_col\[0\].pe__1478_/A g_row\[1\].g_col\[0\].pe__1478_/B
+ g_row\[1\].g_col\[0\].pe__1507_/X VGND VGND VPWR VPWR g_row\[1\].g_col\[0\].pe__1549_/C
+ sky130_fd_sc_hd__a21o_2
Xg_row\[0\].g_col\[1\].pe__2720_ clkbuf_leaf_95_clk/X g_row\[0\].g_col\[1\].pe__2720_/D
+ VGND VGND VPWR VPWR hold2088/A sky130_fd_sc_hd__dfxtp_2
Xg_row\[0\].g_col\[1\].pe_hold2218 g_row\[0\].g_col\[1\].pe__2613_/X VGND VGND VPWR
+ VPWR g_row\[0\].g_col\[1\].pe__2695_/D sky130_fd_sc_hd__clkbuf_2
XFILLER_24_802 VGND VGND VPWR VPWR sky130_fd_sc_hd__fill_1
XFILLER_36_640 VGND VGND VPWR VPWR sky130_fd_sc_hd__decap_3
Xg_row\[0\].g_col\[0\].pe__2635_ _290_/Q _289_/Q g_row\[0\].g_col\[0\].pe__2635_/C
+ g_row\[0\].g_col\[0\].pe__2635_/D VGND VGND VPWR VPWR g_row\[0\].g_col\[0\].pe__2635_/X
+ sky130_fd_sc_hd__or4_2
Xg_row\[1\].g_col\[1\].pe__1386_ g_row\[1\].g_col\[1\].pe__1386_/A1 g_row\[1\].g_col\[1\].pe__2686_/B
+ g_row\[1\].g_col\[1\].pe__1385_/X g_row\[1\].g_col\[1\].pe__2666_/B1 VGND VGND VPWR
+ VPWR g_row\[1\].g_col\[1\].pe__1386_/X sky130_fd_sc_hd__o211a_2
Xg_row\[0\].g_col\[1\].pe__2651_ g_row\[0\].g_col\[1\].pe__2661_/A hold2141/X VGND
+ VGND VPWR VPWR g_row\[0\].g_col\[1\].pe__2651_/X sky130_fd_sc_hd__or2_2
XFILLER_51_610 VGND VGND VPWR VPWR sky130_fd_sc_hd__decap_3
XFILLER_82_289 VGND VGND VPWR VPWR sky130_fd_sc_hd__fill_2
Xg_row\[0\].g_col\[1\].pe__1602_ g_row\[0\].g_col\[1\].pe__2179_/A g_row\[0\].g_col\[1\].pe__1602_/B
+ VGND VGND VPWR VPWR g_row\[0\].g_col\[1\].pe__1604_/B sky130_fd_sc_hd__xnor2_2
Xg_row\[0\].g_col\[1\].pe__2582_ g_row\[0\].g_col\[1\].pe__2595_/A g_row\[0\].g_col\[1\].pe__2582_/B
+ VGND VGND VPWR VPWR g_row\[0\].g_col\[1\].pe__2768_/D sky130_fd_sc_hd__and2_2
Xg_row\[0\].g_col\[0\].pe__1517_ g_row\[0\].g_col\[0\].pe__1705_/A g_row\[0\].g_col\[0\].pe__1517_/B
+ VGND VGND VPWR VPWR g_row\[0\].g_col\[0\].pe__1580_/A sky130_fd_sc_hd__xnor2_2
Xg_row\[0\].g_col\[1\].pe__1533_ g_row\[0\].g_col\[1\].pe__1533_/A g_row\[0\].g_col\[1\].pe__1533_/B
+ VGND VGND VPWR VPWR g_row\[0\].g_col\[1\].pe__1588_/B sky130_fd_sc_hd__xnor2_2
XFILLER_11_529 VGND VGND VPWR VPWR sky130_fd_sc_hd__fill_1
Xg_row\[0\].g_col\[0\].pe__2497_ g_row\[0\].g_col\[0\].pe__2497_/A g_row\[0\].g_col\[0\].pe__2497_/B
+ VGND VGND VPWR VPWR g_row\[0\].g_col\[0\].pe__2546_/B sky130_fd_sc_hd__nor2_2
Xg_row\[0\].g_col\[1\].pe__1464_ g_row\[0\].g_col\[1\].pe__1673_/A g_row\[0\].g_col\[1\].pe__1464_/B
+ VGND VGND VPWR VPWR g_row\[0\].g_col\[1\].pe__1507_/B sky130_fd_sc_hd__xnor2_2
Xg_row\[1\].g_col\[1\].pe__2007_ g_row\[1\].g_col\[1\].pe__2009_/C g_row\[1\].g_col\[1\].pe__2008_/A
+ g_row\[1\].g_col\[1\].pe__2151_/B VGND VGND VPWR VPWR g_row\[1\].g_col\[1\].pe__2010_/B
+ sky130_fd_sc_hd__and3b_2
XTAP_TAPCELL_ROW_21_524 VGND VPWR sky130_fd_sc_hd__tapvpwrvgnd_1
Xg_row\[0\].g_col\[0\].pe__1448_ g_row\[0\].g_col\[0\].pe__2729_/Q g_row\[0\].g_col\[0\].pe__2728_/Q
+ g_row\[0\].g_col\[0\].pe__1460_/B VGND VGND VPWR VPWR g_row\[0\].g_col\[0\].pe__1449_/B
+ sky130_fd_sc_hd__or3b_4
Xg_row\[0\].g_col\[1\].pe__1395_ g_row\[0\].g_col\[1\].pe__1395_/A1 g_row\[0\].g_col\[1\].pe__1372_/X
+ g_row\[0\].g_col\[1\].pe__1394_/X g_row\[0\].g_col\[1\].pe__2656_/B1 VGND VGND VPWR
+ VPWR g_row\[0\].g_col\[1\].pe__1395_/X sky130_fd_sc_hd__o211a_2
Xg_row\[0\].g_col\[1\].pe__2016_ g_row\[0\].g_col\[1\].pe__1905_/A g_row\[0\].g_col\[1\].pe__1905_/B
+ g_row\[0\].g_col\[1\].pe__1964_/B g_row\[0\].g_col\[1\].pe__1963_/B g_row\[0\].g_col\[1\].pe__1963_/A
+ VGND VGND VPWR VPWR g_row\[0\].g_col\[1\].pe__2017_/A sky130_fd_sc_hd__a32o_2
XTAP_TAPCELL_ROW_53_1006 VGND VPWR sky130_fd_sc_hd__tapvpwrvgnd_1
XFILLER_76_25 VGND VGND VPWR VPWR sky130_fd_sc_hd__decap_3
XFILLER_18_128 VGND VGND VPWR VPWR sky130_fd_sc_hd__decap_3
XFILLER_73_212 VGND VGND VPWR VPWR sky130_fd_sc_hd__fill_1
XFILLER_74_757 VGND VGND VPWR VPWR sky130_fd_sc_hd__fill_1
XTAP_TAPCELL_ROW_29_646 VGND VPWR sky130_fd_sc_hd__tapvpwrvgnd_1
XFILLER_15_802 VGND VGND VPWR VPWR sky130_fd_sc_hd__decap_3
XFILLER_27_673 VGND VGND VPWR VPWR sky130_fd_sc_hd__decap_3
XFILLER_54_470 VGND VGND VPWR VPWR sky130_fd_sc_hd__decap_3
XFILLER_73_289 VGND VGND VPWR VPWR sky130_fd_sc_hd__fill_1
XFILLER_25_84 VGND VGND VPWR VPWR sky130_fd_sc_hd__decap_3
XTAP_TAPCELL_ROW_40_811 VGND VPWR sky130_fd_sc_hd__tapvpwrvgnd_1
XTAP_TAPCELL_ROW_64_1168 VGND VPWR sky130_fd_sc_hd__tapvpwrvgnd_1
X_333_ _333_/CLK _333_/D VGND VGND VPWR VPWR _333_/Q sky130_fd_sc_hd__dfxtp_2
XFILLER_10_551 VGND VGND VPWR VPWR sky130_fd_sc_hd__fill_1
XFILLER_10_573 VGND VGND VPWR VPWR sky130_fd_sc_hd__decap_3
XFILLER_41_72 VGND VGND VPWR VPWR sky130_fd_sc_hd__decap_3
X_195_ _195_/A _195_/B_N VGND VGND VPWR VPWR _195_/Y sky130_fd_sc_hd__nor2b_4
XFILLER_41_94 VGND VGND VPWR VPWR sky130_fd_sc_hd__fill_1
Xg_row\[1\].g_col\[0\].pe__1790_ g_row\[1\].g_col\[0\].pe__1795_/B g_row\[1\].g_col\[0\].pe__1790_/B
+ VGND VGND VPWR VPWR g_row\[1\].g_col\[0\].pe__1811_/A sky130_fd_sc_hd__nand2_2
Xg_row\[1\].g_col\[0\].pe__2411_ g_row\[1\].g_col\[0\].pe__2740_/Q g_row\[1\].g_col\[0\].pe__2739_/Q
+ g_row\[1\].g_col\[0\].pe__2754_/Q VGND VGND VPWR VPWR g_row\[1\].g_col\[0\].pe__2455_/B
+ sky130_fd_sc_hd__o21ba_2
XFILLER_2_44 VGND VGND VPWR VPWR sky130_fd_sc_hd__fill_1
Xg_row\[1\].g_col\[0\].pe__2342_ g_row\[1\].g_col\[0\].pe__2388_/A g_row\[1\].g_col\[0\].pe__1540_/X
+ g_row\[1\].g_col\[0\].pe__2341_/Y g_row\[1\].g_col\[0\].pe__2736_/Q VGND VGND VPWR
+ VPWR g_row\[1\].g_col\[0\].pe__2365_/A sky130_fd_sc_hd__a22o_2
XFILLER_77_595 VGND VGND VPWR VPWR sky130_fd_sc_hd__fill_2
XTAP_TAPCELL_ROW_48_933 VGND VPWR sky130_fd_sc_hd__tapvpwrvgnd_1
Xg_row\[1\].g_col\[0\].pe__2273_ g_row\[1\].g_col\[0\].pe__2273_/A g_row\[1\].g_col\[0\].pe__2273_/B
+ VGND VGND VPWR VPWR g_row\[1\].g_col\[0\].pe__2287_/A sky130_fd_sc_hd__or2_2
XFILLER_18_640 VGND VGND VPWR VPWR sky130_fd_sc_hd__decap_3
XFILLER_80_705 VGND VGND VPWR VPWR sky130_fd_sc_hd__fill_2
XFILLER_17_161 VGND VGND VPWR VPWR sky130_fd_sc_hd__decap_3
XFILLER_17_172 VGND VGND VPWR VPWR sky130_fd_sc_hd__decap_3
XFILLER_80_738 VGND VGND VPWR VPWR sky130_fd_sc_hd__fill_2
XFILLER_80_749 VGND VGND VPWR VPWR sky130_fd_sc_hd__fill_2
Xg_row\[0\].g_col\[0\].pe__2420_ g_row\[0\].g_col\[0\].pe__2754_/Q g_row\[0\].g_col\[0\].pe__2336_/Y
+ g_row\[0\].g_col\[0\].pe__2429_/B VGND VGND VPWR VPWR g_row\[0\].g_col\[0\].pe__2426_/B
+ sky130_fd_sc_hd__o21ai_2
XFILLER_60_473 VGND VGND VPWR VPWR sky130_fd_sc_hd__decap_3
Xg_row\[0\].g_col\[0\].pe__2351_ g_row\[0\].g_col\[0\].pe__2352_/A g_row\[0\].g_col\[0\].pe__2352_/B
+ g_row\[0\].g_col\[0\].pe__2352_/C VGND VGND VPWR VPWR g_row\[0\].g_col\[0\].pe__2375_/A
+ sky130_fd_sc_hd__a21oi_2
XANTENNA_16 b_inputs_flat[15] VGND VGND VPWR VPWR sky130_fd_sc_hd__diode_2
XANTENNA_27 b_inputs_flat[7] VGND VGND VPWR VPWR sky130_fd_sc_hd__diode_2
XANTENNA_38 _274_/Q VGND VGND VPWR VPWR sky130_fd_sc_hd__diode_2
XFILLER_32_197 VGND VGND VPWR VPWR sky130_fd_sc_hd__fill_2
Xg_row\[0\].g_col\[0\].pe__2282_ g_row\[0\].g_col\[0\].pe__2283_/A g_row\[0\].g_col\[0\].pe__2283_/B
+ VGND VGND VPWR VPWR g_row\[0\].g_col\[0\].pe__2284_/A sky130_fd_sc_hd__nor2_2
XANTENNA_49 hold3300/A VGND VGND VPWR VPWR sky130_fd_sc_hd__diode_2
XFILLER_9_393 VGND VGND VPWR VPWR sky130_fd_sc_hd__fill_2
Xg_row\[1\].g_col\[0\].pe__1988_ g_row\[1\].g_col\[0\].pe__2043_/A g_row\[1\].g_col\[0\].pe__1988_/B
+ g_row\[1\].g_col\[0\].pe__1988_/C VGND VGND VPWR VPWR g_row\[1\].g_col\[0\].pe__1988_/X
+ sky130_fd_sc_hd__and3b_4
XTAP_TAPCELL_ROW_7_308 VGND VPWR sky130_fd_sc_hd__tapvpwrvgnd_1
XTAP_TAPCELL_ROW_7_319 VGND VPWR sky130_fd_sc_hd__tapvpwrvgnd_1
Xg_row\[1\].g_col\[1\].pe__2625_ g_row\[1\].g_col\[1\].pe__2639_/A g_row\[1\].g_col\[1\].pe__2625_/B
+ VGND VGND VPWR VPWR g_row\[1\].g_col\[1\].pe__2625_/X sky130_fd_sc_hd__or2_2
Xg_row\[0\].g_col\[0\].pe__1997_ g_row\[0\].g_col\[0\].pe__1997_/A g_row\[0\].g_col\[0\].pe__1997_/B
+ VGND VGND VPWR VPWR g_row\[0\].g_col\[0\].pe__2014_/B sky130_fd_sc_hd__xor2_2
XFILLER_55_234 VGND VGND VPWR VPWR sky130_fd_sc_hd__decap_3
XFILLER_56_746 VGND VGND VPWR VPWR sky130_fd_sc_hd__fill_2
Xg_row\[1\].g_col\[1\].pe__2487_ g_row\[1\].g_col\[1\].pe__2487_/A g_row\[1\].g_col\[1\].pe__2487_/B
+ g_row\[1\].g_col\[1\].pe__2490_/A VGND VGND VPWR VPWR g_row\[1\].g_col\[1\].pe__2488_/B
+ sky130_fd_sc_hd__or3_2
Xg_row\[1\].g_col\[1\].pe__1507_ g_row\[1\].g_col\[1\].pe__1507_/A g_row\[1\].g_col\[1\].pe__1507_/B
+ VGND VGND VPWR VPWR g_row\[1\].g_col\[1\].pe__1507_/X sky130_fd_sc_hd__and2_2
Xg_row\[1\].g_col\[1\].pe__1438_ g_row\[1\].g_col\[1\].pe__1481_/A g_row\[1\].g_col\[1\].pe__1481_/B
+ VGND VGND VPWR VPWR g_row\[1\].g_col\[1\].pe__1442_/A sky130_fd_sc_hd__xor2_2
Xg_row\[0\].g_col\[1\].pe_hold2037 g_row\[0\].g_col\[1\].pe__2759_/Q VGND VGND VPWR
+ VPWR g_row\[0\].g_col\[1\].pe__2535_/A1 sky130_fd_sc_hd__clkbuf_2
Xg_row\[0\].g_col\[1\].pe__2703_ clkbuf_leaf_10_clk/X g_row\[0\].g_col\[1\].pe__2703_/D
+ VGND VGND VPWR VPWR g_row\[0\].g_col\[1\].pe__2703_/Q sky130_fd_sc_hd__dfxtp_2
XFILLER_55_278 VGND VGND VPWR VPWR sky130_fd_sc_hd__fill_2
XFILLER_70_215 VGND VGND VPWR VPWR sky130_fd_sc_hd__fill_1
XFILLER_71_727 VGND VGND VPWR VPWR sky130_fd_sc_hd__fill_1
XTAP_TAPCELL_ROW_26_605 VGND VPWR sky130_fd_sc_hd__tapvpwrvgnd_1
Xg_row\[0\].g_col\[0\].pe__2618_ g_row\[0\].g_col\[0\].pe__2639_/A place1205/A VGND
+ VGND VPWR VPWR g_row\[0\].g_col\[0\].pe__2618_/X sky130_fd_sc_hd__or2_2
Xg_row\[0\].g_col\[1\].pe__2634_ place1204/X place1205/X place1199/X place1201/X VGND
+ VGND VPWR VPWR g_row\[0\].g_col\[1\].pe__2635_/D sky130_fd_sc_hd__or4_2
Xg_row\[1\].g_col\[1\].pe__1369_ g_row\[1\].g_col\[1\].pe__2770_/Q VGND VGND VPWR
+ VPWR g_row\[1\].g_col\[1\].pe__2424_/A sky130_fd_sc_hd__inv_2
XFILLER_23_142 VGND VGND VPWR VPWR sky130_fd_sc_hd__decap_3
Xg_row\[0\].g_col\[0\].pe__2549_ g_row\[0\].g_col\[0\].pe__2555_/A g_row\[0\].g_col\[0\].pe__2549_/B
+ VGND VGND VPWR VPWR g_row\[0\].g_col\[0\].pe__2761_/D sky130_fd_sc_hd__and2_2
Xg_row\[0\].g_col\[1\].pe__2565_ g_row\[0\].g_col\[1\].pe__2592_/A g_row\[0\].g_col\[1\].pe__2565_/B
+ VGND VGND VPWR VPWR g_row\[0\].g_col\[1\].pe__2764_/D sky130_fd_sc_hd__and2_2
XFILLER_11_337 VGND VGND VPWR VPWR sky130_fd_sc_hd__fill_1
XFILLER_23_175 VGND VGND VPWR VPWR sky130_fd_sc_hd__fill_2
XFILLER_51_484 VGND VGND VPWR VPWR sky130_fd_sc_hd__fill_1
Xg_row\[0\].g_col\[1\].pe__1516_ g_row\[0\].g_col\[1\].pe__1704_/A1 g_row\[0\].g_col\[1\].pe__2703_/Q
+ g_row\[0\].g_col\[1\].pe__1965_/A g_row\[0\].g_col\[1\].pe__1704_/B2 VGND VGND VPWR
+ VPWR g_row\[0\].g_col\[1\].pe__1517_/B sky130_fd_sc_hd__a22o_2
Xg_row\[0\].g_col\[1\].pe__2496_ g_row\[0\].g_col\[1\].pe__2496_/A g_row\[0\].g_col\[1\].pe__2496_/B
+ VGND VGND VPWR VPWR g_row\[0\].g_col\[1\].pe__2558_/B sky130_fd_sc_hd__nor2_2
Xg_row\[0\].g_col\[1\].pe__1447_ g_row\[0\].g_col\[1\].pe__1459_/C g_row\[0\].g_col\[1\].pe__2729_/Q
+ g_row\[0\].g_col\[1\].pe__2125_/C VGND VGND VPWR VPWR g_row\[0\].g_col\[1\].pe__1449_/A
+ sky130_fd_sc_hd__nand3b_2
XFILLER_3_558 VGND VGND VPWR VPWR sky130_fd_sc_hd__fill_2
XFILLER_87_57 VGND VGND VPWR VPWR sky130_fd_sc_hd__fill_2
XFILLER_93_318 VGND VGND VPWR VPWR sky130_fd_sc_hd__fill_1
XFILLER_34_429 VGND VGND VPWR VPWR sky130_fd_sc_hd__fill_2
XFILLER_15_676 VGND VGND VPWR VPWR sky130_fd_sc_hd__fill_2
XFILLER_15_687 VGND VGND VPWR VPWR sky130_fd_sc_hd__decap_3
X_316_ _324_/CLK _316_/D VGND VGND VPWR VPWR _316_/Q sky130_fd_sc_hd__dfxtp_2
XFILLER_30_668 VGND VGND VPWR VPWR sky130_fd_sc_hd__decap_3
XTAP_TAPCELL_ROW_12_387 VGND VPWR sky130_fd_sc_hd__tapvpwrvgnd_1
X_247_ _269_/A _247_/B_N VGND VGND VPWR VPWR _247_/Y sky130_fd_sc_hd__nor2b_4
Xg_row\[1\].g_col\[0\].pe__1911_ hold3129/A g_row\[1\].g_col\[0\].pe__2163_/B g_row\[1\].g_col\[0\].pe__1461_/Y
+ place1090/X VGND VGND VPWR VPWR g_row\[1\].g_col\[0\].pe__1912_/B sky130_fd_sc_hd__a22o_2
XFILLER_6_330 VGND VGND VPWR VPWR sky130_fd_sc_hd__fill_1
Xg_row\[1\].g_col\[0\].pe__1842_ g_row\[1\].g_col\[0\].pe__1702_/X g_row\[1\].g_col\[0\].pe__1829_/Y
+ g_row\[1\].g_col\[0\].pe__1834_/A g_row\[1\].g_col\[0\].pe__1832_/Y VGND VGND VPWR
+ VPWR g_row\[1\].g_col\[0\].pe__1843_/B sky130_fd_sc_hd__a211o_2
XTAP_TAPCELL_ROW_77_1359 VGND VPWR sky130_fd_sc_hd__tapvpwrvgnd_1
Xg_row\[1\].g_col\[0\].pe__1773_ g_row\[1\].g_col\[0\].pe__1816_/A g_row\[1\].g_col\[0\].pe__1816_/B
+ VGND VGND VPWR VPWR g_row\[1\].g_col\[0\].pe__1778_/A sky130_fd_sc_hd__nand2_2
Xg_row\[0\].g_col\[0\].pe__1920_ g_row\[0\].g_col\[0\].pe__2125_/A g_row\[0\].g_col\[0\].pe__1416_/X
+ g_row\[0\].g_col\[0\].pe__2043_/A VGND VGND VPWR VPWR g_row\[0\].g_col\[0\].pe__1980_/A
+ sky130_fd_sc_hd__o21bai_2
XTAP_TAPCELL_ROW_90_1559 VGND VPWR sky130_fd_sc_hd__tapvpwrvgnd_1
XFILLER_28_3 VGND VGND VPWR VPWR sky130_fd_sc_hd__fill_2
Xg_row\[0\].g_col\[0\].pe__1851_ g_row\[0\].g_col\[0\].pe__1851_/A g_row\[0\].g_col\[0\].pe__1851_/B
+ VGND VGND VPWR VPWR g_row\[0\].g_col\[0\].pe__1851_/X sky130_fd_sc_hd__and2_2
Xhold1509 hold2556/X VGND VGND VPWR VPWR hold2557/A sky130_fd_sc_hd__clkbuf_2
Xg_row\[1\].g_col\[1\].pe__2410_ g_row\[1\].g_col\[1\].pe__2775_/A g_row\[1\].g_col\[1\].pe__2410_/B
+ VGND VGND VPWR VPWR g_row\[1\].g_col\[1\].pe__2499_/A sky130_fd_sc_hd__and2_2
XFILLER_93_841 VGND VGND VPWR VPWR sky130_fd_sc_hd__fill_1
Xg_row\[0\].g_col\[0\].pe__1782_ g_row\[0\].g_col\[0\].pe__1804_/A place1216/X place1218/X
+ g_row\[0\].g_col\[0\].pe__1804_/B VGND VGND VPWR VPWR g_row\[0\].g_col\[0\].pe__1783_/B
+ sky130_fd_sc_hd__a22o_2
Xg_row\[1\].g_col\[1\].pe__2341_ g_row\[1\].g_col\[1\].pe__2388_/A g_row\[1\].g_col\[1\].pe__2341_/B
+ VGND VGND VPWR VPWR g_row\[1\].g_col\[1\].pe__2341_/Y sky130_fd_sc_hd__nand2_2
Xg_row\[1\].g_col\[0\].pe__2325_ g_row\[1\].g_col\[0\].pe__2325_/A g_row\[1\].g_col\[0\].pe__2338_/A
+ VGND VGND VPWR VPWR g_row\[1\].g_col\[0\].pe__2327_/C sky130_fd_sc_hd__xnor2_2
XFILLER_65_554 VGND VGND VPWR VPWR sky130_fd_sc_hd__decap_3
Xg_row\[1\].g_col\[1\].pe__2272_ g_row\[1\].g_col\[1\].pe__2257_/A g_row\[1\].g_col\[1\].pe__2272_/B
+ VGND VGND VPWR VPWR g_row\[1\].g_col\[1\].pe__2295_/B sky130_fd_sc_hd__and2b_2
XFILLER_65_576 VGND VGND VPWR VPWR sky130_fd_sc_hd__decap_3
XFILLER_65_598 VGND VGND VPWR VPWR sky130_fd_sc_hd__decap_3
Xg_row\[1\].g_col\[0\].pe__2256_ g_row\[1\].g_col\[0\].pe__2213_/A g_row\[1\].g_col\[0\].pe__2213_/B
+ g_row\[1\].g_col\[0\].pe__2220_/B g_row\[1\].g_col\[0\].pe__2219_/B g_row\[1\].g_col\[0\].pe__2219_/A
+ VGND VGND VPWR VPWR g_row\[1\].g_col\[0\].pe__2272_/B sky130_fd_sc_hd__a32o_2
XFILLER_80_546 VGND VGND VPWR VPWR sky130_fd_sc_hd__decap_3
Xg_row\[1\].g_col\[0\].pe__2187_ g_row\[1\].g_col\[0\].pe__2142_/A g_row\[1\].g_col\[0\].pe__2187_/B
+ VGND VGND VPWR VPWR g_row\[1\].g_col\[0\].pe__2187_/X sky130_fd_sc_hd__and2b_2
Xg_row\[0\].g_col\[0\].pe__2403_ g_row\[0\].g_col\[0\].pe__2403_/A VGND VGND VPWR
+ VPWR g_row\[0\].g_col\[0\].pe__2403_/Y sky130_fd_sc_hd__inv_2
Xg_row\[1\].g_col\[0\].pe_place1069 g_row\[1\].g_col\[0\].pe__2125_/C VGND VGND VPWR
+ VPWR g_row\[1\].g_col\[0\].pe__1733_/A sky130_fd_sc_hd__buf_6
Xg_row\[1\].g_col\[0\].pe_place1058 g_row\[1\].g_col\[0\].pe__2776_/A VGND VGND VPWR
+ VPWR g_row\[1\].g_col\[0\].pe__2594_/B2 sky130_fd_sc_hd__buf_6
Xg_row\[0\].g_col\[0\].pe__2334_ g_row\[0\].g_col\[0\].pe__2395_/A1 g_row\[0\].g_col\[0\].pe__2334_/A2
+ g_row\[0\].g_col\[0\].pe__2331_/X g_row\[0\].g_col\[0\].pe__2333_/Y VGND VGND VPWR
+ VPWR g_row\[0\].g_col\[0\].pe__2335_/B sky130_fd_sc_hd__o22a_2
Xg_row\[0\].g_col\[0\].pe_hold2271 _309_/Q VGND VGND VPWR VPWR g_row\[0\].g_col\[0\].pe_hold2271/X
+ sky130_fd_sc_hd__clkbuf_2
Xg_row\[0\].g_col\[1\].pe__2350_ g_row\[0\].g_col\[1\].pe__2350_/A g_row\[0\].g_col\[1\].pe__2350_/B
+ VGND VGND VPWR VPWR g_row\[0\].g_col\[1\].pe__2352_/C sky130_fd_sc_hd__xnor2_2
XFILLER_20_134 VGND VGND VPWR VPWR sky130_fd_sc_hd__decap_3
Xg_row\[0\].g_col\[0\].pe_hold2282 g_row\[0\].g_col\[0\].pe_hold3055/X VGND VGND VPWR
+ VPWR g_row\[0\].g_col\[0\].pe__2636_/B sky130_fd_sc_hd__clkbuf_2
Xg_row\[0\].g_col\[0\].pe_hold2293 g_row\[0\].g_col\[0\].pe_hold3128/X VGND VGND VPWR
+ VPWR g_row\[0\].g_col\[0\].pe__2638_/B1 sky130_fd_sc_hd__clkbuf_2
Xg_row\[0\].g_col\[1\].pe_place852 g_row\[0\].g_col\[1\].pe__1727_/B2 VGND VGND VPWR
+ VPWR g_row\[0\].g_col\[1\].pe__1704_/B2 sky130_fd_sc_hd__buf_6
Xg_row\[0\].g_col\[1\].pe__2281_ g_row\[0\].g_col\[1\].pe__2311_/A g_row\[0\].g_col\[1\].pe__2311_/B
+ VGND VGND VPWR VPWR g_row\[0\].g_col\[1\].pe__2283_/B sky130_fd_sc_hd__xor2_2
XFILLER_20_167 VGND VGND VPWR VPWR sky130_fd_sc_hd__decap_3
XTAP_TAPCELL_ROW_31_674 VGND VPWR sky130_fd_sc_hd__tapvpwrvgnd_1
Xg_row\[0\].g_col\[0\].pe__2265_ g_row\[0\].g_col\[0\].pe__2238_/X g_row\[0\].g_col\[0\].pe__2234_/Y
+ g_row\[0\].g_col\[0\].pe__2263_/X VGND VGND VPWR VPWR g_row\[0\].g_col\[0\].pe__2265_/Y
+ sky130_fd_sc_hd__o21ai_2
Xg_row\[0\].g_col\[0\].pe__2196_ g_row\[0\].g_col\[0\].pe__2161_/Y g_row\[0\].g_col\[0\].pe__2157_/B
+ g_row\[0\].g_col\[0\].pe__2200_/B g_row\[0\].g_col\[0\].pe__2394_/B1 VGND VGND VPWR
+ VPWR g_row\[0\].g_col\[0\].pe__2196_/X sky130_fd_sc_hd__a31o_2
Xg_row\[1\].g_col\[1\].pe__1987_ g_row\[1\].g_col\[1\].pe__1988_/B g_row\[1\].g_col\[1\].pe__1988_/C
+ g_row\[1\].g_col\[1\].pe__2043_/A VGND VGND VPWR VPWR g_row\[1\].g_col\[1\].pe__1987_/Y
+ sky130_fd_sc_hd__a21boi_2
Xhold3401 hold3401/A VGND VGND VPWR VPWR hold3401/X sky130_fd_sc_hd__clkbuf_2
Xhold3434 hold3434/A VGND VGND VPWR VPWR hold3434/X sky130_fd_sc_hd__clkbuf_2
Xhold3423 hold3423/A VGND VGND VPWR VPWR hold3423/X sky130_fd_sc_hd__clkbuf_2
Xhold3412 hold3412/A VGND VGND VPWR VPWR hold3412/X sky130_fd_sc_hd__clkbuf_2
Xhold2700 _177_/Y VGND VGND VPWR VPWR hold2700/X sky130_fd_sc_hd__clkbuf_2
Xhold2711 hold3416/X VGND VGND VPWR VPWR _153_/B_N sky130_fd_sc_hd__clkbuf_2
Xhold2722 hold3519/X VGND VGND VPWR VPWR hold3520/A sky130_fd_sc_hd__clkbuf_2
Xoutput1395 output1395/A VGND VGND VPWR VPWR results_flat[46] sky130_fd_sc_hd__buf_2
Xoutput1384 output1384/A VGND VGND VPWR VPWR results_flat[36] sky130_fd_sc_hd__buf_2
Xoutput1373 output1373/A VGND VGND VPWR VPWR results_flat[26] sky130_fd_sc_hd__buf_2
Xoutput1362 output1362/A VGND VGND VPWR VPWR results_flat[16] sky130_fd_sc_hd__buf_2
Xhold3467 hold3467/A VGND VGND VPWR VPWR hold3467/X sky130_fd_sc_hd__clkbuf_2
Xhold3456 hold3456/A VGND VGND VPWR VPWR hold3456/X sky130_fd_sc_hd__clkbuf_2
Xhold3445 a_inputs_flat[23] VGND VGND VPWR VPWR hold3445/X sky130_fd_sc_hd__clkbuf_2
Xhold2733 hold3496/X VGND VGND VPWR VPWR hold3497/A sky130_fd_sc_hd__clkbuf_2
Xhold2744 hold3522/X VGND VGND VPWR VPWR hold3523/A sky130_fd_sc_hd__clkbuf_2
Xhold2755 hold2755/A VGND VGND VPWR VPWR _278_/D sky130_fd_sc_hd__clkbuf_2
Xhold3489 hold3489/A VGND VGND VPWR VPWR hold3489/X sky130_fd_sc_hd__clkbuf_2
Xhold3478 hold3478/A VGND VGND VPWR VPWR hold3478/X sky130_fd_sc_hd__clkbuf_2
Xg_row\[1\].g_col\[1\].pe__2608_ g_row\[1\].g_col\[1\].pe__2633_/A1 g_row\[1\].g_col\[1\].pe__2608_/A2
+ g_row\[1\].g_col\[1\].pe__2679_/C1 g_row\[1\].g_col\[1\].pe__2608_/C1 VGND VGND
+ VPWR VPWR g_row\[1\].g_col\[1\].pe__2608_/X sky130_fd_sc_hd__o211a_2
XFILLER_28_212 VGND VGND VPWR VPWR sky130_fd_sc_hd__decap_3
XFILLER_29_746 VGND VGND VPWR VPWR sky130_fd_sc_hd__fill_2
Xhold2766 _165_/Y VGND VGND VPWR VPWR hold2766/X sky130_fd_sc_hd__clkbuf_2
Xhold2777 hold2777/A VGND VGND VPWR VPWR _143_/B_N sky130_fd_sc_hd__clkbuf_2
Xhold2788 hold3569/X VGND VGND VPWR VPWR hold3570/A sky130_fd_sc_hd__clkbuf_2
Xhold2799 hold3591/X VGND VGND VPWR VPWR hold3592/A sky130_fd_sc_hd__clkbuf_2
Xg_row\[1\].g_col\[1\].pe__2539_ g_row\[1\].g_col\[1\].pe__2538_/B g_row\[1\].g_col\[1\].pe__2538_/C
+ g_row\[1\].g_col\[1\].pe__2538_/A VGND VGND VPWR VPWR g_row\[1\].g_col\[1\].pe__2539_/X
+ sky130_fd_sc_hd__a21o_2
Xg_row\[0\].g_col\[1\].pe__1996_ g_row\[0\].g_col\[1\].pe__2055_/A g_row\[0\].g_col\[1\].pe__2055_/B
+ VGND VGND VPWR VPWR g_row\[0\].g_col\[1\].pe__1997_/B sky130_fd_sc_hd__xor2_2
XTAP_TAPCELL_ROW_39_796 VGND VPWR sky130_fd_sc_hd__tapvpwrvgnd_1
Xg_row\[0\].g_col\[1\].pe__2617_ g_row\[0\].g_col\[1\].pe__2624_/A1 place1207/X g_row\[0\].g_col\[1\].pe__2626_/B1
+ g_row\[0\].g_col\[1\].pe__2616_/X VGND VGND VPWR VPWR g_row\[0\].g_col\[1\].pe__2697_/D
+ sky130_fd_sc_hd__o211a_2
XTAP_TAPCELL_ROW_61_1127 VGND VPWR sky130_fd_sc_hd__tapvpwrvgnd_1
Xg_row\[0\].g_col\[1\].pe__2548_ g_row\[0\].g_col\[1\].pe__2548_/A1 g_row\[0\].g_col\[1\].pe__2406_/Y
+ g_row\[0\].g_col\[1\].pe__2591_/B1 g_row\[0\].g_col\[1\].pe__2547_/X VGND VGND VPWR
+ VPWR g_row\[0\].g_col\[1\].pe__2548_/X sky130_fd_sc_hd__a22o_2
XTAP_TAPCELL_ROW_50_961 VGND VPWR sky130_fd_sc_hd__tapvpwrvgnd_1
Xg_row\[0\].g_col\[1\].pe__2479_ g_row\[0\].g_col\[1\].pe__2579_/B g_row\[0\].g_col\[1\].pe__2579_/C
+ g_row\[0\].g_col\[1\].pe__2579_/A VGND VGND VPWR VPWR g_row\[0\].g_col\[1\].pe__2479_/X
+ sky130_fd_sc_hd__a21o_2
XTAP_TAPCELL_ROW_59_1089 VGND VPWR sky130_fd_sc_hd__tapvpwrvgnd_1
XTAP_TAPCELL_ROW_72_1289 VGND VPWR sky130_fd_sc_hd__tapvpwrvgnd_1
XFILLER_47_521 VGND VGND VPWR VPWR sky130_fd_sc_hd__fill_2
XFILLER_47_532 VGND VGND VPWR VPWR sky130_fd_sc_hd__decap_3
XFILLER_75_841 VGND VGND VPWR VPWR sky130_fd_sc_hd__fill_1
XFILLER_93_126 VGND VGND VPWR VPWR sky130_fd_sc_hd__fill_1
XFILLER_35_705 VGND VGND VPWR VPWR sky130_fd_sc_hd__fill_1
XFILLER_47_554 VGND VGND VPWR VPWR sky130_fd_sc_hd__decap_3
Xg_row\[1\].g_col\[0\].pe__2110_ g_row\[1\].g_col\[0\].pe__2110_/A g_row\[1\].g_col\[0\].pe__2110_/B
+ VGND VGND VPWR VPWR g_row\[1\].g_col\[0\].pe__2153_/C sky130_fd_sc_hd__or2_2
XFILLER_62_546 VGND VGND VPWR VPWR sky130_fd_sc_hd__decap_3
Xg_row\[1\].g_col\[0\].pe__2041_ g_row\[1\].g_col\[0\].pe__1924_/A g_row\[1\].g_col\[0\].pe__2040_/X
+ g_row\[1\].g_col\[0\].pe__1424_/A g_row\[1\].g_col\[0\].pe__2125_/A VGND VGND VPWR
+ VPWR g_row\[1\].g_col\[0\].pe__2043_/B sky130_fd_sc_hd__o2bb2a_2
Xg_row\[0\].g_col\[1\].pe_hold2390 g_row\[0\].g_col\[1\].pe__2011_/Y VGND VGND VPWR
+ VPWR g_row\[0\].g_col\[1\].pe__2742_/D sky130_fd_sc_hd__clkbuf_2
XTAP_TAPCELL_ROW_17_468 VGND VPWR sky130_fd_sc_hd__tapvpwrvgnd_1
XFILLER_43_793 VGND VGND VPWR VPWR sky130_fd_sc_hd__fill_1
XFILLER_42_292 VGND VGND VPWR VPWR sky130_fd_sc_hd__decap_3
XFILLER_30_498 VGND VGND VPWR VPWR sky130_fd_sc_hd__decap_3
XFILLER_11_690 VGND VGND VPWR VPWR sky130_fd_sc_hd__fill_2
Xg_row\[0\].g_col\[0\].pe__2050_ g_row\[0\].g_col\[0\].pe__2025_/Y g_row\[0\].g_col\[0\].pe__1991_/X
+ g_row\[0\].g_col\[0\].pe__2048_/Y g_row\[0\].g_col\[0\].pe__2049_/X VGND VGND VPWR
+ VPWR g_row\[0\].g_col\[0\].pe__2052_/B sky130_fd_sc_hd__o211a_4
Xg_row\[1\].g_col\[1\].pe__1910_ g_row\[1\].g_col\[1\].pe__2167_/A g_row\[1\].g_col\[1\].pe__1910_/B
+ VGND VGND VPWR VPWR g_row\[1\].g_col\[1\].pe__1955_/A sky130_fd_sc_hd__xor2_2
XFILLER_7_683 VGND VGND VPWR VPWR sky130_fd_sc_hd__fill_1
Xg_row\[1\].g_col\[1\].pe__1841_ g_row\[1\].g_col\[1\].pe__1841_/A VGND VGND VPWR
+ VPWR g_row\[1\].g_col\[1\].pe__1843_/A sky130_fd_sc_hd__inv_2
Xg_row\[1\].g_col\[0\].pe__1825_ g_row\[1\].g_col\[0\].pe__1747_/A g_row\[1\].g_col\[0\].pe__1820_/B
+ g_row\[1\].g_col\[0\].pe__1824_/X VGND VGND VPWR VPWR g_row\[1\].g_col\[0\].pe__1828_/B
+ sky130_fd_sc_hd__a21oi_2
Xg_row\[1\].g_col\[1\].pe__1772_ g_row\[1\].g_col\[1\].pe__1780_/A g_row\[1\].g_col\[1\].pe__1794_/A
+ VGND VGND VPWR VPWR g_row\[1\].g_col\[1\].pe__1813_/A sky130_fd_sc_hd__and2_2
Xg_row\[1\].g_col\[0\].pe__1756_ g_row\[1\].g_col\[0\].pe__1756_/A g_row\[1\].g_col\[0\].pe__1756_/B
+ VGND VGND VPWR VPWR g_row\[1\].g_col\[0\].pe__1756_/X sky130_fd_sc_hd__and2_2
Xg_row\[0\].g_col\[0\].pe__1903_ g_row\[0\].g_col\[0\].pe__2364_/A g_row\[0\].g_col\[0\].pe__1903_/B
+ VGND VGND VPWR VPWR g_row\[0\].g_col\[0\].pe__1905_/B sky130_fd_sc_hd__xnor2_2
Xg_row\[1\].g_col\[0\].pe_hold2931 g_row\[1\].g_col\[0\].pe_hold2931/A VGND VGND VPWR
+ VPWR g_row\[1\].g_col\[0\].pe__2633_/A2 sky130_fd_sc_hd__clkbuf_2
Xg_row\[1\].g_col\[0\].pe__1687_ g_row\[1\].g_col\[0\].pe__1713_/A g_row\[1\].g_col\[0\].pe__1713_/B
+ g_row\[1\].g_col\[0\].pe__1686_/X VGND VGND VPWR VPWR g_row\[1\].g_col\[0\].pe__1721_/A
+ sky130_fd_sc_hd__a21oi_2
XFILLER_69_189 VGND VGND VPWR VPWR sky130_fd_sc_hd__fill_1
Xg_row\[0\].g_col\[0\].pe__1834_ g_row\[0\].g_col\[0\].pe__1834_/A g_row\[0\].g_col\[0\].pe__1834_/B
+ VGND VGND VPWR VPWR g_row\[0\].g_col\[0\].pe__1834_/Y sky130_fd_sc_hd__xnor2_2
Xg_row\[0\].g_col\[1\].pe__1850_ g_row\[0\].g_col\[1\].pe__1850_/A g_row\[0\].g_col\[1\].pe__1850_/B
+ VGND VGND VPWR VPWR g_row\[0\].g_col\[1\].pe__1886_/A sky130_fd_sc_hd__nor2_2
XFILLER_66_841 VGND VGND VPWR VPWR sky130_fd_sc_hd__fill_1
Xg_row\[1\].g_col\[0\].pe_hold2997 g_row\[1\].g_col\[0\].pe__1391_/X VGND VGND VPWR
+ VPWR g_row\[1\].g_col\[0\].pe_hold2997/X sky130_fd_sc_hd__clkbuf_2
Xg_row\[1\].g_col\[0\].pe_hold2986 g_row\[1\].g_col\[0\].pe__2668_/X VGND VGND VPWR
+ VPWR g_row\[1\].g_col\[0\].pe_hold2986/X sky130_fd_sc_hd__clkbuf_2
XFILLER_38_587 VGND VGND VPWR VPWR sky130_fd_sc_hd__fill_1
XFILLER_93_682 VGND VGND VPWR VPWR sky130_fd_sc_hd__decap_3
Xg_row\[0\].g_col\[0\].pe__1765_ g_row\[0\].g_col\[0\].pe__1766_/A g_row\[0\].g_col\[0\].pe__1766_/B
+ VGND VGND VPWR VPWR g_row\[0\].g_col\[0\].pe__1793_/B sky130_fd_sc_hd__nand2_2
Xg_row\[1\].g_col\[1\].pe__2324_ g_row\[1\].g_col\[1\].pe__2285_/A g_row\[1\].g_col\[1\].pe__2285_/B
+ g_row\[1\].g_col\[1\].pe__2284_/B VGND VGND VPWR VPWR g_row\[1\].g_col\[1\].pe__2338_/A
+ sky130_fd_sc_hd__a21oi_2
Xg_row\[1\].g_col\[0\].pe__2308_ g_row\[1\].g_col\[0\].pe__2308_/A VGND VGND VPWR
+ VPWR g_row\[1\].g_col\[0\].pe__2430_/A sky130_fd_sc_hd__inv_2
Xg_row\[0\].g_col\[1\].pe__1781_ g_row\[0\].g_col\[1\].pe__1781_/A g_row\[0\].g_col\[1\].pe__1781_/B
+ VGND VGND VPWR VPWR g_row\[0\].g_col\[1\].pe__1791_/A sky130_fd_sc_hd__xnor2_2
XFILLER_53_535 VGND VGND VPWR VPWR sky130_fd_sc_hd__decap_3
XTAP_TAPCELL_ROW_36_744 VGND VPWR sky130_fd_sc_hd__tapvpwrvgnd_1
Xg_row\[0\].g_col\[0\].pe__1696_ g_row\[0\].g_col\[0\].pe__1678_/Y g_row\[0\].g_col\[0\].pe__1703_/B
+ g_row\[0\].g_col\[0\].pe__1695_/X VGND VGND VPWR VPWR g_row\[0\].g_col\[0\].pe__1698_/A
+ sky130_fd_sc_hd__a21oi_2
Xg_row\[1\].g_col\[1\].pe__2255_ g_row\[1\].g_col\[1\].pe__2271_/A g_row\[1\].g_col\[1\].pe__2271_/B
+ VGND VGND VPWR VPWR g_row\[1\].g_col\[1\].pe__2257_/A sky130_fd_sc_hd__xnor2_2
Xg_row\[1\].g_col\[0\].pe__2239_ g_row\[1\].g_col\[0\].pe__2239_/A g_row\[1\].g_col\[0\].pe__2239_/B
+ VGND VGND VPWR VPWR g_row\[1\].g_col\[0\].pe__2246_/A sky130_fd_sc_hd__nand2_2
XFILLER_80_365 VGND VGND VPWR VPWR sky130_fd_sc_hd__fill_2
XTAP_TAPCELL_ROW_36_755 VGND VPWR sky130_fd_sc_hd__tapvpwrvgnd_1
Xg_row\[1\].g_col\[1\].pe__2186_ g_row\[1\].g_col\[1\].pe__2203_/B g_row\[1\].g_col\[1\].pe__2186_/B
+ VGND VGND VPWR VPWR g_row\[1\].g_col\[1\].pe__2190_/A sky130_fd_sc_hd__xor2_2
Xg_row\[0\].g_col\[1\].pe__2402_ _203_/A g_row\[0\].g_col\[1\].pe__2402_/B VGND VGND
+ VPWR VPWR g_row\[0\].g_col\[1\].pe__2754_/D sky130_fd_sc_hd__nor2_2
Xg_row\[0\].g_col\[1\].pe__2333_ g_row\[0\].g_col\[1\].pe__2330_/X g_row\[0\].g_col\[1\].pe__2329_/B
+ g_row\[0\].g_col\[1\].pe__2358_/A g_row\[0\].g_col\[1\].pe__2157_/A VGND VGND VPWR
+ VPWR g_row\[0\].g_col\[1\].pe__2333_/Y sky130_fd_sc_hd__o211ai_2
Xg_row\[0\].g_col\[0\].pe__2317_ g_row\[0\].g_col\[0\].pe__2347_/A g_row\[0\].g_col\[0\].pe__2317_/B
+ VGND VGND VPWR VPWR g_row\[0\].g_col\[0\].pe__2318_/B sky130_fd_sc_hd__nor2_2
Xg_row\[0\].g_col\[0\].pe__2248_ g_row\[0\].g_col\[0\].pe__2348_/A g_row\[0\].g_col\[0\].pe__2248_/B
+ VGND VGND VPWR VPWR g_row\[0\].g_col\[0\].pe__2250_/B sky130_fd_sc_hd__xnor2_2
Xg_row\[0\].g_col\[1\].pe__2264_ g_row\[0\].g_col\[1\].pe__2238_/X g_row\[0\].g_col\[1\].pe__2234_/Y
+ g_row\[0\].g_col\[1\].pe__2263_/X g_row\[0\].g_col\[1\].pe__2157_/A VGND VGND VPWR
+ VPWR g_row\[0\].g_col\[1\].pe__2264_/X sky130_fd_sc_hd__o31a_2
Xg_row\[0\].g_col\[1\].pe__2195_ g_row\[0\].g_col\[1\].pe__2231_/A g_row\[0\].g_col\[1\].pe__2231_/B
+ VGND VGND VPWR VPWR g_row\[0\].g_col\[1\].pe__2200_/B sky130_fd_sc_hd__xnor2_2
Xg_row\[0\].g_col\[0\].pe__2179_ g_row\[0\].g_col\[0\].pe__2217_/A g_row\[0\].g_col\[0\].pe__2179_/B
+ VGND VGND VPWR VPWR g_row\[0\].g_col\[0\].pe__2213_/B sky130_fd_sc_hd__xnor2_2
Xg_row\[1\].g_col\[1\].pe_hold1815 g_row\[1\].g_col\[1\].pe__2564_/X VGND VGND VPWR
+ VPWR g_row\[1\].g_col\[1\].pe__2565_/B sky130_fd_sc_hd__clkbuf_2
XFILLER_1_837 VGND VGND VPWR VPWR sky130_fd_sc_hd__decap_3
Xhold3220 hold3220/A VGND VGND VPWR VPWR hold3220/X sky130_fd_sc_hd__clkbuf_2
Xhold3231 hold3231/A VGND VGND VPWR VPWR hold3231/X sky130_fd_sc_hd__clkbuf_2
Xhold3242 b_inputs_flat[9] VGND VGND VPWR VPWR hold3242/X sky130_fd_sc_hd__clkbuf_2
Xhold2530 hold3281/X VGND VGND VPWR VPWR hold3282/A sky130_fd_sc_hd__clkbuf_2
Xhold3253 hold3253/A VGND VGND VPWR VPWR hold3253/X sky130_fd_sc_hd__clkbuf_2
Xhold3264 hold3264/A VGND VGND VPWR VPWR hold3264/X sky130_fd_sc_hd__clkbuf_2
Xhold3275 hold3275/A VGND VGND VPWR VPWR hold3275/X sky130_fd_sc_hd__clkbuf_2
XFILLER_76_627 VGND VGND VPWR VPWR sky130_fd_sc_hd__decap_3
Xhold2541 hold3286/X VGND VGND VPWR VPWR hold3287/A sky130_fd_sc_hd__clkbuf_2
Xhold2552 hold3312/X VGND VGND VPWR VPWR hold3313/A sky130_fd_sc_hd__clkbuf_2
Xhold2563 hold2563/A VGND VGND VPWR VPWR _309_/D sky130_fd_sc_hd__clkbuf_2
Xhold2574 _149_/Y VGND VGND VPWR VPWR hold2574/X sky130_fd_sc_hd__clkbuf_2
Xhold3286 hold3286/A VGND VGND VPWR VPWR hold3286/X sky130_fd_sc_hd__clkbuf_2
Xhold3297 hold3297/A VGND VGND VPWR VPWR hold3297/X sky130_fd_sc_hd__clkbuf_2
XFILLER_29_554 VGND VGND VPWR VPWR sky130_fd_sc_hd__fill_1
XFILLER_57_841 VGND VGND VPWR VPWR sky130_fd_sc_hd__fill_1
XFILLER_84_25 VGND VGND VPWR VPWR sky130_fd_sc_hd__decap_3
Xhold2585 hold3360/X VGND VGND VPWR VPWR _235_/B_N sky130_fd_sc_hd__clkbuf_2
Xhold2596 hold3393/X VGND VGND VPWR VPWR hold3394/A sky130_fd_sc_hd__clkbuf_2
XFILLER_44_513 VGND VGND VPWR VPWR sky130_fd_sc_hd__fill_2
XFILLER_56_362 VGND VGND VPWR VPWR sky130_fd_sc_hd__fill_2
XFILLER_56_373 VGND VGND VPWR VPWR sky130_fd_sc_hd__fill_2
Xhold1884 hold2984/X VGND VGND VPWR VPWR hold1884/X sky130_fd_sc_hd__clkbuf_2
Xg_row\[0\].g_col\[1\].pe__1979_ g_row\[0\].g_col\[1\].pe__1978_/A g_row\[0\].g_col\[1\].pe__1978_/B
+ g_row\[0\].g_col\[1\].pe__1978_/C VGND VGND VPWR VPWR g_row\[0\].g_col\[1\].pe__1991_/B
+ sky130_fd_sc_hd__o21ai_2
XFILLER_24_281 VGND VGND VPWR VPWR sky130_fd_sc_hd__decap_3
XTAP_TAPCELL_ROW_14_416 VGND VPWR sky130_fd_sc_hd__tapvpwrvgnd_1
XTAP_TAPCELL_ROW_14_427 VGND VPWR sky130_fd_sc_hd__tapvpwrvgnd_1
XTAP_TAPCELL_ROW_74_1318 VGND VPWR sky130_fd_sc_hd__tapvpwrvgnd_1
XFILLER_4_675 VGND VGND VPWR VPWR sky130_fd_sc_hd__decap_3
Xg_row\[1\].g_col\[0\].pe__2590_ g_row\[1\].g_col\[0\].pe__2590_/A g_row\[1\].g_col\[0\].pe__2508_/Y
+ VGND VGND VPWR VPWR g_row\[1\].g_col\[0\].pe__2590_/X sky130_fd_sc_hd__or2b_2
Xg_row\[1\].g_col\[0\].pe__1610_ place1092/A g_row\[1\].g_col\[0\].pe__1715_/B g_row\[1\].g_col\[0\].pe__1863_/B1
+ place1094/X VGND VGND VPWR VPWR g_row\[1\].g_col\[0\].pe__1611_/B sky130_fd_sc_hd__a22o_2
XFILLER_3_196 VGND VGND VPWR VPWR sky130_fd_sc_hd__fill_1
Xg_row\[1\].g_col\[0\].pe__1541_ g_row\[1\].g_col\[0\].pe__2736_/Q g_row\[1\].g_col\[0\].pe__2341_/B
+ g_row\[1\].g_col\[0\].pe__1540_/X VGND VGND VPWR VPWR g_row\[1\].g_col\[0\].pe__1541_/X
+ sky130_fd_sc_hd__a21o_2
XFILLER_67_638 VGND VGND VPWR VPWR sky130_fd_sc_hd__decap_3
XFILLER_47_340 VGND VGND VPWR VPWR sky130_fd_sc_hd__fill_1
XTAP_TAPCELL_ROW_89_1550 VGND VPWR sky130_fd_sc_hd__tapvpwrvgnd_1
XFILLER_35_535 VGND VGND VPWR VPWR sky130_fd_sc_hd__fill_1
XFILLER_47_384 VGND VGND VPWR VPWR sky130_fd_sc_hd__decap_3
XFILLER_62_332 VGND VGND VPWR VPWR sky130_fd_sc_hd__fill_1
Xg_row\[0\].g_col\[0\].pe__1550_ g_row\[0\].g_col\[0\].pe__1550_/A g_row\[0\].g_col\[0\].pe__1550_/B
+ VGND VGND VPWR VPWR g_row\[0\].g_col\[0\].pe__1669_/B sky130_fd_sc_hd__xnor2_2
XFILLER_16_760 VGND VGND VPWR VPWR sky130_fd_sc_hd__fill_1
XFILLER_23_708 VGND VGND VPWR VPWR sky130_fd_sc_hd__fill_2
XFILLER_62_365 VGND VGND VPWR VPWR sky130_fd_sc_hd__fill_1
XFILLER_90_652 VGND VGND VPWR VPWR sky130_fd_sc_hd__decap_3
XTAP_TAPCELL_ROW_33_703 VGND VPWR sky130_fd_sc_hd__tapvpwrvgnd_1
Xg_row\[1\].g_col\[1\].pe__2040_ g_row\[1\].g_col\[1\].pe__2726_/Q g_row\[1\].g_col\[1\].pe__2727_/Q
+ g_row\[1\].g_col\[1\].pe__2163_/A VGND VGND VPWR VPWR g_row\[1\].g_col\[1\].pe__2040_/X
+ sky130_fd_sc_hd__or3b_4
XFILLER_16_782 VGND VGND VPWR VPWR sky130_fd_sc_hd__fill_1
XFILLER_50_549 VGND VGND VPWR VPWR sky130_fd_sc_hd__decap_3
Xg_row\[0\].g_col\[0\].pe__1481_ g_row\[0\].g_col\[0\].pe__1481_/A g_row\[0\].g_col\[0\].pe__1481_/B
+ VGND VGND VPWR VPWR g_row\[0\].g_col\[0\].pe__1481_/X sky130_fd_sc_hd__and2_2
Xg_row\[1\].g_col\[0\].pe__2024_ g_row\[1\].g_col\[0\].pe__2024_/A g_row\[1\].g_col\[0\].pe__2024_/B
+ VGND VGND VPWR VPWR g_row\[1\].g_col\[0\].pe__2052_/A sky130_fd_sc_hd__xor2_2
XFILLER_30_251 VGND VGND VPWR VPWR sky130_fd_sc_hd__fill_1
XFILLER_31_785 VGND VGND VPWR VPWR sky130_fd_sc_hd__fill_2
Xclkbuf_4_4_0_clk clkbuf_0_clk/X VGND VGND VPWR VPWR clkbuf_4_4_0_clk/X sky130_fd_sc_hd__clkbuf_16
Xg_row\[0\].g_col\[0\].pe__2102_ g_row\[0\].g_col\[0\].pe__2145_/A g_row\[0\].g_col\[0\].pe__2101_/C
+ g_row\[0\].g_col\[0\].pe__2101_/A VGND VGND VPWR VPWR g_row\[0\].g_col\[0\].pe__2104_/B
+ sky130_fd_sc_hd__o21ai_2
Xg_row\[0\].g_col\[0\].pe__2033_ g_row\[0\].g_col\[0\].pe__2032_/B g_row\[0\].g_col\[0\].pe__2032_/C
+ g_row\[0\].g_col\[0\].pe__2165_/A VGND VGND VPWR VPWR g_row\[0\].g_col\[0\].pe__2034_/D
+ sky130_fd_sc_hd__a21o_2
Xplace1102 hold2198/X VGND VGND VPWR VPWR place1102/X sky130_fd_sc_hd__buf_6
Xg_row\[1\].g_col\[1\].pe__1824_ g_row\[1\].g_col\[1\].pe__1726_/B g_row\[1\].g_col\[1\].pe__1824_/B
+ VGND VGND VPWR VPWR g_row\[1\].g_col\[1\].pe__1824_/X sky130_fd_sc_hd__and2b_2
Xg_row\[1\].g_col\[0\].pe__1808_ g_row\[1\].g_col\[0\].pe__1808_/A g_row\[1\].g_col\[0\].pe__1808_/B
+ g_row\[1\].g_col\[0\].pe__1808_/C g_row\[1\].g_col\[0\].pe__1811_/C VGND VGND VPWR
+ VPWR g_row\[1\].g_col\[0\].pe__1808_/X sky130_fd_sc_hd__or4b_4
Xg_row\[1\].g_col\[1\].pe__1755_ g_row\[1\].g_col\[1\].pe__2728_/Q g_row\[1\].g_col\[1\].pe__1755_/B
+ VGND VGND VPWR VPWR g_row\[1\].g_col\[1\].pe__1770_/B sky130_fd_sc_hd__xor2_2
Xg_row\[1\].g_col\[0\].pe__1739_ g_row\[1\].g_col\[0\].pe__1816_/A g_row\[1\].g_col\[0\].pe__1739_/B
+ VGND VGND VPWR VPWR g_row\[1\].g_col\[0\].pe__1776_/B sky130_fd_sc_hd__xor2_2
XFILLER_38_29 VGND VGND VPWR VPWR sky130_fd_sc_hd__fill_1
XFILLER_58_627 VGND VGND VPWR VPWR sky130_fd_sc_hd__decap_3
Xg_row\[1\].g_col\[1\].pe__1686_ g_row\[1\].g_col\[1\].pe__1686_/A g_row\[1\].g_col\[1\].pe__1686_/B
+ VGND VGND VPWR VPWR g_row\[1\].g_col\[1\].pe__1686_/X sky130_fd_sc_hd__and2_2
Xg_row\[0\].g_col\[1\].pe__1902_ g_row\[0\].g_col\[1\].pe__2695_/Q g_row\[0\].g_col\[1\].pe__1549_/B
+ g_row\[0\].g_col\[1\].pe__2216_/B1 g_row\[0\].g_col\[1\].pe__2019_/B2 VGND VGND
+ VPWR VPWR g_row\[0\].g_col\[1\].pe__1903_/B sky130_fd_sc_hd__a22o_2
XFILLER_39_841 VGND VGND VPWR VPWR sky130_fd_sc_hd__fill_1
XFILLER_85_468 VGND VGND VPWR VPWR sky130_fd_sc_hd__fill_2
XFILLER_38_362 VGND VGND VPWR VPWR sky130_fd_sc_hd__fill_2
Xg_row\[0\].g_col\[0\].pe__1817_ g_row\[0\].g_col\[0\].pe__1777_/A g_row\[0\].g_col\[0\].pe__1777_/B
+ g_row\[0\].g_col\[0\].pe__1816_/X VGND VGND VPWR VPWR g_row\[0\].g_col\[0\].pe__1818_/B
+ sky130_fd_sc_hd__a21oi_2
Xg_row\[0\].g_col\[1\].pe__1833_ g_row\[0\].g_col\[1\].pe__1702_/X g_row\[0\].g_col\[1\].pe__1829_/Y
+ g_row\[0\].g_col\[1\].pe__1832_/Y VGND VGND VPWR VPWR g_row\[0\].g_col\[1\].pe__1834_/B
+ sky130_fd_sc_hd__a21oi_2
Xclkbuf_leaf_92_clk clkload1/A VGND VGND VPWR VPWR clkbuf_leaf_92_clk/X sky130_fd_sc_hd__clkbuf_16
Xg_row\[0\].g_col\[0\].pe__1748_ place1221/X g_row\[0\].g_col\[0\].pe__1748_/B VGND
+ VGND VPWR VPWR g_row\[0\].g_col\[0\].pe__1816_/B sky130_fd_sc_hd__nand2_2
Xg_row\[1\].g_col\[1\].pe__2307_ g_row\[1\].g_col\[1\].pe__2396_/A g_row\[1\].g_col\[1\].pe__2307_/B
+ VGND VGND VPWR VPWR g_row\[1\].g_col\[1\].pe__2749_/D sky130_fd_sc_hd__nor2_2
Xg_row\[0\].g_col\[1\].pe__1764_ g_row\[0\].g_col\[1\].pe__2686_/A g_row\[0\].g_col\[1\].pe__1764_/B
+ VGND VGND VPWR VPWR g_row\[0\].g_col\[1\].pe__1766_/B sky130_fd_sc_hd__xor2_2
XFILLER_53_343 VGND VGND VPWR VPWR sky130_fd_sc_hd__decap_3
XTAP_TAPCELL_ROW_0_188 VGND VPWR sky130_fd_sc_hd__tapvpwrvgnd_1
XFILLER_53_387 VGND VGND VPWR VPWR sky130_fd_sc_hd__decap_3
XTAP_TAPCELL_ROW_0_199 VGND VPWR sky130_fd_sc_hd__tapvpwrvgnd_1
Xg_row\[0\].g_col\[0\].pe__1679_ g_row\[0\].g_col\[0\].pe__1804_/A place1205/X place1207/X
+ g_row\[0\].g_col\[0\].pe__1804_/B VGND VGND VPWR VPWR g_row\[0\].g_col\[0\].pe__1680_/B
+ sky130_fd_sc_hd__a22o_2
Xg_row\[0\].g_col\[1\].pe__1695_ g_row\[0\].g_col\[1\].pe__1695_/A g_row\[0\].g_col\[1\].pe__1695_/B
+ VGND VGND VPWR VPWR g_row\[0\].g_col\[1\].pe__1695_/X sky130_fd_sc_hd__and2_2
Xg_row\[1\].g_col\[1\].pe__2238_ g_row\[1\].g_col\[1\].pe__2238_/A g_row\[1\].g_col\[1\].pe__2238_/B
+ VGND VGND VPWR VPWR g_row\[1\].g_col\[1\].pe__2238_/X sky130_fd_sc_hd__and2_2
Xg_row\[1\].g_col\[1\].pe__2169_ g_row\[1\].g_col\[1\].pe__2167_/X g_row\[1\].g_col\[1\].pe__2169_/B
+ VGND VGND VPWR VPWR g_row\[1\].g_col\[1\].pe__2172_/A sky130_fd_sc_hd__and2b_2
Xg_row\[0\].g_col\[1\].pe__2316_ g_row\[0\].g_col\[1\].pe__2316_/A g_row\[0\].g_col\[1\].pe__2316_/B
+ VGND VGND VPWR VPWR g_row\[0\].g_col\[1\].pe__2317_/B sky130_fd_sc_hd__nor2_2
Xg_row\[0\].g_col\[1\].pe__2247_ g_row\[0\].g_col\[1\].pe__2704_/Q g_row\[0\].g_col\[1\].pe__1657_/B
+ g_row\[0\].g_col\[1\].pe__2247_/B1 g_row\[0\].g_col\[1\].pe__2630_/B VGND VGND VPWR
+ VPWR g_row\[0\].g_col\[1\].pe__2248_/B sky130_fd_sc_hd__a22o_2
Xg_row\[1\].g_col\[1\].pe_hold3058 hold2139/X VGND VGND VPWR VPWR g_row\[1\].g_col\[1\].pe__2648_/A2
+ sky130_fd_sc_hd__clkbuf_2
Xg_row\[1\].g_col\[1\].pe_hold3069 g_row\[1\].g_col\[1\].pe__2730_/Q VGND VGND VPWR
+ VPWR g_row\[1\].g_col\[1\].pe_hold3069/X sky130_fd_sc_hd__clkbuf_2
Xg_row\[0\].g_col\[1\].pe__2178_ g_row\[0\].g_col\[1\].pe__2241_/A1 g_row\[0\].g_col\[1\].pe__1504_/Y
+ g_row\[0\].g_col\[1\].pe__2216_/B1 g_row\[0\].g_col\[1\].pe__2621_/B VGND VGND VPWR
+ VPWR g_row\[0\].g_col\[1\].pe__2179_/B sky130_fd_sc_hd__a22o_2
XTAP_TAPCELL_ROW_56_1048 VGND VPWR sky130_fd_sc_hd__tapvpwrvgnd_1
Xg_row\[1\].g_col\[1\].pe_hold1645 g_row\[1\].g_col\[1\].pe__1948_/Y VGND VGND VPWR
+ VPWR g_row\[1\].g_col\[1\].pe__2741_/D sky130_fd_sc_hd__clkbuf_2
Xg_row\[1\].g_col\[1\].pe_hold1678 g_row\[1\].g_col\[1\].pe__2513_/Y VGND VGND VPWR
+ VPWR g_row\[1\].g_col\[1\].pe__2514_/B sky130_fd_sc_hd__clkbuf_2
Xg_row\[1\].g_col\[1\].pe_hold1667 g_row\[1\].g_col\[1\].pe__2739_/Q VGND VGND VPWR
+ VPWR g_row\[1\].g_col\[1\].pe__1835_/A2 sky130_fd_sc_hd__clkbuf_2
XFILLER_89_785 VGND VGND VPWR VPWR sky130_fd_sc_hd__fill_1
XFILLER_29_373 VGND VGND VPWR VPWR sky130_fd_sc_hd__decap_3
XFILLER_57_660 VGND VGND VPWR VPWR sky130_fd_sc_hd__decap_3
Xclkbuf_leaf_83_clk clkbuf_4_8_0_clk/X VGND VGND VPWR VPWR clkbuf_leaf_83_clk/X sky130_fd_sc_hd__clkbuf_16
XFILLER_17_579 VGND VGND VPWR VPWR sky130_fd_sc_hd__decap_3
XFILLER_44_343 VGND VGND VPWR VPWR sky130_fd_sc_hd__decap_3
XFILLER_44_354 VGND VGND VPWR VPWR sky130_fd_sc_hd__decap_3
XFILLER_44_365 VGND VGND VPWR VPWR sky130_fd_sc_hd__fill_1
XFILLER_72_696 VGND VGND VPWR VPWR sky130_fd_sc_hd__decap_3
XFILLER_9_723 VGND VGND VPWR VPWR sky130_fd_sc_hd__decap_3
XFILLER_9_767 VGND VGND VPWR VPWR sky130_fd_sc_hd__fill_1
XFILLER_60_82 VGND VGND VPWR VPWR sky130_fd_sc_hd__fill_2
Xg_row\[0\].g_col\[0\].pe_place1251 _273_/Q VGND VGND VPWR VPWR g_row\[0\].g_col\[0\].pe__2623_/A
+ sky130_fd_sc_hd__buf_6
Xg_row\[1\].g_col\[0\].pe__2711_ clkbuf_leaf_45_clk/X g_row\[1\].g_col\[0\].pe__2711_/D
+ VGND VGND VPWR VPWR g_row\[1\].g_col\[0\].pe__2711_/Q sky130_fd_sc_hd__dfxtp_2
Xg_row\[1\].g_col\[0\].pe__2642_ g_row\[1\].g_col\[0\].pe__2652_/A1 hold1887/X g_row\[1\].g_col\[0\].pe__2677_/B1
+ g_row\[1\].g_col\[0\].pe__2642_/C1 VGND VGND VPWR VPWR g_row\[1\].g_col\[0\].pe__2642_/X
+ sky130_fd_sc_hd__o211a_2
Xg_row\[1\].g_col\[0\].pe__2573_ g_row\[1\].g_col\[0\].pe__2595_/A g_row\[1\].g_col\[0\].pe__2573_/B
+ VGND VGND VPWR VPWR g_row\[1\].g_col\[0\].pe__2766_/D sky130_fd_sc_hd__and2_2
Xg_row\[1\].g_col\[1\].pe__1540_ g_row\[1\].g_col\[1\].pe__2736_/Q g_row\[1\].g_col\[1\].pe__2735_/Q
+ g_row\[1\].g_col\[1\].pe__1540_/C VGND VGND VPWR VPWR g_row\[1\].g_col\[1\].pe__1540_/X
+ sky130_fd_sc_hd__and3b_2
Xg_row\[1\].g_col\[0\].pe_hold2046 g_row\[1\].g_col\[0\].pe__2683_/X VGND VGND VPWR
+ VPWR g_row\[1\].g_col\[0\].pe__2724_/D sky130_fd_sc_hd__clkbuf_2
Xg_row\[1\].g_col\[0\].pe__1524_ g_row\[1\].g_col\[0\].pe__1584_/A g_row\[1\].g_col\[0\].pe__1584_/B
+ VGND VGND VPWR VPWR g_row\[1\].g_col\[0\].pe__1533_/A sky130_fd_sc_hd__xor2_2
XTAP_TAPCELL_ROW_87_1509 VGND VPWR sky130_fd_sc_hd__tapvpwrvgnd_1
Xg_row\[0\].g_col\[0\].pe__2720_ clkbuf_leaf_37_clk/X g_row\[0\].g_col\[0\].pe__2720_/D
+ VGND VGND VPWR VPWR hold2082/A sky130_fd_sc_hd__dfxtp_2
Xg_row\[1\].g_col\[1\].pe__1471_ g_row\[1\].g_col\[1\].pe__1471_/A g_row\[1\].g_col\[1\].pe__1471_/B
+ VGND VGND VPWR VPWR g_row\[1\].g_col\[1\].pe__1471_/X sky130_fd_sc_hd__and2_2
Xg_row\[1\].g_col\[0\].pe_hold2079 g_row\[1\].g_col\[0\].pe__2707_/Q VGND VGND VPWR
+ VPWR g_row\[1\].g_col\[0\].pe__2643_/B sky130_fd_sc_hd__clkbuf_2
Xg_row\[1\].g_col\[0\].pe_hold2068 g_row\[1\].g_col\[0\].pe_hold3031/X VGND VGND VPWR
+ VPWR g_row\[1\].g_col\[0\].pe__2715_/D sky130_fd_sc_hd__clkbuf_2
Xg_row\[1\].g_col\[0\].pe_hold2057 g_row\[1\].g_col\[0\].pe__2628_/X VGND VGND VPWR
+ VPWR g_row\[1\].g_col\[0\].pe__2702_/D sky130_fd_sc_hd__clkbuf_2
XFILLER_82_405 VGND VGND VPWR VPWR sky130_fd_sc_hd__fill_2
Xg_row\[0\].g_col\[0\].pe__2651_ g_row\[0\].g_col\[0\].pe__2676_/A hold1896/X VGND
+ VGND VPWR VPWR g_row\[0\].g_col\[0\].pe__2651_/X sky130_fd_sc_hd__or2_2
XFILLER_63_630 VGND VGND VPWR VPWR sky130_fd_sc_hd__decap_3
Xclkbuf_leaf_74_clk clkbuf_4_10_0_clk/X VGND VGND VPWR VPWR clkbuf_leaf_74_clk/X sky130_fd_sc_hd__clkbuf_16
Xg_row\[0\].g_col\[0\].pe__1602_ g_row\[0\].g_col\[0\].pe__1602_/A g_row\[0\].g_col\[0\].pe__1602_/B
+ VGND VGND VPWR VPWR g_row\[0\].g_col\[0\].pe__1604_/B sky130_fd_sc_hd__xnor2_2
Xg_row\[1\].g_col\[0\].pe__1386_ g_row\[1\].g_col\[0\].pe__1386_/A1 g_row\[1\].g_col\[0\].pe__2686_/B
+ g_row\[1\].g_col\[0\].pe__1385_/X g_row\[1\].g_col\[0\].pe__2679_/C1 VGND VGND VPWR
+ VPWR g_row\[1\].g_col\[0\].pe__1386_/X sky130_fd_sc_hd__o211a_2
Xg_row\[0\].g_col\[0\].pe__2582_ g_row\[0\].g_col\[0\].pe__2592_/A g_row\[0\].g_col\[0\].pe__2582_/B
+ VGND VGND VPWR VPWR g_row\[0\].g_col\[0\].pe__2768_/D sky130_fd_sc_hd__and2_2
XFILLER_23_527 VGND VGND VPWR VPWR sky130_fd_sc_hd__decap_3
XTAP_TAPCELL_ROW_46_894 VGND VPWR sky130_fd_sc_hd__tapvpwrvgnd_1
Xg_row\[0\].g_col\[0\].pe__1533_ g_row\[0\].g_col\[0\].pe__1533_/A g_row\[0\].g_col\[0\].pe__1533_/B
+ VGND VGND VPWR VPWR g_row\[0\].g_col\[0\].pe__1588_/B sky130_fd_sc_hd__xnor2_2
Xg_row\[0\].g_col\[0\].pe__1464_ g_row\[0\].g_col\[0\].pe__1864_/A g_row\[0\].g_col\[0\].pe__1464_/B
+ VGND VGND VPWR VPWR g_row\[0\].g_col\[0\].pe__1507_/B sky130_fd_sc_hd__xnor2_2
Xg_row\[0\].g_col\[1\].pe__1480_ g_row\[0\].g_col\[1\].pe__1662_/A g_row\[0\].g_col\[1\].pe__1662_/B
+ g_row\[0\].g_col\[1\].pe__1479_/Y VGND VGND VPWR VPWR g_row\[0\].g_col\[1\].pe__1501_/A
+ sky130_fd_sc_hd__a21oi_2
Xg_row\[1\].g_col\[1\].pe__2023_ g_row\[1\].g_col\[1\].pe__2023_/A g_row\[1\].g_col\[1\].pe__2023_/B
+ VGND VGND VPWR VPWR g_row\[1\].g_col\[1\].pe__2024_/B sky130_fd_sc_hd__xor2_2
Xg_row\[1\].g_col\[0\].pe__2007_ g_row\[1\].g_col\[0\].pe__2009_/C g_row\[1\].g_col\[0\].pe__2008_/A
+ g_row\[1\].g_col\[0\].pe__2151_/B VGND VGND VPWR VPWR g_row\[1\].g_col\[0\].pe__2010_/B
+ sky130_fd_sc_hd__and3b_2
XFILLER_50_368 VGND VGND VPWR VPWR sky130_fd_sc_hd__decap_3
Xg_row\[0\].g_col\[0\].pe__1395_ g_row\[0\].g_col\[0\].pe__1395_/A1 g_row\[0\].g_col\[0\].pe__1399_/A2
+ g_row\[0\].g_col\[0\].pe__1395_/B1 g_row\[0\].g_col\[0\].pe__2633_/B1 VGND VGND
+ VPWR VPWR g_row\[0\].g_col\[0\].pe__1395_/X sky130_fd_sc_hd__o211a_2
Xg_row\[0\].g_col\[1\].pe__2101_ g_row\[0\].g_col\[1\].pe__2101_/A g_row\[0\].g_col\[1\].pe__2145_/A
+ g_row\[0\].g_col\[1\].pe__2101_/C VGND VGND VPWR VPWR g_row\[0\].g_col\[1\].pe__2104_/A
+ sky130_fd_sc_hd__or3_4
Xg_row\[0\].g_col\[0\].pe__2016_ g_row\[0\].g_col\[0\].pe__1905_/A g_row\[0\].g_col\[0\].pe__1905_/B
+ g_row\[0\].g_col\[0\].pe__1964_/B g_row\[0\].g_col\[0\].pe__1963_/B g_row\[0\].g_col\[0\].pe__1963_/A
+ VGND VGND VPWR VPWR g_row\[0\].g_col\[0\].pe__2017_/A sky130_fd_sc_hd__a32o_2
Xg_row\[0\].g_col\[1\].pe__2032_ g_row\[0\].g_col\[1\].pe__2123_/A g_row\[0\].g_col\[1\].pe__2032_/B
+ g_row\[0\].g_col\[1\].pe__2032_/C VGND VGND VPWR VPWR g_row\[0\].g_col\[1\].pe__2034_/C
+ sky130_fd_sc_hd__nand3_2
Xg_row\[1\].g_col\[1\].pe__1807_ g_row\[1\].g_col\[1\].pe__1807_/A g_row\[1\].g_col\[1\].pe__1807_/B
+ VGND VGND VPWR VPWR g_row\[1\].g_col\[1\].pe__1811_/C sky130_fd_sc_hd__nand2_2
Xg_row\[1\].g_col\[1\].pe__1738_ g_row\[1\].g_col\[1\].pe__1805_/A2 g_row\[1\].g_col\[1\].pe__1748_/B
+ g_row\[1\].g_col\[1\].pe__1738_/B1 g_row\[1\].g_col\[1\].pe__2599_/B VGND VGND VPWR
+ VPWR g_row\[1\].g_col\[1\].pe__1739_/B sky130_fd_sc_hd__a22o_2
XFILLER_86_744 VGND VGND VPWR VPWR sky130_fd_sc_hd__fill_2
Xg_row\[1\].g_col\[1\].pe__1669_ g_row\[1\].g_col\[1\].pe__1669_/A g_row\[1\].g_col\[1\].pe__1669_/B
+ VGND VGND VPWR VPWR g_row\[1\].g_col\[1\].pe__1831_/B sky130_fd_sc_hd__xnor2_2
XFILLER_46_619 VGND VGND VPWR VPWR sky130_fd_sc_hd__fill_1
XANTENNA_106 hold3585/A VGND VGND VPWR VPWR sky130_fd_sc_hd__diode_2
Xclkbuf_leaf_65_clk clkload5/A VGND VGND VPWR VPWR _301_/CLK sky130_fd_sc_hd__clkbuf_16
Xg_row\[1\].g_col\[0\].pe_hold1890 g_row\[1\].g_col\[0\].pe__1396_/X VGND VGND VPWR
+ VPWR g_row\[1\].g_col\[0\].pe__1397_/B1 sky130_fd_sc_hd__clkbuf_2
Xg_row\[0\].g_col\[1\].pe__1816_ g_row\[0\].g_col\[1\].pe__1816_/A g_row\[0\].g_col\[1\].pe__1816_/B
+ g_row\[0\].g_col\[1\].pe__1816_/C VGND VGND VPWR VPWR g_row\[0\].g_col\[1\].pe__1816_/X
+ sky130_fd_sc_hd__and3_2
XANTENNA_117 ANTENNA_117/DIODE VGND VGND VPWR VPWR sky130_fd_sc_hd__diode_2
XANTENNA_128 hold3328/A VGND VGND VPWR VPWR sky130_fd_sc_hd__diode_2
XANTENNA_139 _255_/Y VGND VGND VPWR VPWR sky130_fd_sc_hd__diode_2
XFILLER_54_641 VGND VGND VPWR VPWR sky130_fd_sc_hd__decap_3
Xg_row\[0\].g_col\[1\].pe_hold2989 g_row\[0\].g_col\[1\].pe__2666_/X VGND VGND VPWR
+ VPWR g_row\[0\].g_col\[1\].pe_hold2989/X sky130_fd_sc_hd__clkbuf_2
Xg_row\[0\].g_col\[1\].pe_hold2967 _329_/Q VGND VGND VPWR VPWR ANTENNA_117/DIODE sky130_fd_sc_hd__clkbuf_2
XFILLER_81_26 VGND VGND VPWR VPWR sky130_fd_sc_hd__fill_1
Xg_row\[0\].g_col\[1\].pe__1747_ g_row\[0\].g_col\[1\].pe__1747_/A g_row\[0\].g_col\[1\].pe__1820_/B
+ VGND VGND VPWR VPWR g_row\[0\].g_col\[1\].pe__1822_/C sky130_fd_sc_hd__or2_2
X_280_ _292_/CLK _280_/D VGND VGND VPWR VPWR _280_/Q sky130_fd_sc_hd__dfxtp_2
Xg_row\[0\].g_col\[1\].pe__1678_ g_row\[0\].g_col\[1\].pe__1703_/A VGND VGND VPWR
+ VPWR g_row\[0\].g_col\[1\].pe__1678_/Y sky130_fd_sc_hd__inv_2
XTAP_TAPCELL_ROW_24_566 VGND VPWR sky130_fd_sc_hd__tapvpwrvgnd_1
XTAP_TAPCELL_ROW_24_577 VGND VPWR sky130_fd_sc_hd__tapvpwrvgnd_1
XFILLER_10_755 VGND VGND VPWR VPWR sky130_fd_sc_hd__fill_1
XFILLER_30_85 VGND VGND VPWR VPWR sky130_fd_sc_hd__decap_3
Xg_row\[1\].g_col\[1\].pe_hold2143 g_row\[1\].g_col\[1\].pe__1384_/X VGND VGND VPWR
+ VPWR g_row\[1\].g_col\[1\].pe__2728_/D sky130_fd_sc_hd__clkbuf_2
XFILLER_77_766 VGND VGND VPWR VPWR sky130_fd_sc_hd__decap_3
XFILLER_77_799 VGND VGND VPWR VPWR sky130_fd_sc_hd__decap_3
XFILLER_76_298 VGND VGND VPWR VPWR sky130_fd_sc_hd__fill_2
XTAP_TAPCELL_ROW_69_1239 VGND VPWR sky130_fd_sc_hd__tapvpwrvgnd_1
Xclkbuf_leaf_56_clk clkload7/A VGND VGND VPWR VPWR clkbuf_leaf_56_clk/X sky130_fd_sc_hd__clkbuf_16
XFILLER_45_641 VGND VGND VPWR VPWR sky130_fd_sc_hd__decap_3
XTAP_TAPCELL_ROW_82_1439 VGND VPWR sky130_fd_sc_hd__tapvpwrvgnd_1
Xg_row\[1\].g_col\[0\].pe_place850 g_row\[1\].g_col\[0\].pe__1449_/Y VGND VGND VPWR
+ VPWR g_row\[1\].g_col\[0\].pe__1738_/B1 sky130_fd_sc_hd__buf_6
XTAP_TAPCELL_ROW_43_853 VGND VPWR sky130_fd_sc_hd__tapvpwrvgnd_1
XFILLER_20_508 VGND VGND VPWR VPWR sky130_fd_sc_hd__fill_2
Xg_row\[0\].g_col\[0\].pe_hold1911 g_row\[0\].g_col\[0\].pe__2455_/A VGND VGND VPWR
+ VPWR g_row\[0\].g_col\[0\].pe__1947_/B1 sky130_fd_sc_hd__clkbuf_2
Xg_row\[0\].g_col\[0\].pe_hold1933 g_row\[0\].g_col\[0\].pe__2740_/Q VGND VGND VPWR
+ VPWR g_row\[0\].g_col\[0\].pe_hold1933/X sky130_fd_sc_hd__clkbuf_2
XFILLER_9_575 VGND VGND VPWR VPWR sky130_fd_sc_hd__decap_3
XFILLER_9_586 VGND VGND VPWR VPWR sky130_fd_sc_hd__decap_3
Xg_row\[0\].g_col\[0\].pe_hold1999 g_row\[0\].g_col\[0\].pe__2739_/Q VGND VGND VPWR
+ VPWR g_row\[0\].g_col\[0\].pe__1835_/A2 sky130_fd_sc_hd__clkbuf_2
XFILLER_58_3 VGND VGND VPWR VPWR sky130_fd_sc_hd__fill_1
Xg_row\[1\].g_col\[1\].pe__2710_ clkbuf_leaf_96_clk/X g_row\[1\].g_col\[1\].pe__2710_/D
+ VGND VGND VPWR VPWR g_row\[1\].g_col\[1\].pe__2710_/Q sky130_fd_sc_hd__dfxtp_2
Xg_row\[1\].g_col\[1\].pe__2641_ g_row\[1\].g_col\[1\].pe__2676_/A g_row\[1\].g_col\[1\].pe__2641_/B
+ VGND VGND VPWR VPWR g_row\[1\].g_col\[1\].pe__2641_/X sky130_fd_sc_hd__or2_2
Xg_row\[1\].g_col\[0\].pe__2625_ place1246/X hold1938/X VGND VGND VPWR VPWR g_row\[1\].g_col\[0\].pe__2625_/X
+ sky130_fd_sc_hd__or2_2
Xg_row\[1\].g_col\[1\].pe__2572_ g_row\[1\].g_col\[1\].pe__2572_/A1 g_row\[1\].g_col\[1\].pe__2591_/A2
+ g_row\[1\].g_col\[1\].pe__2591_/B1 g_row\[1\].g_col\[1\].pe__2571_/X VGND VGND VPWR
+ VPWR g_row\[1\].g_col\[1\].pe__2573_/B sky130_fd_sc_hd__a22o_2
Xg_row\[1\].g_col\[1\].pe__1523_ g_row\[1\].g_col\[1\].pe__1523_/A g_row\[1\].g_col\[1\].pe__1523_/B
+ VGND VGND VPWR VPWR g_row\[1\].g_col\[1\].pe__1584_/B sky130_fd_sc_hd__xnor2_2
Xg_row\[1\].g_col\[0\].pe__1507_ g_row\[1\].g_col\[0\].pe__1507_/A g_row\[1\].g_col\[0\].pe__1507_/B
+ VGND VGND VPWR VPWR g_row\[1\].g_col\[0\].pe__1507_/X sky130_fd_sc_hd__and2_2
Xg_row\[0\].g_col\[0\].pe__2703_ clkbuf_leaf_20_clk/X g_row\[0\].g_col\[0\].pe__2703_/D
+ VGND VGND VPWR VPWR hold2340/A sky130_fd_sc_hd__dfxtp_2
Xg_row\[1\].g_col\[0\].pe__2487_ g_row\[1\].g_col\[0\].pe__2487_/A g_row\[1\].g_col\[0\].pe__2487_/B
+ g_row\[1\].g_col\[0\].pe__2490_/A VGND VGND VPWR VPWR g_row\[1\].g_col\[0\].pe__2488_/B
+ sky130_fd_sc_hd__or3_2
XTAP_TAPCELL_ROW_2_239 VGND VPWR sky130_fd_sc_hd__tapvpwrvgnd_1
Xg_row\[1\].g_col\[0\].pe__1438_ g_row\[1\].g_col\[0\].pe__1481_/A g_row\[1\].g_col\[0\].pe__1481_/B
+ VGND VGND VPWR VPWR g_row\[1\].g_col\[0\].pe__1442_/A sky130_fd_sc_hd__xor2_2
Xg_row\[0\].g_col\[1\].pe_hold2219 _327_/Q VGND VGND VPWR VPWR g_row\[0\].g_col\[1\].pe_hold2219/X
+ sky130_fd_sc_hd__clkbuf_2
Xg_row\[0\].g_col\[1\].pe__2650_ g_row\[0\].g_col\[1\].pe__2666_/A1 g_row\[0\].g_col\[1\].pe__2650_/A2
+ g_row\[0\].g_col\[1\].pe__2677_/B1 g_row\[0\].g_col\[1\].pe__2649_/X VGND VGND VPWR
+ VPWR g_row\[0\].g_col\[1\].pe__2650_/X sky130_fd_sc_hd__o211a_2
Xclkbuf_leaf_47_clk clkload6/A VGND VGND VPWR VPWR clkbuf_leaf_47_clk/X sky130_fd_sc_hd__clkbuf_16
Xg_row\[0\].g_col\[0\].pe__2634_ _286_/Q _285_/Q _288_/Q _287_/Q VGND VGND VPWR VPWR
+ g_row\[0\].g_col\[0\].pe__2635_/D sky130_fd_sc_hd__or4_2
Xg_row\[0\].g_col\[1\].pe__1601_ g_row\[0\].g_col\[1\].pe__2693_/Q g_row\[0\].g_col\[1\].pe__1549_/B
+ g_row\[0\].g_col\[1\].pe__2216_/B1 g_row\[0\].g_col\[1\].pe__2605_/B VGND VGND VPWR
+ VPWR g_row\[0\].g_col\[1\].pe__1602_/B sky130_fd_sc_hd__a22o_2
Xg_row\[1\].g_col\[1\].pe__1385_ hold2176/X g_row\[1\].g_col\[1\].pe__1402_/B VGND
+ VGND VPWR VPWR g_row\[1\].g_col\[1\].pe__1385_/X sky130_fd_sc_hd__or2_2
Xg_row\[1\].g_col\[0\].pe__1369_ g_row\[1\].g_col\[0\].pe__2770_/Q VGND VGND VPWR
+ VPWR g_row\[1\].g_col\[0\].pe__2424_/A sky130_fd_sc_hd__inv_2
XFILLER_51_600 VGND VGND VPWR VPWR sky130_fd_sc_hd__fill_2
Xg_row\[0\].g_col\[0\].pe__2565_ g_row\[0\].g_col\[0\].pe__2592_/A g_row\[0\].g_col\[0\].pe__2565_/B
+ VGND VGND VPWR VPWR g_row\[0\].g_col\[0\].pe__2764_/D sky130_fd_sc_hd__and2_2
Xg_row\[0\].g_col\[1\].pe__2581_ g_row\[0\].g_col\[1\].pe__2581_/A1 g_row\[0\].g_col\[1\].pe__2587_/A2
+ g_row\[0\].g_col\[1\].pe__2517_/Y g_row\[0\].g_col\[1\].pe__2580_/X VGND VGND VPWR
+ VPWR g_row\[0\].g_col\[1\].pe__2581_/X sky130_fd_sc_hd__a22o_2
XFILLER_51_633 VGND VGND VPWR VPWR sky130_fd_sc_hd__decap_3
Xg_row\[0\].g_col\[0\].pe__1516_ g_row\[0\].g_col\[0\].pe__1761_/A1 place1195/X place1198/X
+ g_row\[0\].g_col\[0\].pe__1616_/A2 VGND VGND VPWR VPWR g_row\[0\].g_col\[0\].pe__1517_/B
+ sky130_fd_sc_hd__a22o_2
Xg_row\[0\].g_col\[1\].pe__1532_ g_row\[0\].g_col\[1\].pe__1555_/A g_row\[0\].g_col\[1\].pe__1555_/B
+ VGND VGND VPWR VPWR g_row\[0\].g_col\[1\].pe__1533_/B sky130_fd_sc_hd__xor2_2
XFILLER_51_699 VGND VGND VPWR VPWR sky130_fd_sc_hd__fill_1
Xg_row\[0\].g_col\[0\].pe__2496_ g_row\[0\].g_col\[0\].pe__2496_/A g_row\[0\].g_col\[0\].pe__2496_/B
+ VGND VGND VPWR VPWR g_row\[0\].g_col\[0\].pe__2558_/B sky130_fd_sc_hd__nor2_2
Xg_row\[0\].g_col\[1\].pe__1463_ g_row\[0\].g_col\[1\].pe__1957_/B2 g_row\[0\].g_col\[1\].pe__1715_/B
+ g_row\[0\].g_col\[1\].pe__1863_/B1 g_row\[0\].g_col\[1\].pe__2692_/Q VGND VGND VPWR
+ VPWR g_row\[0\].g_col\[1\].pe__1464_/B sky130_fd_sc_hd__a22o_2
Xg_row\[1\].g_col\[1\].pe__2006_ g_row\[1\].g_col\[1\].pe__2006_/A g_row\[1\].g_col\[1\].pe__2009_/B
+ VGND VGND VPWR VPWR g_row\[1\].g_col\[1\].pe__2151_/B sky130_fd_sc_hd__or2b_2
XTAP_TAPCELL_ROW_21_525 VGND VPWR sky130_fd_sc_hd__tapvpwrvgnd_1
Xg_row\[0\].g_col\[0\].pe__1447_ g_row\[0\].g_col\[0\].pe__1460_/B g_row\[0\].g_col\[0\].pe__2729_/Q
+ g_row\[0\].g_col\[0\].pe__2728_/Q VGND VGND VPWR VPWR g_row\[0\].g_col\[0\].pe__1449_/A
+ sky130_fd_sc_hd__nand3b_2
Xg_row\[0\].g_col\[1\].pe__1394_ g_row\[0\].g_col\[1\].pe__1394_/A g_row\[0\].g_col\[1\].pe__1402_/B
+ VGND VGND VPWR VPWR g_row\[0\].g_col\[1\].pe__1394_/X sky130_fd_sc_hd__or2_2
XFILLER_3_729 VGND VGND VPWR VPWR sky130_fd_sc_hd__fill_1
Xg_row\[0\].g_col\[1\].pe__2015_ g_row\[0\].g_col\[1\].pe__2002_/A g_row\[0\].g_col\[1\].pe__2002_/B
+ g_row\[0\].g_col\[1\].pe__2014_/X VGND VGND VPWR VPWR g_row\[0\].g_col\[1\].pe__2059_/A
+ sky130_fd_sc_hd__a21o_2
XTAP_TAPCELL_ROW_53_1007 VGND VPWR sky130_fd_sc_hd__tapvpwrvgnd_1
XFILLER_27_630 VGND VGND VPWR VPWR sky130_fd_sc_hd__decap_3
XTAP_TAPCELL_ROW_29_647 VGND VPWR sky130_fd_sc_hd__tapvpwrvgnd_1
Xclkbuf_leaf_38_clk clkbuf_4_6_0_clk/X VGND VGND VPWR VPWR clkbuf_leaf_38_clk/X sky130_fd_sc_hd__clkbuf_16
XFILLER_27_685 VGND VGND VPWR VPWR sky130_fd_sc_hd__decap_3
XFILLER_82_780 VGND VGND VPWR VPWR sky130_fd_sc_hd__fill_1
XFILLER_26_184 VGND VGND VPWR VPWR sky130_fd_sc_hd__fill_1
XFILLER_42_699 VGND VGND VPWR VPWR sky130_fd_sc_hd__fill_1
XTAP_TAPCELL_ROW_40_812 VGND VPWR sky130_fd_sc_hd__tapvpwrvgnd_1
XTAP_TAPCELL_ROW_64_1169 VGND VPWR sky130_fd_sc_hd__tapvpwrvgnd_1
X_332_ _332_/CLK _332_/D VGND VGND VPWR VPWR _332_/Q sky130_fd_sc_hd__dfxtp_2
X_263_ _269_/A _263_/B_N VGND VGND VPWR VPWR _263_/Y sky130_fd_sc_hd__nor2b_4
XFILLER_41_40 VGND VGND VPWR VPWR sky130_fd_sc_hd__fill_1
XFILLER_41_84 VGND VGND VPWR VPWR sky130_fd_sc_hd__fill_1
XFILLER_6_567 VGND VGND VPWR VPWR sky130_fd_sc_hd__decap_3
XFILLER_6_589 VGND VGND VPWR VPWR sky130_fd_sc_hd__decap_3
XTAP_TAPCELL_ROW_79_1390 VGND VPWR sky130_fd_sc_hd__tapvpwrvgnd_1
XTAP_TAPCELL_ROW_9_350 VGND VPWR sky130_fd_sc_hd__tapvpwrvgnd_1
XTAP_TAPCELL_ROW_92_1590 VGND VPWR sky130_fd_sc_hd__tapvpwrvgnd_1
Xg_row\[1\].g_col\[0\].pe__2410_ g_row\[1\].g_col\[0\].pe__2775_/A g_row\[1\].g_col\[0\].pe__2410_/B
+ VGND VGND VPWR VPWR g_row\[1\].g_col\[0\].pe__2499_/A sky130_fd_sc_hd__and2_2
XFILLER_77_574 VGND VGND VPWR VPWR sky130_fd_sc_hd__fill_1
Xg_row\[1\].g_col\[0\].pe__2341_ g_row\[1\].g_col\[0\].pe__2388_/A g_row\[1\].g_col\[0\].pe__2341_/B
+ VGND VGND VPWR VPWR g_row\[1\].g_col\[0\].pe__2341_/Y sky130_fd_sc_hd__nand2_2
XTAP_TAPCELL_ROW_48_923 VGND VPWR sky130_fd_sc_hd__tapvpwrvgnd_1
XTAP_TAPCELL_ROW_48_934 VGND VPWR sky130_fd_sc_hd__tapvpwrvgnd_1
Xg_row\[1\].g_col\[0\].pe__2272_ g_row\[1\].g_col\[0\].pe__2257_/A g_row\[1\].g_col\[0\].pe__2272_/B
+ VGND VGND VPWR VPWR g_row\[1\].g_col\[0\].pe__2295_/B sky130_fd_sc_hd__and2b_2
Xclkbuf_leaf_29_clk clkload3/A VGND VGND VPWR VPWR _318_/CLK sky130_fd_sc_hd__clkbuf_16
XFILLER_60_441 VGND VGND VPWR VPWR sky130_fd_sc_hd__fill_1
Xg_row\[0\].g_col\[0\].pe__2350_ g_row\[0\].g_col\[0\].pe__2350_/A g_row\[0\].g_col\[0\].pe__2350_/B
+ VGND VGND VPWR VPWR g_row\[0\].g_col\[0\].pe__2352_/C sky130_fd_sc_hd__xnor2_2
XANTENNA_17 b_inputs_flat[16] VGND VGND VPWR VPWR sky130_fd_sc_hd__diode_2
XANTENNA_28 b_inputs_flat[8] VGND VGND VPWR VPWR sky130_fd_sc_hd__diode_2
XANTENNA_39 _274_/Q VGND VGND VPWR VPWR sky130_fd_sc_hd__diode_2
Xg_row\[0\].g_col\[0\].pe__2281_ g_row\[0\].g_col\[0\].pe__2311_/A g_row\[0\].g_col\[0\].pe__2311_/B
+ VGND VGND VPWR VPWR g_row\[0\].g_col\[0\].pe__2283_/B sky130_fd_sc_hd__xor2_2
Xg_row\[1\].g_col\[0\].pe__1987_ g_row\[1\].g_col\[0\].pe__1988_/B g_row\[1\].g_col\[0\].pe__1988_/C
+ g_row\[1\].g_col\[0\].pe__2043_/A VGND VGND VPWR VPWR g_row\[1\].g_col\[0\].pe__1987_/Y
+ sky130_fd_sc_hd__a21boi_2
XTAP_TAPCELL_ROW_7_309 VGND VPWR sky130_fd_sc_hd__tapvpwrvgnd_1
Xg_row\[1\].g_col\[1\].pe__2624_ g_row\[1\].g_col\[1\].pe__2626_/A1 place1085/X g_row\[1\].g_col\[1\].pe__2626_/B1
+ g_row\[1\].g_col\[1\].pe__2624_/C1 VGND VGND VPWR VPWR g_row\[1\].g_col\[1\].pe__2624_/X
+ sky130_fd_sc_hd__o211a_2
Xg_row\[1\].g_col\[0\].pe__2608_ g_row\[1\].g_col\[0\].pe__2640_/A1 g_row\[1\].g_col\[0\].pe__2608_/A2
+ g_row\[1\].g_col\[0\].pe__2640_/C1 g_row\[1\].g_col\[0\].pe__2607_/X VGND VGND VPWR
+ VPWR g_row\[1\].g_col\[0\].pe__2608_/X sky130_fd_sc_hd__o211a_2
XFILLER_68_552 VGND VGND VPWR VPWR sky130_fd_sc_hd__fill_1
XFILLER_68_574 VGND VGND VPWR VPWR sky130_fd_sc_hd__decap_3
Xg_row\[0\].g_col\[0\].pe__1996_ g_row\[0\].g_col\[0\].pe__2055_/A g_row\[0\].g_col\[0\].pe__2055_/B
+ VGND VGND VPWR VPWR g_row\[0\].g_col\[0\].pe__1997_/B sky130_fd_sc_hd__xor2_2
Xg_row\[1\].g_col\[1\].pe__2555_ g_row\[1\].g_col\[1\].pe__2569_/A g_row\[1\].g_col\[1\].pe__2555_/B
+ VGND VGND VPWR VPWR g_row\[1\].g_col\[1\].pe__2762_/D sky130_fd_sc_hd__and2_2
Xg_row\[1\].g_col\[0\].pe__2539_ g_row\[1\].g_col\[0\].pe__2538_/B g_row\[1\].g_col\[0\].pe__2538_/C
+ g_row\[1\].g_col\[0\].pe__2538_/A VGND VGND VPWR VPWR g_row\[1\].g_col\[0\].pe__2539_/X
+ sky130_fd_sc_hd__a21o_2
XFILLER_46_29 VGND VGND VPWR VPWR sky130_fd_sc_hd__fill_2
Xg_row\[1\].g_col\[1\].pe__2486_ g_row\[1\].g_col\[1\].pe__2509_/S g_row\[1\].g_col\[1\].pe__2486_/B
+ VGND VGND VPWR VPWR g_row\[1\].g_col\[1\].pe__2516_/B sky130_fd_sc_hd__or2_2
Xg_row\[1\].g_col\[1\].pe__1506_ g_row\[1\].g_col\[1\].pe__1657_/A g_row\[1\].g_col\[1\].pe__1549_/B
+ VGND VGND VPWR VPWR g_row\[1\].g_col\[1\].pe__1535_/B sky130_fd_sc_hd__nand2_2
Xg_row\[0\].g_col\[1\].pe__2702_ _336_/CLK g_row\[0\].g_col\[1\].pe__2702_/D VGND
+ VGND VPWR VPWR g_row\[0\].g_col\[1\].pe__2702_/Q sky130_fd_sc_hd__dfxtp_2
XFILLER_83_555 VGND VGND VPWR VPWR sky130_fd_sc_hd__decap_3
Xg_row\[1\].g_col\[1\].pe__1437_ g_row\[1\].g_col\[1\].pe__1730_/A g_row\[1\].g_col\[1\].pe__1437_/B
+ VGND VGND VPWR VPWR g_row\[1\].g_col\[1\].pe__1481_/B sky130_fd_sc_hd__xor2_2
Xg_row\[0\].g_col\[1\].pe_hold2038 g_row\[0\].g_col\[1\].pe__2535_/X VGND VGND VPWR
+ VPWR g_row\[0\].g_col\[1\].pe__2536_/B sky130_fd_sc_hd__clkbuf_2
XTAP_TAPCELL_ROW_26_606 VGND VPWR sky130_fd_sc_hd__tapvpwrvgnd_1
Xg_row\[0\].g_col\[0\].pe__2617_ g_row\[0\].g_col\[0\].pe__2628_/A1 g_row\[0\].g_col\[0\].pe__2617_/A2
+ g_row\[0\].g_col\[0\].pe__2628_/B1 g_row\[0\].g_col\[0\].pe__2616_/X VGND VGND VPWR
+ VPWR g_row\[0\].g_col\[0\].pe__2617_/X sky130_fd_sc_hd__o211a_2
Xg_row\[0\].g_col\[1\].pe__2633_ g_row\[0\].g_col\[1\].pe__2633_/A1 g_row\[0\].g_col\[1\].pe__2633_/A2
+ g_row\[0\].g_col\[1\].pe__2381_/A g_row\[0\].g_col\[1\].pe__2632_/X VGND VGND VPWR
+ VPWR g_row\[0\].g_col\[1\].pe__2633_/X sky130_fd_sc_hd__o211a_2
XFILLER_24_633 VGND VGND VPWR VPWR sky130_fd_sc_hd__decap_3
Xg_row\[1\].g_col\[1\].pe__1368_ g_row\[1\].g_col\[1\].pe__2769_/Q g_row\[1\].g_col\[1\].pe__1368_/B
+ VGND VGND VPWR VPWR output1412/A sky130_fd_sc_hd__xnor2_2
Xg_row\[0\].g_col\[1\].pe__2564_ g_row\[0\].g_col\[1\].pe__2564_/A1 g_row\[0\].g_col\[1\].pe__2587_/A2
+ g_row\[0\].g_col\[1\].pe__2517_/Y g_row\[0\].g_col\[1\].pe__2563_/X VGND VGND VPWR
+ VPWR g_row\[0\].g_col\[1\].pe__2564_/X sky130_fd_sc_hd__a22o_2
Xg_row\[0\].g_col\[0\].pe__2548_ g_row\[0\].g_col\[0\].pe__2548_/A1 g_row\[0\].g_col\[0\].pe__2554_/A2
+ g_row\[0\].g_col\[0\].pe__2517_/Y g_row\[0\].g_col\[0\].pe__2547_/X VGND VGND VPWR
+ VPWR g_row\[0\].g_col\[0\].pe__2548_/X sky130_fd_sc_hd__a22o_2
Xg_row\[0\].g_col\[1\].pe__1515_ g_row\[0\].g_col\[1\].pe__1490_/A g_row\[0\].g_col\[1\].pe__1490_/B
+ g_row\[0\].g_col\[1\].pe__1514_/X VGND VGND VPWR VPWR g_row\[0\].g_col\[1\].pe__1584_/A
+ sky130_fd_sc_hd__a21oi_2
Xg_row\[0\].g_col\[0\].pe__2479_ g_row\[0\].g_col\[0\].pe__2579_/B g_row\[0\].g_col\[0\].pe__2579_/C
+ g_row\[0\].g_col\[0\].pe__2579_/A VGND VGND VPWR VPWR g_row\[0\].g_col\[0\].pe__2479_/X
+ sky130_fd_sc_hd__a21o_2
Xg_row\[0\].g_col\[1\].pe__2495_ g_row\[0\].g_col\[1\].pe__2495_/A VGND VGND VPWR
+ VPWR g_row\[0\].g_col\[1\].pe__2496_/A sky130_fd_sc_hd__inv_2
XFILLER_7_309 VGND VGND VPWR VPWR sky130_fd_sc_hd__decap_3
Xg_row\[0\].g_col\[1\].pe__1377_ _171_/A VGND VGND VPWR VPWR g_row\[0\].g_col\[1\].pe__1836_/A
+ sky130_fd_sc_hd__inv_2
XFILLER_87_25 VGND VGND VPWR VPWR sky130_fd_sc_hd__fill_1
XFILLER_78_349 VGND VGND VPWR VPWR sky130_fd_sc_hd__fill_2
XFILLER_74_533 VGND VGND VPWR VPWR sky130_fd_sc_hd__decap_3
XFILLER_74_555 VGND VGND VPWR VPWR sky130_fd_sc_hd__fill_1
XFILLER_27_471 VGND VGND VPWR VPWR sky130_fd_sc_hd__decap_3
XFILLER_46_268 VGND VGND VPWR VPWR sky130_fd_sc_hd__fill_2
XFILLER_62_717 VGND VGND VPWR VPWR sky130_fd_sc_hd__fill_2
XFILLER_62_739 VGND VGND VPWR VPWR sky130_fd_sc_hd__fill_2
XFILLER_15_633 VGND VGND VPWR VPWR sky130_fd_sc_hd__decap_3
XFILLER_27_493 VGND VGND VPWR VPWR sky130_fd_sc_hd__fill_2
XFILLER_14_176 VGND VGND VPWR VPWR sky130_fd_sc_hd__fill_1
X_315_ _318_/CLK _315_/D VGND VGND VPWR VPWR _315_/Q sky130_fd_sc_hd__dfxtp_2
XFILLER_30_658 VGND VGND VPWR VPWR sky130_fd_sc_hd__decap_3
Xg_row\[1\].g_col\[0\].pe__1910_ g_row\[1\].g_col\[0\].pe__1910_/A g_row\[1\].g_col\[0\].pe__1910_/B
+ VGND VGND VPWR VPWR g_row\[1\].g_col\[0\].pe__1955_/A sky130_fd_sc_hd__xor2_2
XTAP_TAPCELL_ROW_12_388 VGND VPWR sky130_fd_sc_hd__tapvpwrvgnd_1
X_177_ _189_/A _177_/B_N VGND VGND VPWR VPWR _177_/Y sky130_fd_sc_hd__nor2b_4
Xg_row\[1\].g_col\[0\].pe__1841_ g_row\[1\].g_col\[0\].pe__1841_/A VGND VGND VPWR
+ VPWR g_row\[1\].g_col\[0\].pe__1843_/A sky130_fd_sc_hd__inv_2
Xg_row\[1\].g_col\[0\].pe__1772_ g_row\[1\].g_col\[0\].pe__1780_/A g_row\[1\].g_col\[0\].pe__1794_/A
+ VGND VGND VPWR VPWR g_row\[1\].g_col\[0\].pe__1813_/A sky130_fd_sc_hd__and2_2
XFILLER_69_349 VGND VGND VPWR VPWR sky130_fd_sc_hd__fill_2
XFILLER_38_714 VGND VGND VPWR VPWR sky130_fd_sc_hd__fill_1
Xg_row\[0\].g_col\[0\].pe__1850_ g_row\[0\].g_col\[0\].pe__1850_/A g_row\[0\].g_col\[0\].pe__1850_/B
+ VGND VGND VPWR VPWR g_row\[0\].g_col\[0\].pe__1886_/A sky130_fd_sc_hd__nor2_2
XFILLER_37_202 VGND VGND VPWR VPWR sky130_fd_sc_hd__fill_1
XFILLER_65_511 VGND VGND VPWR VPWR sky130_fd_sc_hd__decap_3
XFILLER_77_393 VGND VGND VPWR VPWR sky130_fd_sc_hd__fill_1
Xg_row\[0\].g_col\[0\].pe__1781_ g_row\[0\].g_col\[0\].pe__1781_/A g_row\[0\].g_col\[0\].pe__1781_/B
+ VGND VGND VPWR VPWR g_row\[0\].g_col\[0\].pe__1791_/A sky130_fd_sc_hd__xnor2_2
Xg_row\[1\].g_col\[1\].pe__2340_ g_row\[1\].g_col\[1\].pe__2121_/A g_row\[1\].g_col\[1\].pe__2363_/A2
+ g_row\[1\].g_col\[1\].pe__2388_/B g_row\[1\].g_col\[1\].pe__2340_/B2 VGND VGND VPWR
+ VPWR g_row\[1\].g_col\[1\].pe__2343_/A sky130_fd_sc_hd__a22o_2
Xg_row\[1\].g_col\[0\].pe__2324_ g_row\[1\].g_col\[0\].pe__2285_/A g_row\[1\].g_col\[0\].pe__2285_/B
+ g_row\[1\].g_col\[0\].pe__2284_/B VGND VGND VPWR VPWR g_row\[1\].g_col\[0\].pe__2338_/A
+ sky130_fd_sc_hd__a21oi_2
XFILLER_65_544 VGND VGND VPWR VPWR sky130_fd_sc_hd__fill_1
Xg_row\[1\].g_col\[1\].pe__2271_ g_row\[1\].g_col\[1\].pe__2271_/A g_row\[1\].g_col\[1\].pe__2271_/B
+ VGND VGND VPWR VPWR g_row\[1\].g_col\[1\].pe__2295_/A sky130_fd_sc_hd__nor2_2
XFILLER_37_279 VGND VGND VPWR VPWR sky130_fd_sc_hd__fill_1
Xg_row\[1\].g_col\[0\].pe__2255_ g_row\[1\].g_col\[0\].pe__2271_/A g_row\[1\].g_col\[0\].pe__2271_/B
+ VGND VGND VPWR VPWR g_row\[1\].g_col\[0\].pe__2257_/A sky130_fd_sc_hd__xnor2_2
XFILLER_18_482 VGND VGND VPWR VPWR sky130_fd_sc_hd__decap_3
XFILLER_52_227 VGND VGND VPWR VPWR sky130_fd_sc_hd__decap_3
Xg_row\[0\].g_col\[0\].pe__2402_ place1269/X g_row\[0\].g_col\[0\].pe__2402_/B VGND
+ VGND VPWR VPWR g_row\[0\].g_col\[0\].pe__2402_/Y sky130_fd_sc_hd__nor2_2
Xg_row\[1\].g_col\[0\].pe__2186_ g_row\[1\].g_col\[0\].pe__2203_/B g_row\[1\].g_col\[0\].pe__2186_/B
+ VGND VGND VPWR VPWR g_row\[1\].g_col\[0\].pe__2190_/A sky130_fd_sc_hd__xor2_2
XFILLER_33_463 VGND VGND VPWR VPWR sky130_fd_sc_hd__decap_3
Xg_row\[1\].g_col\[0\].pe_place1059 g_row\[1\].g_col\[0\].pe__2771_/Q VGND VGND VPWR
+ VPWR g_row\[1\].g_col\[0\].pe__2776_/A sky130_fd_sc_hd__buf_6
Xg_row\[0\].g_col\[0\].pe__2333_ g_row\[0\].g_col\[0\].pe__2330_/X g_row\[0\].g_col\[0\].pe__2329_/B
+ g_row\[0\].g_col\[0\].pe__2358_/A g_row\[0\].g_col\[0\].pe__2157_/A VGND VGND VPWR
+ VPWR g_row\[0\].g_col\[0\].pe__2333_/Y sky130_fd_sc_hd__o211ai_2
Xg_row\[0\].g_col\[0\].pe_hold2250 g_row\[0\].g_col\[0\].pe__2687_/X VGND VGND VPWR
+ VPWR g_row\[0\].g_col\[0\].pe__2726_/D sky130_fd_sc_hd__clkbuf_2
XFILLER_21_669 VGND VGND VPWR VPWR sky130_fd_sc_hd__decap_3
Xg_row\[0\].g_col\[0\].pe__2264_ g_row\[0\].g_col\[0\].pe__2238_/X g_row\[0\].g_col\[0\].pe__2234_/Y
+ g_row\[0\].g_col\[0\].pe__2263_/X g_row\[0\].g_col\[0\].pe__2157_/A VGND VGND VPWR
+ VPWR g_row\[0\].g_col\[0\].pe__2264_/X sky130_fd_sc_hd__o31a_2
Xg_row\[0\].g_col\[0\].pe_hold2272 g_row\[0\].g_col\[0\].pe__2681_/A1 VGND VGND VPWR
+ VPWR g_row\[0\].g_col\[0\].pe__2642_/A2 sky130_fd_sc_hd__clkbuf_2
Xg_row\[0\].g_col\[0\].pe_hold2283 g_row\[0\].g_col\[0\].pe__2600_/X VGND VGND VPWR
+ VPWR g_row\[0\].g_col\[0\].pe__2690_/D sky130_fd_sc_hd__clkbuf_2
Xg_row\[0\].g_col\[0\].pe_hold2294 g_row\[0\].g_col\[0\].pe__2638_/X VGND VGND VPWR
+ VPWR g_row\[0\].g_col\[0\].pe__2640_/A2 sky130_fd_sc_hd__clkbuf_2
Xg_row\[0\].g_col\[1\].pe_place853 g_row\[0\].g_col\[1\].pe__1727_/B2 VGND VGND VPWR
+ VPWR g_row\[0\].g_col\[1\].pe__1804_/B sky130_fd_sc_hd__buf_6
Xg_row\[0\].g_col\[1\].pe__2280_ g_row\[0\].g_col\[1\].pe__2364_/A g_row\[0\].g_col\[1\].pe__2280_/B
+ VGND VGND VPWR VPWR g_row\[0\].g_col\[1\].pe__2311_/B sky130_fd_sc_hd__xnor2_2
XTAP_TAPCELL_ROW_31_675 VGND VPWR sky130_fd_sc_hd__tapvpwrvgnd_1
Xclkbuf_leaf_9_clk clkload0/A VGND VGND VPWR VPWR _336_/CLK sky130_fd_sc_hd__clkbuf_16
Xg_row\[0\].g_col\[0\].pe__2195_ g_row\[0\].g_col\[0\].pe__2231_/A g_row\[0\].g_col\[0\].pe__2231_/B
+ VGND VGND VPWR VPWR g_row\[0\].g_col\[0\].pe__2200_/B sky130_fd_sc_hd__xnor2_2
Xg_row\[1\].g_col\[1\].pe__1986_ g_row\[1\].g_col\[1\].pe__1985_/B g_row\[1\].g_col\[1\].pe__1985_/C
+ g_row\[1\].g_col\[1\].pe__2094_/A VGND VGND VPWR VPWR g_row\[1\].g_col\[1\].pe__1988_/C
+ sky130_fd_sc_hd__a21bo_2
Xhold3402 hold3402/A VGND VGND VPWR VPWR hold3402/X sky130_fd_sc_hd__clkbuf_2
Xhold3424 a_inputs_flat[16] VGND VGND VPWR VPWR hold3424/X sky130_fd_sc_hd__clkbuf_2
Xhold3413 hold3413/A VGND VGND VPWR VPWR hold3413/X sky130_fd_sc_hd__clkbuf_2
Xhold2701 hold2701/A VGND VGND VPWR VPWR _294_/D sky130_fd_sc_hd__clkbuf_2
Xhold2712 _153_/Y VGND VGND VPWR VPWR hold2712/X sky130_fd_sc_hd__clkbuf_2
Xhold2723 hold3521/X VGND VGND VPWR VPWR _183_/B_N sky130_fd_sc_hd__clkbuf_2
Xoutput1385 output1385/A VGND VGND VPWR VPWR results_flat[37] sky130_fd_sc_hd__buf_2
Xoutput1374 output1374/A VGND VGND VPWR VPWR results_flat[27] sky130_fd_sc_hd__buf_2
Xoutput1363 output1363/A VGND VGND VPWR VPWR results_flat[17] sky130_fd_sc_hd__buf_2
Xhold3457 hold3457/A VGND VGND VPWR VPWR hold3457/X sky130_fd_sc_hd__clkbuf_2
Xhold3446 hold3446/A VGND VGND VPWR VPWR hold3446/X sky130_fd_sc_hd__clkbuf_2
Xhold3435 hold3435/A VGND VGND VPWR VPWR hold3435/X sky130_fd_sc_hd__clkbuf_2
XFILLER_75_319 VGND VGND VPWR VPWR sky130_fd_sc_hd__decap_3
Xhold2734 hold3498/X VGND VGND VPWR VPWR hold3499/A sky130_fd_sc_hd__clkbuf_2
Xhold2745 hold3524/X VGND VGND VPWR VPWR hold3525/A sky130_fd_sc_hd__clkbuf_2
Xhold2756 hold3547/X VGND VGND VPWR VPWR hold3548/A sky130_fd_sc_hd__clkbuf_2
Xoutput1396 output1396/A VGND VGND VPWR VPWR results_flat[47] sky130_fd_sc_hd__buf_2
Xhold3479 hold3479/A VGND VGND VPWR VPWR hold3479/X sky130_fd_sc_hd__clkbuf_2
Xhold3468 hold3468/A VGND VGND VPWR VPWR hold3468/X sky130_fd_sc_hd__clkbuf_2
Xg_row\[1\].g_col\[1\].pe__2607_ place1247/X g_row\[1\].g_col\[1\].pe__2607_/B VGND
+ VGND VPWR VPWR g_row\[1\].g_col\[1\].pe__2607_/X sky130_fd_sc_hd__or2_2
XFILLER_56_511 VGND VGND VPWR VPWR sky130_fd_sc_hd__decap_3
Xhold2767 hold2767/A VGND VGND VPWR VPWR _288_/D sky130_fd_sc_hd__clkbuf_2
Xhold2778 _143_/Y VGND VGND VPWR VPWR hold2778/X sky130_fd_sc_hd__clkbuf_2
Xhold2789 hold2789/A VGND VGND VPWR VPWR _141_/B_N sky130_fd_sc_hd__clkbuf_2
Xg_row\[1\].g_col\[1\].pe__2538_ g_row\[1\].g_col\[1\].pe__2538_/A g_row\[1\].g_col\[1\].pe__2538_/B
+ g_row\[1\].g_col\[1\].pe__2538_/C VGND VGND VPWR VPWR g_row\[1\].g_col\[1\].pe__2544_/B
+ sky130_fd_sc_hd__nand3_2
Xg_row\[0\].g_col\[1\].pe__1995_ g_row\[0\].g_col\[1\].pe__1931_/A g_row\[0\].g_col\[1\].pe__1931_/B
+ g_row\[0\].g_col\[1\].pe__1994_/Y VGND VGND VPWR VPWR g_row\[0\].g_col\[1\].pe__2055_/B
+ sky130_fd_sc_hd__a21oi_2
XFILLER_29_769 VGND VGND VPWR VPWR sky130_fd_sc_hd__fill_1
XFILLER_44_706 VGND VGND VPWR VPWR sky130_fd_sc_hd__fill_1
XFILLER_56_533 VGND VGND VPWR VPWR sky130_fd_sc_hd__decap_3
XFILLER_56_566 VGND VGND VPWR VPWR sky130_fd_sc_hd__decap_3
Xg_row\[0\].g_col\[0\].pe__1979_ g_row\[0\].g_col\[0\].pe__1978_/A g_row\[0\].g_col\[0\].pe__1978_/B
+ g_row\[0\].g_col\[0\].pe__1978_/C VGND VGND VPWR VPWR g_row\[0\].g_col\[0\].pe__1991_/B
+ sky130_fd_sc_hd__o21ai_2
XFILLER_73_38 VGND VGND VPWR VPWR sky130_fd_sc_hd__fill_1
Xg_row\[1\].g_col\[1\].pe__2469_ g_row\[1\].g_col\[1\].pe__2439_/Y g_row\[1\].g_col\[1\].pe__2763_/Q
+ VGND VGND VPWR VPWR g_row\[1\].g_col\[1\].pe__2496_/B sky130_fd_sc_hd__and2b_2
XTAP_TAPCELL_ROW_39_797 VGND VPWR sky130_fd_sc_hd__tapvpwrvgnd_1
Xg_row\[0\].g_col\[1\].pe__2616_ place1249/X g_row\[0\].g_col\[1\].pe__2616_/B VGND
+ VGND VPWR VPWR g_row\[0\].g_col\[1\].pe__2616_/X sky130_fd_sc_hd__or2_2
XFILLER_11_113 VGND VGND VPWR VPWR sky130_fd_sc_hd__decap_3
XTAP_TAPCELL_ROW_61_1128 VGND VPWR sky130_fd_sc_hd__tapvpwrvgnd_1
Xg_row\[0\].g_col\[1\].pe__2547_ g_row\[0\].g_col\[1\].pe__2559_/A g_row\[0\].g_col\[1\].pe__2547_/B
+ g_row\[0\].g_col\[1\].pe__2546_/Y VGND VGND VPWR VPWR g_row\[0\].g_col\[1\].pe__2547_/X
+ sky130_fd_sc_hd__or3b_2
XFILLER_8_629 VGND VGND VPWR VPWR sky130_fd_sc_hd__fill_2
XTAP_TAPCELL_ROW_50_962 VGND VPWR sky130_fd_sc_hd__tapvpwrvgnd_1
Xg_row\[0\].g_col\[1\].pe__2478_ g_row\[0\].g_col\[1\].pe__2478_/A g_row\[0\].g_col\[1\].pe__2478_/B
+ VGND VGND VPWR VPWR g_row\[0\].g_col\[1\].pe__2579_/A sky130_fd_sc_hd__xnor2_2
Xg_row\[0\].g_col\[1\].pe__1429_ g_row\[0\].g_col\[1\].pe__1650_/A g_row\[0\].g_col\[1\].pe__1650_/B
+ g_row\[0\].g_col\[1\].pe__1428_/X VGND VGND VPWR VPWR g_row\[0\].g_col\[1\].pe__1479_/A
+ sky130_fd_sc_hd__a21oi_2
XFILLER_3_389 VGND VGND VPWR VPWR sky130_fd_sc_hd__decap_3
XFILLER_47_577 VGND VGND VPWR VPWR sky130_fd_sc_hd__decap_3
XFILLER_34_249 VGND VGND VPWR VPWR sky130_fd_sc_hd__decap_3
XFILLER_62_536 VGND VGND VPWR VPWR sky130_fd_sc_hd__fill_2
XFILLER_62_558 VGND VGND VPWR VPWR sky130_fd_sc_hd__decap_3
Xg_row\[1\].g_col\[0\].pe__2040_ g_row\[1\].g_col\[0\].pe__2726_/Q g_row\[1\].g_col\[0\].pe__2727_/Q
+ g_row\[1\].g_col\[0\].pe__2163_/A VGND VGND VPWR VPWR g_row\[1\].g_col\[0\].pe__2040_/X
+ sky130_fd_sc_hd__or3b_4
Xg_row\[0\].g_col\[1\].pe_hold2380 g_row\[0\].g_col\[1\].pe__2750_/Q VGND VGND VPWR
+ VPWR g_row\[0\].g_col\[1\].pe__2308_/A sky130_fd_sc_hd__clkbuf_2
XFILLER_15_463 VGND VGND VPWR VPWR sky130_fd_sc_hd__fill_1
XTAP_TAPCELL_ROW_17_458 VGND VPWR sky130_fd_sc_hd__tapvpwrvgnd_1
XTAP_TAPCELL_ROW_17_469 VGND VPWR sky130_fd_sc_hd__tapvpwrvgnd_1
Xg_row\[0\].g_col\[1\].pe_hold2391 g_row\[0\].g_col\[1\].pe__2751_/Q VGND VGND VPWR
+ VPWR g_row\[0\].g_col\[1\].pe__2336_/A sky130_fd_sc_hd__clkbuf_2
XFILLER_43_783 VGND VGND VPWR VPWR sky130_fd_sc_hd__fill_1
XFILLER_30_444 VGND VGND VPWR VPWR sky130_fd_sc_hd__decap_3
XFILLER_8_33 VGND VGND VPWR VPWR sky130_fd_sc_hd__fill_2
XPHY_EDGE_ROW_7_Left_101 VGND VGND VPWR VPWR sky130_fd_sc_hd__decap_3
XFILLER_30_477 VGND VGND VPWR VPWR sky130_fd_sc_hd__fill_2
XFILLER_7_640 VGND VGND VPWR VPWR sky130_fd_sc_hd__decap_3
X_229_ _237_/A _229_/B_N VGND VGND VPWR VPWR _229_/Y sky130_fd_sc_hd__nor2b_4
XFILLER_7_673 VGND VGND VPWR VPWR sky130_fd_sc_hd__fill_1
Xg_row\[1\].g_col\[1\].pe__1840_ g_row\[1\].g_col\[1\].pe__1840_/A g_row\[1\].g_col\[1\].pe__1840_/B
+ VGND VGND VPWR VPWR g_row\[1\].g_col\[1\].pe__1841_/A sky130_fd_sc_hd__nor2_2
Xg_row\[1\].g_col\[0\].pe__1824_ g_row\[1\].g_col\[0\].pe__1726_/B g_row\[1\].g_col\[0\].pe__1824_/B
+ VGND VGND VPWR VPWR g_row\[1\].g_col\[0\].pe__1824_/X sky130_fd_sc_hd__and2b_2
XFILLER_40_3 VGND VGND VPWR VPWR sky130_fd_sc_hd__fill_1
Xg_row\[1\].g_col\[1\].pe__1771_ g_row\[1\].g_col\[1\].pe__1793_/B g_row\[1\].g_col\[1\].pe__1793_/C
+ g_row\[1\].g_col\[1\].pe__1793_/A VGND VGND VPWR VPWR g_row\[1\].g_col\[1\].pe__1794_/A
+ sky130_fd_sc_hd__a21oi_2
Xg_row\[1\].g_col\[0\].pe__1755_ g_row\[1\].g_col\[0\].pe__1789_/A g_row\[1\].g_col\[0\].pe__1755_/B
+ VGND VGND VPWR VPWR g_row\[1\].g_col\[0\].pe__1770_/B sky130_fd_sc_hd__xor2_2
Xg_row\[1\].g_col\[0\].pe__1686_ g_row\[1\].g_col\[0\].pe__1686_/A g_row\[1\].g_col\[0\].pe__1686_/B
+ VGND VGND VPWR VPWR g_row\[1\].g_col\[0\].pe__1686_/X sky130_fd_sc_hd__and2_2
Xg_row\[0\].g_col\[0\].pe__1902_ place1212/A g_row\[0\].g_col\[0\].pe__1504_/Y g_row\[0\].g_col\[0\].pe__1541_/X
+ place1214/X VGND VGND VPWR VPWR g_row\[0\].g_col\[0\].pe__1903_/B sky130_fd_sc_hd__a22o_2
Xhold2019 hold3008/X VGND VGND VPWR VPWR hold2019/X sky130_fd_sc_hd__clkbuf_2
Xg_row\[0\].g_col\[0\].pe__1833_ g_row\[0\].g_col\[0\].pe__1702_/X g_row\[0\].g_col\[0\].pe__1829_/Y
+ g_row\[0\].g_col\[0\].pe__1832_/Y VGND VGND VPWR VPWR g_row\[0\].g_col\[0\].pe__1834_/B
+ sky130_fd_sc_hd__a21oi_2
Xg_row\[1\].g_col\[0\].pe_hold2965 _296_/Q VGND VGND VPWR VPWR g_row\[1\].g_col\[0\].pe_hold2965/X
+ sky130_fd_sc_hd__clkbuf_2
XFILLER_38_533 VGND VGND VPWR VPWR sky130_fd_sc_hd__fill_2
Xg_row\[1\].g_col\[1\].pe__2323_ g_row\[1\].g_col\[1\].pe__2337_/A g_row\[1\].g_col\[1\].pe__2323_/B
+ VGND VGND VPWR VPWR g_row\[1\].g_col\[1\].pe__2325_/A sky130_fd_sc_hd__xnor2_2
Xg_row\[0\].g_col\[1\].pe__1780_ g_row\[0\].g_col\[1\].pe__1780_/A g_row\[0\].g_col\[1\].pe__1794_/A
+ VGND VGND VPWR VPWR g_row\[0\].g_col\[1\].pe__1780_/Y sky130_fd_sc_hd__nor2_2
Xg_row\[0\].g_col\[0\].pe__1764_ g_row\[0\].g_col\[0\].pe__1785_/A g_row\[0\].g_col\[0\].pe__1764_/B
+ VGND VGND VPWR VPWR g_row\[0\].g_col\[0\].pe__1766_/B sky130_fd_sc_hd__xor2_2
Xg_row\[1\].g_col\[0\].pe__2307_ place1268/X g_row\[1\].g_col\[0\].pe__2307_/B VGND
+ VGND VPWR VPWR g_row\[1\].g_col\[0\].pe__2749_/D sky130_fd_sc_hd__nor2_2
XTAP_TAPCELL_ROW_36_745 VGND VPWR sky130_fd_sc_hd__tapvpwrvgnd_1
Xg_row\[0\].g_col\[0\].pe__1695_ g_row\[0\].g_col\[0\].pe__1695_/A g_row\[0\].g_col\[0\].pe__1695_/B
+ VGND VGND VPWR VPWR g_row\[0\].g_col\[0\].pe__1695_/X sky130_fd_sc_hd__and2_2
Xg_row\[1\].g_col\[1\].pe__2254_ g_row\[1\].g_col\[1\].pe__2221_/A g_row\[1\].g_col\[1\].pe__2221_/B
+ g_row\[1\].g_col\[1\].pe__2253_/Y VGND VGND VPWR VPWR g_row\[1\].g_col\[1\].pe__2271_/B
+ sky130_fd_sc_hd__o21a_2
Xg_row\[1\].g_col\[0\].pe__2238_ g_row\[1\].g_col\[0\].pe__2238_/A g_row\[1\].g_col\[0\].pe__2238_/B
+ VGND VGND VPWR VPWR g_row\[1\].g_col\[0\].pe__2238_/X sky130_fd_sc_hd__and2_2
XTAP_TAPCELL_ROW_36_756 VGND VPWR sky130_fd_sc_hd__tapvpwrvgnd_1
Xg_row\[1\].g_col\[1\].pe__2185_ g_row\[1\].g_col\[1\].pe__2184_/X g_row\[1\].g_col\[1\].pe__2144_/B
+ g_row\[1\].g_col\[1\].pe__2135_/A VGND VGND VPWR VPWR g_row\[1\].g_col\[1\].pe__2186_/B
+ sky130_fd_sc_hd__o21a_2
XFILLER_33_271 VGND VGND VPWR VPWR sky130_fd_sc_hd__fill_2
XFILLER_40_219 VGND VGND VPWR VPWR sky130_fd_sc_hd__fill_2
Xg_row\[1\].g_col\[0\].pe__2169_ g_row\[1\].g_col\[0\].pe__2167_/X g_row\[1\].g_col\[0\].pe__2169_/B
+ VGND VGND VPWR VPWR g_row\[1\].g_col\[0\].pe__2172_/A sky130_fd_sc_hd__and2b_2
Xg_row\[0\].g_col\[1\].pe__2401_ g_row\[0\].g_col\[1\].pe__2010_/A g_row\[0\].g_col\[1\].pe__2401_/A2
+ g_row\[0\].g_col\[1\].pe__2398_/X g_row\[0\].g_col\[1\].pe__2421_/A1 place1248/X
+ VGND VGND VPWR VPWR g_row\[0\].g_col\[1\].pe__2401_/X sky130_fd_sc_hd__o32a_2
Xg_row\[0\].g_col\[1\].pe__2332_ g_row\[0\].g_col\[1\].pe__2304_/A g_row\[0\].g_col\[1\].pe__2304_/B
+ g_row\[0\].g_col\[1\].pe__2304_/C g_row\[0\].g_col\[1\].pe__2329_/Y g_row\[0\].g_col\[1\].pe__2305_/A
+ VGND VGND VPWR VPWR g_row\[0\].g_col\[1\].pe__2358_/A sky130_fd_sc_hd__a311o_4
Xg_row\[0\].g_col\[0\].pe__2316_ g_row\[0\].g_col\[0\].pe__2316_/A g_row\[0\].g_col\[0\].pe__2316_/B
+ VGND VGND VPWR VPWR g_row\[0\].g_col\[0\].pe__2317_/B sky130_fd_sc_hd__nor2_2
Xg_row\[0\].g_col\[0\].pe__2247_ g_row\[0\].g_col\[0\].pe__2388_/A g_row\[0\].g_col\[0\].pe__1471_/X
+ g_row\[0\].g_col\[0\].pe__2247_/B1 g_row\[0\].g_col\[0\].pe__2121_/A VGND VGND VPWR
+ VPWR g_row\[0\].g_col\[0\].pe__2248_/B sky130_fd_sc_hd__a22o_2
Xg_row\[0\].g_col\[1\].pe__2263_ g_row\[0\].g_col\[1\].pe__2261_/Y g_row\[0\].g_col\[1\].pe__2263_/B
+ VGND VGND VPWR VPWR g_row\[0\].g_col\[1\].pe__2263_/X sky130_fd_sc_hd__and2b_2
Xg_row\[0\].g_col\[0\].pe__2178_ g_row\[0\].g_col\[0\].pe__1970_/A g_row\[0\].g_col\[0\].pe__2279_/A2
+ g_row\[0\].g_col\[0\].pe__2279_/B1 g_row\[0\].g_col\[0\].pe__2241_/B2 VGND VGND
+ VPWR VPWR g_row\[0\].g_col\[0\].pe__2179_/B sky130_fd_sc_hd__a22o_2
Xg_row\[0\].g_col\[1\].pe__2194_ g_row\[0\].g_col\[1\].pe__2202_/A g_row\[0\].g_col\[1\].pe__2202_/B
+ VGND VGND VPWR VPWR g_row\[0\].g_col\[1\].pe__2231_/B sky130_fd_sc_hd__xor2_2
Xg_row\[1\].g_col\[1\].pe_hold1816 g_row\[1\].g_col\[1\].pe__2761_/Q VGND VGND VPWR
+ VPWR g_row\[1\].g_col\[1\].pe__2548_/A1 sky130_fd_sc_hd__clkbuf_2
Xg_row\[1\].g_col\[1\].pe__1969_ g_row\[1\].g_col\[1\].pe__1968_/B g_row\[1\].g_col\[1\].pe__1968_/C
+ g_row\[1\].g_col\[1\].pe__2126_/B2 VGND VGND VPWR VPWR g_row\[1\].g_col\[1\].pe__1974_/B
+ sky130_fd_sc_hd__a21bo_2
XFILLER_68_49 VGND VGND VPWR VPWR sky130_fd_sc_hd__fill_2
Xhold3210 hold3210/A VGND VGND VPWR VPWR hold3210/X sky130_fd_sc_hd__clkbuf_2
Xhold3221 a_inputs_flat[2] VGND VGND VPWR VPWR hold3221/X sky130_fd_sc_hd__clkbuf_2
Xhold3232 hold3232/A VGND VGND VPWR VPWR hold3232/X sky130_fd_sc_hd__clkbuf_2
Xhold2520 _147_/Y VGND VGND VPWR VPWR hold2520/X sky130_fd_sc_hd__clkbuf_2
Xhold2531 hold3283/X VGND VGND VPWR VPWR _239_/B_N sky130_fd_sc_hd__clkbuf_2
Xhold3243 hold3243/A VGND VGND VPWR VPWR hold3243/X sky130_fd_sc_hd__clkbuf_2
Xhold3254 hold3254/A VGND VGND VPWR VPWR hold3254/X sky130_fd_sc_hd__clkbuf_2
Xhold3265 hold3265/A VGND VGND VPWR VPWR hold3265/X sky130_fd_sc_hd__clkbuf_2
Xhold3276 hold3276/A VGND VGND VPWR VPWR hold3276/X sky130_fd_sc_hd__clkbuf_2
Xhold2542 hold3288/X VGND VGND VPWR VPWR hold3289/A sky130_fd_sc_hd__clkbuf_2
Xhold2553 hold3314/X VGND VGND VPWR VPWR hold3315/A sky130_fd_sc_hd__clkbuf_2
Xhold2564 hold3319/X VGND VGND VPWR VPWR hold3320/A sky130_fd_sc_hd__clkbuf_2
Xhold3287 hold3287/A VGND VGND VPWR VPWR hold3287/X sky130_fd_sc_hd__clkbuf_2
Xhold3298 b_inputs_flat[3] VGND VGND VPWR VPWR hold3298/X sky130_fd_sc_hd__clkbuf_2
Xhold2575 hold2575/A VGND VGND VPWR VPWR _280_/D sky130_fd_sc_hd__clkbuf_2
Xhold2586 _235_/Y VGND VGND VPWR VPWR hold2586/X sky130_fd_sc_hd__clkbuf_2
Xhold2597 hold3395/X VGND VGND VPWR VPWR _231_/B_N sky130_fd_sc_hd__clkbuf_2
XFILLER_29_577 VGND VGND VPWR VPWR sky130_fd_sc_hd__decap_3
XFILLER_56_352 VGND VGND VPWR VPWR sky130_fd_sc_hd__fill_1
Xhold1896 hold3100/X VGND VGND VPWR VPWR hold1896/X sky130_fd_sc_hd__clkbuf_2
Xg_row\[0\].g_col\[1\].pe__1978_ g_row\[0\].g_col\[1\].pe__1978_/A g_row\[0\].g_col\[1\].pe__1978_/B
+ g_row\[0\].g_col\[1\].pe__1978_/C VGND VGND VPWR VPWR g_row\[0\].g_col\[1\].pe__1991_/A
+ sky130_fd_sc_hd__or3_4
XFILLER_17_97 VGND VGND VPWR VPWR sky130_fd_sc_hd__fill_2
XTAP_TAPCELL_ROW_14_417 VGND VPWR sky130_fd_sc_hd__tapvpwrvgnd_1
XFILLER_12_477 VGND VGND VPWR VPWR sky130_fd_sc_hd__fill_2
XFILLER_8_448 VGND VGND VPWR VPWR sky130_fd_sc_hd__fill_2
XFILLER_4_621 VGND VGND VPWR VPWR sky130_fd_sc_hd__decap_3
XFILLER_4_643 VGND VGND VPWR VPWR sky130_fd_sc_hd__fill_1
XTAP_TAPCELL_ROW_74_1319 VGND VPWR sky130_fd_sc_hd__tapvpwrvgnd_1
XPHY_EDGE_ROW_89_Left_183 VGND VGND VPWR VPWR sky130_fd_sc_hd__decap_3
XFILLER_79_422 VGND VGND VPWR VPWR sky130_fd_sc_hd__fill_2
Xg_row\[1\].g_col\[0\].pe__1540_ g_row\[1\].g_col\[0\].pe__2736_/Q g_row\[1\].g_col\[0\].pe__2735_/Q
+ g_row\[1\].g_col\[0\].pe__2734_/Q VGND VGND VPWR VPWR g_row\[1\].g_col\[0\].pe__1540_/X
+ sky130_fd_sc_hd__and3b_2
Xg_row\[1\].g_col\[0\].pe__1471_ g_row\[1\].g_col\[0\].pe__1471_/A g_row\[1\].g_col\[0\].pe__1471_/B
+ VGND VGND VPWR VPWR g_row\[1\].g_col\[0\].pe__1471_/X sky130_fd_sc_hd__and2_2
XTAP_TAPCELL_ROW_89_1540 VGND VPWR sky130_fd_sc_hd__tapvpwrvgnd_1
XFILLER_75_650 VGND VGND VPWR VPWR sky130_fd_sc_hd__decap_3
XTAP_TAPCELL_ROW_89_1551 VGND VPWR sky130_fd_sc_hd__tapvpwrvgnd_1
XFILLER_90_620 VGND VGND VPWR VPWR sky130_fd_sc_hd__fill_2
XFILLER_90_642 VGND VGND VPWR VPWR sky130_fd_sc_hd__fill_2
Xg_row\[0\].g_col\[0\].pe__1480_ g_row\[0\].g_col\[0\].pe__1662_/A g_row\[0\].g_col\[0\].pe__1662_/B
+ g_row\[0\].g_col\[0\].pe__1479_/Y VGND VGND VPWR VPWR g_row\[0\].g_col\[0\].pe__1501_/A
+ sky130_fd_sc_hd__a21oi_2
Xg_row\[1\].g_col\[0\].pe__2023_ g_row\[1\].g_col\[0\].pe__2023_/A g_row\[1\].g_col\[0\].pe__2023_/B
+ VGND VGND VPWR VPWR g_row\[1\].g_col\[0\].pe__2024_/B sky130_fd_sc_hd__xor2_2
XTAP_TAPCELL_ROW_33_704 VGND VPWR sky130_fd_sc_hd__tapvpwrvgnd_1
XFILLER_31_753 VGND VGND VPWR VPWR sky130_fd_sc_hd__fill_2
XFILLER_88_3 VGND VGND VPWR VPWR sky130_fd_sc_hd__fill_2
Xg_row\[0\].g_col\[0\].pe__2101_ g_row\[0\].g_col\[0\].pe__2101_/A g_row\[0\].g_col\[0\].pe__2145_/A
+ g_row\[0\].g_col\[0\].pe__2101_/C VGND VGND VPWR VPWR g_row\[0\].g_col\[0\].pe__2104_/A
+ sky130_fd_sc_hd__or3_4
Xg_row\[0\].g_col\[0\].pe__2032_ g_row\[0\].g_col\[0\].pe__2165_/A g_row\[0\].g_col\[0\].pe__2032_/B
+ g_row\[0\].g_col\[0\].pe__2032_/C VGND VGND VPWR VPWR g_row\[0\].g_col\[0\].pe__2034_/C
+ sky130_fd_sc_hd__nand3_2
Xg_row\[1\].g_col\[1\].pe__1823_ g_row\[1\].g_col\[1\].pe__1823_/A g_row\[1\].g_col\[1\].pe__1823_/B
+ VGND VGND VPWR VPWR g_row\[1\].g_col\[1\].pe__1828_/A sky130_fd_sc_hd__xnor2_2
Xg_row\[1\].g_col\[0\].pe__1807_ g_row\[1\].g_col\[0\].pe__1807_/A g_row\[1\].g_col\[0\].pe__1807_/B
+ VGND VGND VPWR VPWR g_row\[1\].g_col\[0\].pe__1811_/C sky130_fd_sc_hd__nand2_2
Xg_row\[1\].g_col\[1\].pe__1754_ g_row\[1\].g_col\[1\].pe__1805_/A2 g_row\[1\].g_col\[1\].pe__1982_/B
+ g_row\[1\].g_col\[1\].pe__1424_/Y g_row\[1\].g_col\[1\].pe__2690_/Q VGND VGND VPWR
+ VPWR g_row\[1\].g_col\[1\].pe__1755_/B sky130_fd_sc_hd__a22o_2
Xg_row\[1\].g_col\[0\].pe__1738_ place1104/X g_row\[1\].g_col\[0\].pe__1748_/B g_row\[1\].g_col\[0\].pe__1738_/B1
+ place1106/X VGND VGND VPWR VPWR g_row\[1\].g_col\[0\].pe__1739_/B sky130_fd_sc_hd__a22o_2
Xg_row\[1\].g_col\[1\].pe__1685_ g_row\[1\].g_col\[1\].pe__1733_/A g_row\[1\].g_col\[1\].pe__1685_/B
+ VGND VGND VPWR VPWR g_row\[1\].g_col\[1\].pe__1713_/B sky130_fd_sc_hd__xor2_2
Xg_row\[1\].g_col\[0\].pe__1669_ g_row\[1\].g_col\[0\].pe__1669_/A g_row\[1\].g_col\[0\].pe__1669_/B
+ VGND VGND VPWR VPWR g_row\[1\].g_col\[0\].pe__1831_/B sky130_fd_sc_hd__xnor2_2
Xg_row\[0\].g_col\[1\].pe__1901_ g_row\[0\].g_col\[1\].pe__1957_/B2 g_row\[0\].g_col\[1\].pe__2177_/A2
+ g_row\[0\].g_col\[1\].pe__1901_/B1 g_row\[0\].g_col\[1\].pe__2605_/B VGND VGND VPWR
+ VPWR g_row\[0\].g_col\[1\].pe__1905_/A sky130_fd_sc_hd__a22o_2
Xg_row\[0\].g_col\[1\].pe__1832_ g_row\[0\].g_col\[1\].pe__1840_/A g_row\[0\].g_col\[1\].pe__1832_/B
+ g_row\[0\].g_col\[1\].pe__1832_/C VGND VGND VPWR VPWR g_row\[0\].g_col\[1\].pe__1832_/Y
+ sky130_fd_sc_hd__nand3_2
Xg_row\[0\].g_col\[0\].pe__1816_ g_row\[0\].g_col\[0\].pe__1816_/A g_row\[0\].g_col\[0\].pe__1816_/B
+ g_row\[0\].g_col\[0\].pe__1816_/C VGND VGND VPWR VPWR g_row\[0\].g_col\[0\].pe__1816_/X
+ sky130_fd_sc_hd__and3_2
XFILLER_26_547 VGND VGND VPWR VPWR sky130_fd_sc_hd__fill_2
XFILLER_81_620 VGND VGND VPWR VPWR sky130_fd_sc_hd__decap_3
Xg_row\[0\].g_col\[0\].pe__1747_ g_row\[0\].g_col\[0\].pe__1747_/A g_row\[0\].g_col\[0\].pe__1820_/B
+ VGND VGND VPWR VPWR g_row\[0\].g_col\[0\].pe__1822_/C sky130_fd_sc_hd__or2_2
Xg_row\[1\].g_col\[1\].pe__2306_ g_row\[1\].g_col\[1\].pe__2334_/A1 g_row\[1\].g_col\[1\].pe__2306_/A2
+ g_row\[1\].g_col\[1\].pe__2394_/B1 g_row\[1\].g_col\[1\].pe__2305_/Y VGND VGND VPWR
+ VPWR g_row\[1\].g_col\[1\].pe__2306_/X sky130_fd_sc_hd__o22a_2
Xg_row\[0\].g_col\[1\].pe__1763_ g_row\[0\].g_col\[1\].pe__2691_/Q g_row\[0\].g_col\[1\].pe__1414_/X
+ g_row\[0\].g_col\[1\].pe__1415_/Y g_row\[0\].g_col\[1\].pe__1416_/X g_row\[0\].g_col\[1\].pe__1799_/A2
+ VGND VGND VPWR VPWR g_row\[0\].g_col\[1\].pe__1764_/B sky130_fd_sc_hd__a32o_2
XFILLER_53_366 VGND VGND VPWR VPWR sky130_fd_sc_hd__decap_3
Xg_row\[0\].g_col\[1\].pe__1694_ g_row\[0\].g_col\[1\].pe__1695_/A g_row\[0\].g_col\[1\].pe__1695_/B
+ VGND VGND VPWR VPWR g_row\[0\].g_col\[1\].pe__1703_/B sky130_fd_sc_hd__xor2_2
Xg_row\[1\].g_col\[1\].pe__2237_ g_row\[1\].g_col\[1\].pe__2396_/A g_row\[1\].g_col\[1\].pe__2237_/B
+ VGND VGND VPWR VPWR g_row\[1\].g_col\[1\].pe__2747_/D sky130_fd_sc_hd__nor2_2
XTAP_TAPCELL_ROW_0_189 VGND VPWR sky130_fd_sc_hd__tapvpwrvgnd_1
Xg_row\[0\].g_col\[0\].pe__1678_ g_row\[0\].g_col\[0\].pe__1703_/A VGND VGND VPWR
+ VPWR g_row\[0\].g_col\[0\].pe__1678_/Y sky130_fd_sc_hd__inv_2
XFILLER_21_230 VGND VGND VPWR VPWR sky130_fd_sc_hd__decap_3
Xg_row\[1\].g_col\[1\].pe__2168_ g_row\[1\].g_col\[1\].pe__2167_/B g_row\[1\].g_col\[1\].pe__2167_/C
+ g_row\[1\].g_col\[1\].pe__2167_/A VGND VGND VPWR VPWR g_row\[1\].g_col\[1\].pe__2169_/B
+ sky130_fd_sc_hd__a21o_2
Xg_row\[1\].g_col\[1\].pe__2099_ g_row\[1\].g_col\[1\].pe__2099_/A g_row\[1\].g_col\[1\].pe__2184_/B
+ g_row\[1\].g_col\[1\].pe__2099_/C VGND VGND VPWR VPWR g_row\[1\].g_col\[1\].pe__2145_/A
+ sky130_fd_sc_hd__and3_4
XPHY_EDGE_ROW_17_Right_17 VGND VGND VPWR VPWR sky130_fd_sc_hd__decap_3
Xg_row\[0\].g_col\[1\].pe__2315_ g_row\[0\].g_col\[1\].pe__2316_/A g_row\[0\].g_col\[1\].pe__2316_/B
+ VGND VGND VPWR VPWR g_row\[0\].g_col\[1\].pe__2347_/A sky130_fd_sc_hd__and2_2
Xg_row\[0\].g_col\[1\].pe__2246_ g_row\[0\].g_col\[1\].pe__2246_/A g_row\[0\].g_col\[1\].pe__2246_/B
+ VGND VGND VPWR VPWR g_row\[0\].g_col\[1\].pe__2273_/A sky130_fd_sc_hd__xnor2_2
Xg_row\[1\].g_col\[1\].pe_hold3059 g_row\[1\].g_col\[1\].pe__2648_/X VGND VGND VPWR
+ VPWR g_row\[1\].g_col\[1\].pe_hold3059/X sky130_fd_sc_hd__clkbuf_2
Xg_row\[0\].g_col\[1\].pe__2177_ g_row\[0\].g_col\[1\].pe__2177_/A1 g_row\[0\].g_col\[1\].pe__2177_/A2
+ g_row\[0\].g_col\[1\].pe__2215_/B1 g_row\[0\].g_col\[1\].pe__2616_/B VGND VGND VPWR
+ VPWR g_row\[0\].g_col\[1\].pe__2213_/A sky130_fd_sc_hd__a22o_2
XTAP_TAPCELL_ROW_56_1049 VGND VPWR sky130_fd_sc_hd__tapvpwrvgnd_1
XFILLER_49_606 VGND VGND VPWR VPWR sky130_fd_sc_hd__decap_3
Xg_row\[1\].g_col\[1\].pe_hold1679 g_row\[1\].g_col\[1\].pe__2514_/Y VGND VGND VPWR
+ VPWR g_row\[1\].g_col\[1\].pe__2756_/D sky130_fd_sc_hd__clkbuf_2
Xg_row\[1\].g_col\[1\].pe_hold1668 g_row\[1\].g_col\[1\].pe__1835_/X VGND VGND VPWR
+ VPWR g_row\[1\].g_col\[1\].pe__1836_/B sky130_fd_sc_hd__clkbuf_2
Xg_row\[1\].g_col\[1\].pe_hold1646 g_row\[1\].g_col\[1\].pe__2744_/Q VGND VGND VPWR
+ VPWR g_row\[1\].g_col\[1\].pe__2065_/A sky130_fd_sc_hd__clkbuf_2
XFILLER_49_617 VGND VGND VPWR VPWR sky130_fd_sc_hd__fill_2
XFILLER_49_639 VGND VGND VPWR VPWR sky130_fd_sc_hd__fill_2
XPHY_EDGE_ROW_26_Right_26 VGND VGND VPWR VPWR sky130_fd_sc_hd__decap_3
XFILLER_48_138 VGND VGND VPWR VPWR sky130_fd_sc_hd__fill_2
XFILLER_17_503 VGND VGND VPWR VPWR sky130_fd_sc_hd__fill_1
XFILLER_17_547 VGND VGND VPWR VPWR sky130_fd_sc_hd__decap_3
XFILLER_28_85 VGND VGND VPWR VPWR sky130_fd_sc_hd__decap_3
XFILLER_72_653 VGND VGND VPWR VPWR sky130_fd_sc_hd__decap_3
XFILLER_44_399 VGND VGND VPWR VPWR sky130_fd_sc_hd__decap_3
XTAP_TAPCELL_ROW_84_1470 VGND VPWR sky130_fd_sc_hd__tapvpwrvgnd_1
XFILLER_9_735 VGND VGND VPWR VPWR sky130_fd_sc_hd__fill_1
XPHY_EDGE_ROW_35_Right_35 VGND VGND VPWR VPWR sky130_fd_sc_hd__decap_3
XFILLER_13_797 VGND VGND VPWR VPWR sky130_fd_sc_hd__fill_2
XFILLER_40_583 VGND VGND VPWR VPWR sky130_fd_sc_hd__fill_1
XFILLER_60_72 VGND VGND VPWR VPWR sky130_fd_sc_hd__fill_1
Xg_row\[0\].g_col\[0\].pe_place1230 g_row\[0\].g_col\[0\].pe__2677_/B1 VGND VGND VPWR
+ VPWR g_row\[0\].g_col\[0\].pe__2687_/C1 sky130_fd_sc_hd__buf_6
Xg_row\[0\].g_col\[0\].pe_place1252 g_row\[0\].g_col\[0\].pe__2599_/A VGND VGND VPWR
+ VPWR g_row\[0\].g_col\[0\].pe__2395_/A1 sky130_fd_sc_hd__buf_6
Xg_row\[1\].g_col\[0\].pe__2710_ clkbuf_leaf_40_clk/X g_row\[1\].g_col\[0\].pe__2710_/D
+ VGND VGND VPWR VPWR g_row\[1\].g_col\[0\].pe__2710_/Q sky130_fd_sc_hd__dfxtp_2
Xg_row\[1\].g_col\[0\].pe__2641_ place1257/X g_row\[1\].g_col\[0\].pe__2641_/B VGND
+ VGND VPWR VPWR g_row\[1\].g_col\[0\].pe__2641_/X sky130_fd_sc_hd__or2_2
XFILLER_5_78 VGND VGND VPWR VPWR sky130_fd_sc_hd__fill_1
Xg_row\[1\].g_col\[1\].pe_hold2870 g_row\[1\].g_col\[1\].pe__2666_/X VGND VGND VPWR
+ VPWR g_row\[1\].g_col\[1\].pe_hold2870/X sky130_fd_sc_hd__clkbuf_2
XPHY_EDGE_ROW_44_Right_44 VGND VGND VPWR VPWR sky130_fd_sc_hd__decap_3
Xg_row\[1\].g_col\[0\].pe__2572_ g_row\[1\].g_col\[0\].pe__2572_/A1 g_row\[1\].g_col\[0\].pe__2591_/A2
+ g_row\[1\].g_col\[0\].pe__2591_/B1 g_row\[1\].g_col\[0\].pe__2571_/X VGND VGND VPWR
+ VPWR g_row\[1\].g_col\[0\].pe__2573_/B sky130_fd_sc_hd__a22o_2
Xg_row\[1\].g_col\[0\].pe__1523_ g_row\[1\].g_col\[0\].pe__1523_/A g_row\[1\].g_col\[0\].pe__1523_/B
+ VGND VGND VPWR VPWR g_row\[1\].g_col\[0\].pe__1584_/B sky130_fd_sc_hd__xnor2_2
Xg_row\[1\].g_col\[1\].pe__1470_ g_row\[1\].g_col\[1\].pe__2733_/Q g_row\[1\].g_col\[1\].pe__2250_/A
+ VGND VGND VPWR VPWR g_row\[1\].g_col\[1\].pe__1471_/B sky130_fd_sc_hd__or2_2
Xg_row\[1\].g_col\[0\].pe_hold2058 g_row\[1\].g_col\[0\].pe__2719_/Q VGND VGND VPWR
+ VPWR g_row\[1\].g_col\[0\].pe__2667_/B sky130_fd_sc_hd__clkbuf_2
XFILLER_67_469 VGND VGND VPWR VPWR sky130_fd_sc_hd__fill_1
Xg_row\[0\].g_col\[0\].pe__2650_ g_row\[0\].g_col\[0\].pe__2656_/A1 g_row\[0\].g_col\[0\].pe__2650_/A2
+ g_row\[0\].g_col\[0\].pe__2687_/C1 g_row\[0\].g_col\[0\].pe__2649_/X VGND VGND VPWR
+ VPWR g_row\[0\].g_col\[0\].pe__2650_/X sky130_fd_sc_hd__o211a_2
XFILLER_35_300 VGND VGND VPWR VPWR sky130_fd_sc_hd__fill_2
XFILLER_48_694 VGND VGND VPWR VPWR sky130_fd_sc_hd__fill_1
XFILLER_82_428 VGND VGND VPWR VPWR sky130_fd_sc_hd__decap_3
Xg_row\[0\].g_col\[0\].pe__1601_ g_row\[0\].g_col\[0\].pe__1957_/B2 g_row\[0\].g_col\[0\].pe__1549_/B
+ g_row\[0\].g_col\[0\].pe__1541_/X place1218/A VGND VGND VPWR VPWR g_row\[0\].g_col\[0\].pe__1602_/B
+ sky130_fd_sc_hd__a22o_2
Xg_row\[0\].g_col\[0\].pe__2581_ g_row\[0\].g_col\[0\].pe__2581_/A1 g_row\[0\].g_col\[0\].pe__2591_/A2
+ g_row\[0\].g_col\[0\].pe__2591_/B1 g_row\[0\].g_col\[0\].pe__2580_/X VGND VGND VPWR
+ VPWR g_row\[0\].g_col\[0\].pe__2581_/X sky130_fd_sc_hd__a22o_2
Xg_row\[1\].g_col\[0\].pe__1385_ hold1905/X g_row\[1\].g_col\[0\].pe__1402_/B VGND
+ VGND VPWR VPWR g_row\[1\].g_col\[0\].pe__1385_/X sky130_fd_sc_hd__or2_2
XFILLER_23_539 VGND VGND VPWR VPWR sky130_fd_sc_hd__fill_2
XTAP_TAPCELL_ROW_46_895 VGND VPWR sky130_fd_sc_hd__tapvpwrvgnd_1
Xg_row\[0\].g_col\[0\].pe__1532_ g_row\[0\].g_col\[0\].pe__1555_/A g_row\[0\].g_col\[0\].pe__1555_/B
+ VGND VGND VPWR VPWR g_row\[0\].g_col\[0\].pe__1533_/B sky130_fd_sc_hd__xor2_2
XFILLER_16_580 VGND VGND VPWR VPWR sky130_fd_sc_hd__fill_2
XFILLER_50_336 VGND VGND VPWR VPWR sky130_fd_sc_hd__fill_2
XFILLER_50_358 VGND VGND VPWR VPWR sky130_fd_sc_hd__decap_3
XPHY_EDGE_ROW_53_Right_53 VGND VGND VPWR VPWR sky130_fd_sc_hd__decap_3
Xg_row\[0\].g_col\[0\].pe__1463_ g_row\[0\].g_col\[0\].pe__1957_/B2 g_row\[0\].g_col\[0\].pe__1715_/B
+ g_row\[0\].g_col\[0\].pe__1863_/B1 place1218/X VGND VGND VPWR VPWR g_row\[0\].g_col\[0\].pe__1464_/B
+ sky130_fd_sc_hd__a22o_2
Xg_row\[1\].g_col\[1\].pe__2022_ g_row\[1\].g_col\[1\].pe__2071_/A g_row\[1\].g_col\[1\].pe__2071_/B
+ VGND VGND VPWR VPWR g_row\[1\].g_col\[1\].pe__2023_/B sky130_fd_sc_hd__xor2_2
Xg_row\[1\].g_col\[0\].pe__2006_ g_row\[1\].g_col\[0\].pe__2006_/A g_row\[1\].g_col\[0\].pe__2009_/B
+ VGND VGND VPWR VPWR g_row\[1\].g_col\[0\].pe__2151_/B sky130_fd_sc_hd__or2b_2
Xg_row\[0\].g_col\[0\].pe__1394_ g_row\[0\].g_col\[0\].pe__1394_/A g_row\[0\].g_col\[0\].pe__1402_/B
+ VGND VGND VPWR VPWR g_row\[0\].g_col\[0\].pe__1394_/X sky130_fd_sc_hd__or2_2
XFILLER_31_583 VGND VGND VPWR VPWR sky130_fd_sc_hd__decap_3
Xg_row\[0\].g_col\[1\].pe__2100_ g_row\[0\].g_col\[1\].pe__2099_/A g_row\[0\].g_col\[1\].pe__2184_/B
+ g_row\[0\].g_col\[1\].pe__2099_/C VGND VGND VPWR VPWR g_row\[0\].g_col\[1\].pe__2101_/C
+ sky130_fd_sc_hd__a21oi_2
Xg_row\[0\].g_col\[1\].pe__2031_ g_row\[0\].g_col\[1\].pe__1461_/A g_row\[0\].g_col\[1\].pe__1461_/B
+ g_row\[0\].g_col\[1\].pe__2241_/A1 VGND VGND VPWR VPWR g_row\[0\].g_col\[1\].pe__2032_/C
+ sky130_fd_sc_hd__a21bo_2
Xg_row\[0\].g_col\[0\].pe__2015_ g_row\[0\].g_col\[0\].pe__2002_/A g_row\[0\].g_col\[0\].pe__2002_/B
+ g_row\[0\].g_col\[0\].pe__2014_/X VGND VGND VPWR VPWR g_row\[0\].g_col\[0\].pe__2059_/A
+ sky130_fd_sc_hd__a21o_2
XPHY_EDGE_ROW_62_Right_62 VGND VGND VPWR VPWR sky130_fd_sc_hd__decap_3
Xg_row\[1\].g_col\[1\].pe__1806_ g_row\[1\].g_col\[1\].pe__1801_/C g_row\[1\].g_col\[1\].pe__1806_/B
+ VGND VGND VPWR VPWR g_row\[1\].g_col\[1\].pe__1808_/C sky130_fd_sc_hd__and2b_2
Xg_row\[1\].g_col\[1\].pe__1737_ g_row\[1\].g_col\[1\].pe__1740_/A g_row\[1\].g_col\[1\].pe__1740_/B
+ VGND VGND VPWR VPWR g_row\[1\].g_col\[1\].pe__1776_/A sky130_fd_sc_hd__xor2_2
Xg_row\[1\].g_col\[1\].pe__1668_ g_row\[1\].g_col\[1\].pe__1701_/A g_row\[1\].g_col\[1\].pe__1701_/B
+ VGND VGND VPWR VPWR g_row\[1\].g_col\[1\].pe__1831_/A sky130_fd_sc_hd__or2_2
XANTENNA_107 ANTENNA_107/DIODE VGND VGND VPWR VPWR sky130_fd_sc_hd__diode_2
XFILLER_66_491 VGND VGND VPWR VPWR sky130_fd_sc_hd__fill_1
Xg_row\[0\].g_col\[1\].pe__1815_ g_row\[0\].g_col\[1\].pe__1815_/A g_row\[0\].g_col\[1\].pe__1815_/B
+ VGND VGND VPWR VPWR g_row\[0\].g_col\[1\].pe__1822_/D sky130_fd_sc_hd__xnor2_2
XANTENNA_118 hold3158/X VGND VGND VPWR VPWR sky130_fd_sc_hd__diode_2
XANTENNA_129 hold3259/A VGND VGND VPWR VPWR sky130_fd_sc_hd__diode_2
Xg_row\[0\].g_col\[1\].pe__1746_ g_row\[0\].g_col\[1\].pe__1819_/A g_row\[0\].g_col\[1\].pe__1819_/B
+ VGND VGND VPWR VPWR g_row\[0\].g_col\[1\].pe__1820_/B sky130_fd_sc_hd__nor2_2
Xg_row\[1\].g_col\[0\].pe_hold1891 g_row\[1\].g_col\[0\].pe__1397_/X VGND VGND VPWR
+ VPWR g_row\[1\].g_col\[0\].pe__2734_/D sky130_fd_sc_hd__clkbuf_2
Xg_row\[0\].g_col\[1\].pe_hold2968 g_row\[0\].g_col\[1\].pe__2674_/B VGND VGND VPWR
+ VPWR g_row\[0\].g_col\[1\].pe__2650_/A2 sky130_fd_sc_hd__clkbuf_2
XPHY_EDGE_ROW_71_Right_71 VGND VGND VPWR VPWR sky130_fd_sc_hd__decap_3
Xg_row\[0\].g_col\[1\].pe__1677_ g_row\[0\].g_col\[1\].pe__1823_/A g_row\[0\].g_col\[1\].pe__1677_/B
+ VGND VGND VPWR VPWR g_row\[0\].g_col\[1\].pe__1703_/A sky130_fd_sc_hd__or2_2
XFILLER_14_54 VGND VGND VPWR VPWR sky130_fd_sc_hd__decap_3
XFILLER_22_561 VGND VGND VPWR VPWR sky130_fd_sc_hd__decap_3
XTAP_TAPCELL_ROW_24_567 VGND VPWR sky130_fd_sc_hd__tapvpwrvgnd_1
XFILLER_30_42 VGND VGND VPWR VPWR sky130_fd_sc_hd__fill_1
XPHY_EDGE_ROW_80_Right_80 VGND VGND VPWR VPWR sky130_fd_sc_hd__decap_3
Xg_row\[1\].g_col\[1\].pe_hold2100 g_row\[1\].g_col\[1\].pe_hold2874/X VGND VGND VPWR
+ VPWR g_row\[1\].g_col\[1\].pe__2715_/D sky130_fd_sc_hd__clkbuf_2
Xg_row\[0\].g_col\[1\].pe__2229_ g_row\[0\].g_col\[1\].pe__2262_/A g_row\[0\].g_col\[1\].pe__2229_/B
+ VGND VGND VPWR VPWR g_row\[0\].g_col\[1\].pe__2238_/B sky130_fd_sc_hd__and2_2
Xg_row\[1\].g_col\[1\].pe_hold2199 g_row\[1\].g_col\[1\].pe__2606_/X VGND VGND VPWR
+ VPWR g_row\[1\].g_col\[1\].pe__2692_/D sky130_fd_sc_hd__clkbuf_2
Xg_row\[1\].g_col\[1\].pe_hold2177 g_row\[1\].g_col\[1\].pe_hold2844/X VGND VGND VPWR
+ VPWR g_row\[1\].g_col\[1\].pe_hold2845/A sky130_fd_sc_hd__clkbuf_2
XFILLER_1_476 VGND VGND VPWR VPWR sky130_fd_sc_hd__fill_1
XFILLER_77_712 VGND VGND VPWR VPWR sky130_fd_sc_hd__decap_3
XFILLER_49_458 VGND VGND VPWR VPWR sky130_fd_sc_hd__decap_3
Xclkbuf_4_3_0_clk clkbuf_0_clk/X VGND VGND VPWR VPWR clkload1/A sky130_fd_sc_hd__clkbuf_16
XFILLER_91_225 VGND VGND VPWR VPWR sky130_fd_sc_hd__fill_2
XTAP_TAPCELL_ROW_4_270 VGND VPWR sky130_fd_sc_hd__tapvpwrvgnd_1
XFILLER_17_333 VGND VGND VPWR VPWR sky130_fd_sc_hd__decap_3
XFILLER_17_355 VGND VGND VPWR VPWR sky130_fd_sc_hd__fill_1
XFILLER_29_182 VGND VGND VPWR VPWR sky130_fd_sc_hd__fill_1
XFILLER_44_141 VGND VGND VPWR VPWR sky130_fd_sc_hd__fill_1
XFILLER_57_491 VGND VGND VPWR VPWR sky130_fd_sc_hd__decap_3
Xhold1490 hold3226/X VGND VGND VPWR VPWR hold3227/A sky130_fd_sc_hd__clkbuf_2
Xg_row\[1\].g_col\[0\].pe_place851 g_row\[1\].g_col\[0\].pe__1424_/Y VGND VGND VPWR
+ VPWR g_row\[1\].g_col\[0\].pe__1732_/B1 sky130_fd_sc_hd__buf_6
Xg_row\[1\].g_col\[0\].pe_place840 g_row\[1\].g_col\[0\].pe_place841/A VGND VGND VPWR
+ VPWR g_row\[1\].g_col\[0\].pe__1804_/B sky130_fd_sc_hd__buf_6
XFILLER_17_399 VGND VGND VPWR VPWR sky130_fd_sc_hd__decap_3
XFILLER_60_634 VGND VGND VPWR VPWR sky130_fd_sc_hd__fill_1
XFILLER_60_645 VGND VGND VPWR VPWR sky130_fd_sc_hd__decap_3
XFILLER_13_561 VGND VGND VPWR VPWR sky130_fd_sc_hd__decap_3
XFILLER_60_667 VGND VGND VPWR VPWR sky130_fd_sc_hd__fill_2
XTAP_TAPCELL_ROW_43_854 VGND VPWR sky130_fd_sc_hd__tapvpwrvgnd_1
Xg_row\[0\].g_col\[0\].pe_hold1934 g_row\[0\].g_col\[0\].pe__1892_/X VGND VGND VPWR
+ VPWR g_row\[0\].g_col\[0\].pe__1893_/B sky130_fd_sc_hd__clkbuf_2
XFILLER_9_598 VGND VGND VPWR VPWR sky130_fd_sc_hd__fill_1
Xg_row\[1\].g_col\[1\].pe__2640_ g_row\[1\].g_col\[1\].pe__1950_/A g_row\[1\].g_col\[1\].pe__2640_/A2
+ g_row\[1\].g_col\[1\].pe__2639_/X g_row\[1\].g_col\[1\].pe__2640_/C1 VGND VGND VPWR
+ VPWR g_row\[1\].g_col\[1\].pe__2640_/X sky130_fd_sc_hd__o211a_2
Xg_row\[1\].g_col\[0\].pe__2624_ g_row\[1\].g_col\[0\].pe__2626_/A1 g_row\[1\].g_col\[0\].pe__2624_/A2
+ g_row\[1\].g_col\[0\].pe__2626_/B1 g_row\[1\].g_col\[0\].pe__2623_/X VGND VGND VPWR
+ VPWR g_row\[1\].g_col\[0\].pe__2624_/X sky130_fd_sc_hd__o211a_2
XFILLER_68_701 VGND VGND VPWR VPWR sky130_fd_sc_hd__decap_3
Xg_row\[1\].g_col\[1\].pe__2571_ g_row\[1\].g_col\[1\].pe__2571_/A g_row\[1\].g_col\[1\].pe__2590_/A
+ VGND VGND VPWR VPWR g_row\[1\].g_col\[1\].pe__2571_/X sky130_fd_sc_hd__or2_2
Xg_row\[1\].g_col\[0\].pe__2555_ g_row\[1\].g_col\[0\].pe__2561_/A g_row\[1\].g_col\[0\].pe__2555_/B
+ VGND VGND VPWR VPWR g_row\[1\].g_col\[0\].pe__2762_/D sky130_fd_sc_hd__and2_2
Xg_row\[1\].g_col\[1\].pe__1522_ g_row\[1\].g_col\[1\].pe__1733_/A g_row\[1\].g_col\[1\].pe__1522_/B
+ VGND VGND VPWR VPWR g_row\[1\].g_col\[1\].pe__1523_/B sky130_fd_sc_hd__xor2_2
Xg_row\[1\].g_col\[0\].pe__1506_ g_row\[1\].g_col\[0\].pe__2599_/B g_row\[1\].g_col\[0\].pe__1549_/B
+ VGND VGND VPWR VPWR g_row\[1\].g_col\[0\].pe__1535_/B sky130_fd_sc_hd__nand2_2
XFILLER_55_406 VGND VGND VPWR VPWR sky130_fd_sc_hd__fill_2
Xg_row\[0\].g_col\[0\].pe__2702_ _292_/CLK g_row\[0\].g_col\[0\].pe__2702_/D VGND
+ VGND VPWR VPWR hold2359/A sky130_fd_sc_hd__dfxtp_2
Xg_row\[1\].g_col\[1\].pe__1453_ g_row\[1\].g_col\[1\].pe__2250_/A VGND VGND VPWR
+ VPWR g_row\[1\].g_col\[1\].pe__1611_/A sky130_fd_sc_hd__inv_2
Xg_row\[1\].g_col\[0\].pe__2486_ g_row\[1\].g_col\[0\].pe__2509_/S g_row\[1\].g_col\[0\].pe__2486_/B
+ VGND VGND VPWR VPWR g_row\[1\].g_col\[0\].pe__2516_/B sky130_fd_sc_hd__or2_2
XFILLER_48_480 VGND VGND VPWR VPWR sky130_fd_sc_hd__decap_3
Xg_row\[1\].g_col\[0\].pe__1437_ g_row\[1\].g_col\[0\].pe__1730_/A g_row\[1\].g_col\[0\].pe__1437_/B
+ VGND VGND VPWR VPWR g_row\[1\].g_col\[0\].pe__1481_/B sky130_fd_sc_hd__xor2_2
Xg_row\[0\].g_col\[1\].pe_hold2209 g_row\[0\].g_col\[1\].pe_hold2243/X VGND VGND VPWR
+ VPWR g_row\[0\].g_col\[1\].pe_hold2244/A sky130_fd_sc_hd__clkbuf_2
Xg_row\[0\].g_col\[0\].pe__2633_ g_row\[0\].g_col\[0\].pe__1950_/A g_row\[0\].g_col\[0\].pe__2633_/A2
+ g_row\[0\].g_col\[0\].pe__2633_/B1 g_row\[0\].g_col\[0\].pe__2632_/X VGND VGND VPWR
+ VPWR g_row\[0\].g_col\[0\].pe__2633_/X sky130_fd_sc_hd__o211a_2
Xg_row\[1\].g_col\[1\].pe__1384_ g_row\[1\].g_col\[1\].pe__1384_/A1 g_row\[1\].g_col\[1\].pe__2686_/B
+ g_row\[1\].g_col\[1\].pe__1384_/B1 g_row\[1\].g_col\[1\].pe__2687_/C1 VGND VGND
+ VPWR VPWR g_row\[1\].g_col\[1\].pe__1384_/X sky130_fd_sc_hd__o211a_2
Xg_row\[1\].g_col\[0\].pe__1368_ g_row\[1\].g_col\[0\].pe__2769_/Q g_row\[1\].g_col\[0\].pe__1368_/B
+ VGND VGND VPWR VPWR output1394/A sky130_fd_sc_hd__xnor2_2
XFILLER_24_837 VGND VGND VPWR VPWR sky130_fd_sc_hd__fill_1
Xg_row\[0\].g_col\[0\].pe__2564_ g_row\[0\].g_col\[0\].pe__2564_/A1 g_row\[0\].g_col\[0\].pe__2591_/A2
+ g_row\[0\].g_col\[0\].pe__2591_/B1 g_row\[0\].g_col\[0\].pe__2563_/X VGND VGND VPWR
+ VPWR g_row\[0\].g_col\[0\].pe__2564_/X sky130_fd_sc_hd__a22o_2
Xg_row\[0\].g_col\[1\].pe__2580_ g_row\[0\].g_col\[1\].pe__2479_/X g_row\[0\].g_col\[1\].pe__2579_/Y
+ g_row\[0\].g_col\[1\].pe__2586_/A VGND VGND VPWR VPWR g_row\[0\].g_col\[1\].pe__2580_/X
+ sky130_fd_sc_hd__a21o_2
Xg_row\[0\].g_col\[0\].pe__1515_ g_row\[0\].g_col\[0\].pe__1490_/A g_row\[0\].g_col\[0\].pe__1490_/B
+ g_row\[0\].g_col\[0\].pe__1514_/X VGND VGND VPWR VPWR g_row\[0\].g_col\[0\].pe__1584_/A
+ sky130_fd_sc_hd__a21oi_2
Xg_row\[0\].g_col\[1\].pe__1531_ g_row\[0\].g_col\[1\].pe__1676_/A g_row\[0\].g_col\[1\].pe__1531_/B
+ VGND VGND VPWR VPWR g_row\[0\].g_col\[1\].pe__1555_/B sky130_fd_sc_hd__xnor2_2
XFILLER_50_166 VGND VGND VPWR VPWR sky130_fd_sc_hd__decap_3
Xg_row\[0\].g_col\[0\].pe__2495_ g_row\[0\].g_col\[0\].pe__2495_/A VGND VGND VPWR
+ VPWR g_row\[0\].g_col\[0\].pe__2496_/A sky130_fd_sc_hd__inv_2
Xg_row\[1\].g_col\[1\].pe__2005_ g_row\[1\].g_col\[1\].pe__2005_/A g_row\[1\].g_col\[1\].pe__2005_/B
+ VGND VGND VPWR VPWR g_row\[1\].g_col\[1\].pe__2009_/B sky130_fd_sc_hd__or2_2
XTAP_TAPCELL_ROW_21_526 VGND VPWR sky130_fd_sc_hd__tapvpwrvgnd_1
XFILLER_31_391 VGND VGND VPWR VPWR sky130_fd_sc_hd__fill_1
Xg_row\[0\].g_col\[0\].pe__1377_ _165_/A VGND VGND VPWR VPWR g_row\[0\].g_col\[0\].pe__1377_/Y
+ sky130_fd_sc_hd__inv_2
Xg_row\[0\].g_col\[1\].pe__1393_ g_row\[0\].g_col\[1\].pe__2250_/A g_row\[0\].g_col\[1\].pe__2686_/B
+ g_row\[0\].g_col\[1\].pe__1392_/X g_row\[0\].g_col\[1\].pe__2687_/C1 VGND VGND VPWR
+ VPWR g_row\[0\].g_col\[1\].pe__1393_/X sky130_fd_sc_hd__o211a_2
Xg_row\[0\].g_col\[1\].pe__2014_ g_row\[0\].g_col\[1\].pe__2001_/B g_row\[0\].g_col\[1\].pe__2014_/B
+ VGND VGND VPWR VPWR g_row\[0\].g_col\[1\].pe__2014_/X sky130_fd_sc_hd__and2b_2
XTAP_TAPCELL_ROW_53_1008 VGND VPWR sky130_fd_sc_hd__tapvpwrvgnd_1
Xg_row\[0\].g_col\[0\].pe__2688__1422 VGND VGND VPWR VPWR g_row\[0\].g_col\[0\].pe__2688__1422/HI
+ g_row\[0\].g_col\[0\].pe__2688_/CIN sky130_fd_sc_hd__conb_1
Xg_row\[1\].g_col\[1\].pe__2769_ _301_/CLK g_row\[1\].g_col\[1\].pe__2769_/D VGND
+ VGND VPWR VPWR g_row\[1\].g_col\[1\].pe__2769_/Q sky130_fd_sc_hd__dfxtp_2
Xg_row\[1\].g_col\[0\].pe_hold3090 g_row\[1\].g_col\[0\].pe__2734_/Q VGND VGND VPWR
+ VPWR g_row\[1\].g_col\[0\].pe_hold3090/X sky130_fd_sc_hd__clkbuf_2
XFILLER_46_417 VGND VGND VPWR VPWR sky130_fd_sc_hd__decap_3
XFILLER_73_225 VGND VGND VPWR VPWR sky130_fd_sc_hd__fill_1
XFILLER_74_737 VGND VGND VPWR VPWR sky130_fd_sc_hd__decap_3
XFILLER_74_748 VGND VGND VPWR VPWR sky130_fd_sc_hd__decap_3
XTAP_TAPCELL_ROW_29_648 VGND VPWR sky130_fd_sc_hd__tapvpwrvgnd_1
XFILLER_27_697 VGND VGND VPWR VPWR sky130_fd_sc_hd__decap_3
XFILLER_14_314 VGND VGND VPWR VPWR sky130_fd_sc_hd__fill_1
XFILLER_42_645 VGND VGND VPWR VPWR sky130_fd_sc_hd__fill_2
X_331_ _337_/CLK _331_/D VGND VGND VPWR VPWR _331_/Q sky130_fd_sc_hd__dfxtp_2
Xg_row\[0\].g_col\[1\].pe__1729_ g_row\[0\].g_col\[1\].pe__1782_/A2 g_row\[0\].g_col\[1\].pe__1729_/A2
+ g_row\[0\].g_col\[1\].pe__1729_/A3 g_row\[0\].g_col\[1\].pe__1729_/B1 g_row\[0\].g_col\[1\].pe__1761_/A2
+ VGND VGND VPWR VPWR g_row\[0\].g_col\[1\].pe__1730_/B sky130_fd_sc_hd__a32o_2
XFILLER_25_75 VGND VGND VPWR VPWR sky130_fd_sc_hd__fill_1
XFILLER_42_689 VGND VGND VPWR VPWR sky130_fd_sc_hd__fill_1
XTAP_TAPCELL_ROW_40_813 VGND VPWR sky130_fd_sc_hd__tapvpwrvgnd_1
XFILLER_41_30 VGND VGND VPWR VPWR sky130_fd_sc_hd__fill_1
X_193_ _205_/A _193_/B_N VGND VGND VPWR VPWR _193_/Y sky130_fd_sc_hd__nor2b_4
XFILLER_10_586 VGND VGND VPWR VPWR sky130_fd_sc_hd__fill_2
XFILLER_10_597 VGND VGND VPWR VPWR sky130_fd_sc_hd__fill_2
XTAP_TAPCELL_ROW_79_1391 VGND VPWR sky130_fd_sc_hd__tapvpwrvgnd_1
XTAP_TAPCELL_ROW_9_340 VGND VPWR sky130_fd_sc_hd__tapvpwrvgnd_1
XTAP_TAPCELL_ROW_9_351 VGND VPWR sky130_fd_sc_hd__tapvpwrvgnd_1
XFILLER_2_752 VGND VGND VPWR VPWR sky130_fd_sc_hd__decap_3
XTAP_TAPCELL_ROW_92_1591 VGND VPWR sky130_fd_sc_hd__tapvpwrvgnd_1
XFILLER_1_262 VGND VGND VPWR VPWR sky130_fd_sc_hd__decap_3
XFILLER_49_211 VGND VGND VPWR VPWR sky130_fd_sc_hd__fill_2
XFILLER_49_222 VGND VGND VPWR VPWR sky130_fd_sc_hd__fill_2
Xg_row\[1\].g_col\[0\].pe__2340_ g_row\[1\].g_col\[0\].pe__2121_/A g_row\[1\].g_col\[0\].pe__2363_/A2
+ g_row\[1\].g_col\[0\].pe__2388_/B g_row\[1\].g_col\[0\].pe__1965_/A VGND VGND VPWR
+ VPWR g_row\[1\].g_col\[0\].pe__2343_/A sky130_fd_sc_hd__a22o_2
XFILLER_49_299 VGND VGND VPWR VPWR sky130_fd_sc_hd__decap_3
XFILLER_64_225 VGND VGND VPWR VPWR sky130_fd_sc_hd__decap_3
XTAP_TAPCELL_ROW_48_924 VGND VPWR sky130_fd_sc_hd__tapvpwrvgnd_1
XTAP_TAPCELL_ROW_48_935 VGND VPWR sky130_fd_sc_hd__tapvpwrvgnd_1
Xg_row\[1\].g_col\[0\].pe__2271_ g_row\[1\].g_col\[0\].pe__2271_/A g_row\[1\].g_col\[0\].pe__2271_/B
+ VGND VGND VPWR VPWR g_row\[1\].g_col\[0\].pe__2295_/A sky130_fd_sc_hd__nor2_2
XFILLER_17_130 VGND VGND VPWR VPWR sky130_fd_sc_hd__fill_2
XFILLER_17_141 VGND VGND VPWR VPWR sky130_fd_sc_hd__decap_3
Xg_row\[0\].g_col\[0\].pe_hold3122 g_row\[0\].g_col\[0\].pe__2753_/Q VGND VGND VPWR
+ VPWR g_row\[0\].g_col\[0\].pe__2383_/A sky130_fd_sc_hd__clkbuf_2
XFILLER_18_697 VGND VGND VPWR VPWR sky130_fd_sc_hd__decap_3
XFILLER_33_623 VGND VGND VPWR VPWR sky130_fd_sc_hd__decap_3
XFILLER_45_483 VGND VGND VPWR VPWR sky130_fd_sc_hd__decap_3
XPHY_EDGE_ROW_25_Left_119 VGND VGND VPWR VPWR sky130_fd_sc_hd__decap_3
XANTENNA_18 b_inputs_flat[19] VGND VGND VPWR VPWR sky130_fd_sc_hd__diode_2
XANTENNA_29 clear_acc VGND VGND VPWR VPWR sky130_fd_sc_hd__diode_2
XFILLER_32_188 VGND VGND VPWR VPWR sky130_fd_sc_hd__decap_3
XFILLER_60_486 VGND VGND VPWR VPWR sky130_fd_sc_hd__decap_3
Xg_row\[0\].g_col\[0\].pe__2280_ g_row\[0\].g_col\[0\].pe__2364_/A g_row\[0\].g_col\[0\].pe__2280_/B
+ VGND VGND VPWR VPWR g_row\[0\].g_col\[0\].pe__2311_/B sky130_fd_sc_hd__xnor2_2
Xg_row\[0\].g_col\[0\].pe_hold1720 g_row\[0\].g_col\[0\].pe__2430_/A VGND VGND VPWR
+ VPWR g_row\[0\].g_col\[0\].pe__2334_/A2 sky130_fd_sc_hd__clkbuf_2
XFILLER_13_391 VGND VGND VPWR VPWR sky130_fd_sc_hd__fill_1
Xg_row\[0\].g_col\[0\].pe_hold1753 g_row\[0\].g_col\[0\].pe__2744_/Q VGND VGND VPWR
+ VPWR g_row\[0\].g_col\[0\].pe__2065_/A sky130_fd_sc_hd__clkbuf_2
XFILLER_70_3 VGND VGND VPWR VPWR sky130_fd_sc_hd__fill_1
Xg_row\[0\].g_col\[0\].pe_hold1797 g_row\[0\].g_col\[0\].pe_hold3014/X VGND VGND VPWR
+ VPWR g_row\[0\].g_col\[0\].pe_hold3015/A sky130_fd_sc_hd__clkbuf_2
Xg_row\[1\].g_col\[0\].pe__1986_ g_row\[1\].g_col\[0\].pe__1985_/B g_row\[1\].g_col\[0\].pe__1985_/C
+ g_row\[1\].g_col\[0\].pe__1924_/A VGND VGND VPWR VPWR g_row\[1\].g_col\[0\].pe__1988_/C
+ sky130_fd_sc_hd__a21bo_2
XFILLER_5_590 VGND VGND VPWR VPWR sky130_fd_sc_hd__fill_1
XPHY_EDGE_ROW_34_Left_128 VGND VGND VPWR VPWR sky130_fd_sc_hd__decap_3
Xg_row\[1\].g_col\[1\].pe__2623_ place1246/X g_row\[1\].g_col\[1\].pe__2623_/B VGND
+ VGND VPWR VPWR g_row\[1\].g_col\[1\].pe__2623_/X sky130_fd_sc_hd__or2_2
Xg_row\[1\].g_col\[0\].pe__2607_ g_row\[1\].g_col\[0\].pe__2639_/A place1099/X VGND
+ VGND VPWR VPWR g_row\[1\].g_col\[0\].pe__2607_/X sky130_fd_sc_hd__or2_2
Xg_row\[1\].g_col\[1\].pe__2554_ g_row\[1\].g_col\[1\].pe__2554_/A1 g_row\[1\].g_col\[1\].pe__2568_/A2
+ g_row\[1\].g_col\[1\].pe__2568_/B1 g_row\[1\].g_col\[1\].pe__2553_/X VGND VGND VPWR
+ VPWR g_row\[1\].g_col\[1\].pe__2554_/X sky130_fd_sc_hd__a22o_2
Xg_row\[0\].g_col\[0\].pe__1995_ g_row\[0\].g_col\[0\].pe__1931_/A g_row\[0\].g_col\[0\].pe__1931_/B
+ g_row\[0\].g_col\[0\].pe__1994_/Y VGND VGND VPWR VPWR g_row\[0\].g_col\[0\].pe__2055_/B
+ sky130_fd_sc_hd__a21oi_2
Xg_row\[1\].g_col\[0\].pe__2538_ g_row\[1\].g_col\[0\].pe__2538_/A g_row\[1\].g_col\[0\].pe__2538_/B
+ g_row\[1\].g_col\[0\].pe__2538_/C VGND VGND VPWR VPWR g_row\[1\].g_col\[0\].pe__2544_/B
+ sky130_fd_sc_hd__nand3_2
XFILLER_55_225 VGND VGND VPWR VPWR sky130_fd_sc_hd__decap_3
XFILLER_68_597 VGND VGND VPWR VPWR sky130_fd_sc_hd__decap_3
XFILLER_83_501 VGND VGND VPWR VPWR sky130_fd_sc_hd__decap_3
Xg_row\[1\].g_col\[1\].pe__2485_ g_row\[1\].g_col\[1\].pe__2754_/Q g_row\[1\].g_col\[1\].pe__2422_/A
+ g_row\[1\].g_col\[1\].pe__2484_/Y g_row\[1\].g_col\[1\].pe__1348_/A VGND VGND VPWR
+ VPWR g_row\[1\].g_col\[1\].pe__2486_/B sky130_fd_sc_hd__o211a_2
Xg_row\[1\].g_col\[0\].pe__2469_ g_row\[1\].g_col\[0\].pe__2439_/Y g_row\[1\].g_col\[0\].pe__2763_/Q
+ VGND VGND VPWR VPWR g_row\[1\].g_col\[0\].pe__2496_/B sky130_fd_sc_hd__and2b_2
Xg_row\[0\].g_col\[1\].pe__2701_ clkbuf_leaf_6_clk/X g_row\[0\].g_col\[1\].pe__2701_/D
+ VGND VGND VPWR VPWR g_row\[0\].g_col\[1\].pe__2701_/Q sky130_fd_sc_hd__dfxtp_2
XFILLER_71_707 VGND VGND VPWR VPWR sky130_fd_sc_hd__fill_2
Xg_row\[1\].g_col\[1\].pe__1436_ g_row\[1\].g_col\[1\].pe__2215_/B2 g_row\[1\].g_col\[1\].pe__1729_/A2
+ g_row\[1\].g_col\[1\].pe__1729_/A3 g_row\[1\].g_col\[1\].pe__1729_/B1 g_row\[1\].g_col\[1\].pe__1608_/A1
+ VGND VGND VPWR VPWR g_row\[1\].g_col\[1\].pe__1437_/B sky130_fd_sc_hd__a32o_2
Xg_row\[0\].g_col\[1\].pe_hold2039 g_row\[0\].g_col\[1\].pe__2757_/Q VGND VGND VPWR
+ VPWR g_row\[0\].g_col\[1\].pe__2521_/A1 sky130_fd_sc_hd__clkbuf_2
Xg_row\[0\].g_col\[1\].pe_hold2028 g_row\[0\].g_col\[1\].pe__2766_/Q VGND VGND VPWR
+ VPWR g_row\[0\].g_col\[1\].pe__2572_/A1 sky130_fd_sc_hd__clkbuf_2
XFILLER_36_472 VGND VGND VPWR VPWR sky130_fd_sc_hd__decap_3
XFILLER_43_409 VGND VGND VPWR VPWR sky130_fd_sc_hd__fill_2
XFILLER_71_729 VGND VGND VPWR VPWR sky130_fd_sc_hd__fill_1
XTAP_TAPCELL_ROW_26_607 VGND VPWR sky130_fd_sc_hd__tapvpwrvgnd_1
Xg_row\[0\].g_col\[0\].pe__2616_ g_row\[0\].g_col\[0\].pe__2623_/A place1208/A VGND
+ VGND VPWR VPWR g_row\[0\].g_col\[0\].pe__2616_/X sky130_fd_sc_hd__or2_2
Xg_row\[1\].g_col\[1\].pe__1367_ g_row\[1\].g_col\[1\].pe__2768_/Q g_row\[1\].g_col\[1\].pe__1366_/B
+ g_row\[1\].g_col\[1\].pe__2776_/A VGND VGND VPWR VPWR g_row\[1\].g_col\[1\].pe__1368_/B
+ sky130_fd_sc_hd__o21ai_2
Xg_row\[0\].g_col\[1\].pe__2632_ place1249/X g_row\[0\].g_col\[1\].pe__2632_/B VGND
+ VGND VPWR VPWR g_row\[0\].g_col\[1\].pe__2632_/X sky130_fd_sc_hd__or2_2
XFILLER_23_111 VGND VGND VPWR VPWR sky130_fd_sc_hd__fill_1
XFILLER_36_483 VGND VGND VPWR VPWR sky130_fd_sc_hd__fill_1
XPHY_EDGE_ROW_43_Left_137 VGND VGND VPWR VPWR sky130_fd_sc_hd__decap_3
Xg_row\[0\].g_col\[1\].pe__2563_ g_row\[0\].g_col\[1\].pe__2586_/A g_row\[0\].g_col\[1\].pe__2505_/X
+ VGND VGND VPWR VPWR g_row\[0\].g_col\[1\].pe__2563_/X sky130_fd_sc_hd__or2b_2
XFILLER_23_155 VGND VGND VPWR VPWR sky130_fd_sc_hd__decap_3
XFILLER_24_667 VGND VGND VPWR VPWR sky130_fd_sc_hd__decap_3
XFILLER_62_29 VGND VGND VPWR VPWR sky130_fd_sc_hd__fill_2
Xg_row\[0\].g_col\[0\].pe__2547_ g_row\[0\].g_col\[0\].pe__2559_/A g_row\[0\].g_col\[0\].pe__2547_/B
+ g_row\[0\].g_col\[0\].pe__2546_/Y VGND VGND VPWR VPWR g_row\[0\].g_col\[0\].pe__2547_/X
+ sky130_fd_sc_hd__or3b_2
Xg_row\[0\].g_col\[1\].pe__1514_ g_row\[0\].g_col\[1\].pe__1514_/A g_row\[0\].g_col\[1\].pe__1514_/B
+ VGND VGND VPWR VPWR g_row\[0\].g_col\[1\].pe__1514_/X sky130_fd_sc_hd__and2_2
XFILLER_23_166 VGND VGND VPWR VPWR sky130_fd_sc_hd__fill_2
XFILLER_51_475 VGND VGND VPWR VPWR sky130_fd_sc_hd__decap_3
Xg_row\[0\].g_col\[0\].pe__2478_ g_row\[0\].g_col\[0\].pe__2478_/A g_row\[0\].g_col\[0\].pe__2478_/B
+ VGND VGND VPWR VPWR g_row\[0\].g_col\[0\].pe__2579_/A sky130_fd_sc_hd__xnor2_2
Xg_row\[0\].g_col\[1\].pe__2494_ g_row\[0\].g_col\[1\].pe__2494_/A g_row\[0\].g_col\[1\].pe__2494_/B
+ VGND VGND VPWR VPWR g_row\[0\].g_col\[1\].pe__2585_/B sky130_fd_sc_hd__or2_4
Xg_row\[0\].g_col\[0\].pe__1429_ g_row\[0\].g_col\[0\].pe__1650_/A g_row\[0\].g_col\[0\].pe__1650_/B
+ g_row\[0\].g_col\[0\].pe__1428_/X VGND VGND VPWR VPWR g_row\[0\].g_col\[0\].pe__1479_/A
+ sky130_fd_sc_hd__a21oi_2
Xg_row\[0\].g_col\[1\].pe__1376_ g_row\[0\].g_col\[1\].pe__2674_/B g_row\[0\].g_col\[1\].pe__2680_/B
+ VGND VGND VPWR VPWR g_row\[0\].g_col\[1\].pe__1376_/X sky130_fd_sc_hd__or2_2
XFILLER_3_505 VGND VGND VPWR VPWR sky130_fd_sc_hd__fill_1
XPHY_EDGE_ROW_52_Left_146 VGND VGND VPWR VPWR sky130_fd_sc_hd__decap_3
XFILLER_74_567 VGND VGND VPWR VPWR sky130_fd_sc_hd__decap_3
XFILLER_36_63 VGND VGND VPWR VPWR sky130_fd_sc_hd__fill_2
XFILLER_61_217 VGND VGND VPWR VPWR sky130_fd_sc_hd__decap_3
XPHY_EDGE_ROW_61_Left_155 VGND VGND VPWR VPWR sky130_fd_sc_hd__decap_3
XFILLER_15_645 VGND VGND VPWR VPWR sky130_fd_sc_hd__fill_2
XFILLER_36_85 VGND VGND VPWR VPWR sky130_fd_sc_hd__fill_2
XFILLER_70_740 VGND VGND VPWR VPWR sky130_fd_sc_hd__decap_3
Xg_row\[0\].g_col\[1\].pe_hold1850 g_row\[0\].g_col\[1\].pe__2762_/Q VGND VGND VPWR
+ VPWR g_row\[0\].g_col\[1\].pe__2554_/A1 sky130_fd_sc_hd__clkbuf_2
XFILLER_42_464 VGND VGND VPWR VPWR sky130_fd_sc_hd__fill_2
XFILLER_30_615 VGND VGND VPWR VPWR sky130_fd_sc_hd__fill_2
XFILLER_30_637 VGND VGND VPWR VPWR sky130_fd_sc_hd__decap_3
XFILLER_70_795 VGND VGND VPWR VPWR sky130_fd_sc_hd__fill_1
X_314_ _314_/CLK _314_/D VGND VGND VPWR VPWR _314_/Q sky130_fd_sc_hd__dfxtp_2
XFILLER_30_648 VGND VGND VPWR VPWR sky130_fd_sc_hd__fill_2
X_245_ _267_/A _245_/B_N VGND VGND VPWR VPWR _245_/Y sky130_fd_sc_hd__nor2b_4
XFILLER_7_833 VGND VGND VPWR VPWR sky130_fd_sc_hd__fill_1
XTAP_TAPCELL_ROW_12_389 VGND VPWR sky130_fd_sc_hd__tapvpwrvgnd_1
Xg_row\[1\].g_col\[0\].pe__1840_ g_row\[1\].g_col\[0\].pe__1840_/A g_row\[1\].g_col\[0\].pe__1840_/B
+ VGND VGND VPWR VPWR g_row\[1\].g_col\[0\].pe__1841_/A sky130_fd_sc_hd__nor2_2
XFILLER_6_354 VGND VGND VPWR VPWR sky130_fd_sc_hd__fill_2
XPHY_EDGE_ROW_70_Left_164 VGND VGND VPWR VPWR sky130_fd_sc_hd__decap_3
Xg_row\[1\].g_col\[0\].pe__1771_ g_row\[1\].g_col\[0\].pe__1793_/B g_row\[1\].g_col\[0\].pe__1793_/C
+ g_row\[1\].g_col\[0\].pe__1793_/A VGND VGND VPWR VPWR g_row\[1\].g_col\[0\].pe__1794_/A
+ sky130_fd_sc_hd__a21oi_2
XFILLER_2_571 VGND VGND VPWR VPWR sky130_fd_sc_hd__decap_3
XFILLER_78_840 VGND VGND VPWR VPWR sky130_fd_sc_hd__fill_2
XFILLER_84_309 VGND VGND VPWR VPWR sky130_fd_sc_hd__fill_2
XFILLER_93_810 VGND VGND VPWR VPWR sky130_fd_sc_hd__fill_2
Xg_row\[0\].g_col\[0\].pe__1780_ g_row\[0\].g_col\[0\].pe__1780_/A g_row\[0\].g_col\[0\].pe__1794_/A
+ VGND VGND VPWR VPWR g_row\[0\].g_col\[0\].pe__1780_/Y sky130_fd_sc_hd__nor2_2
Xg_row\[1\].g_col\[0\].pe__2323_ g_row\[1\].g_col\[0\].pe__2337_/A g_row\[1\].g_col\[0\].pe__2323_/B
+ VGND VGND VPWR VPWR g_row\[1\].g_col\[0\].pe__2325_/A sky130_fd_sc_hd__xnor2_2
XFILLER_37_225 VGND VGND VPWR VPWR sky130_fd_sc_hd__fill_1
Xg_row\[1\].g_col\[1\].pe__2270_ g_row\[1\].g_col\[1\].pe__2330_/A g_row\[1\].g_col\[1\].pe__2330_/B
+ VGND VGND VPWR VPWR g_row\[1\].g_col\[1\].pe__2297_/A sky130_fd_sc_hd__nor2_2
XFILLER_52_206 VGND VGND VPWR VPWR sky130_fd_sc_hd__fill_1
Xg_row\[1\].g_col\[0\].pe__2254_ g_row\[1\].g_col\[0\].pe__2221_/A g_row\[1\].g_col\[0\].pe__2221_/B
+ g_row\[1\].g_col\[0\].pe__2253_/Y VGND VGND VPWR VPWR g_row\[1\].g_col\[0\].pe__2271_/B
+ sky130_fd_sc_hd__o21a_2
Xg_row\[0\].g_col\[0\].pe__2401_ g_row\[0\].g_col\[0\].pe__2010_/A g_row\[0\].g_col\[0\].pe__2401_/A2
+ g_row\[0\].g_col\[0\].pe__2398_/X g_row\[0\].g_col\[0\].pe__2399_/Y g_row\[0\].g_col\[0\].pe__2676_/A
+ VGND VGND VPWR VPWR g_row\[0\].g_col\[0\].pe__2401_/X sky130_fd_sc_hd__o32a_2
Xg_row\[1\].g_col\[0\].pe__2185_ g_row\[1\].g_col\[0\].pe__2184_/X g_row\[1\].g_col\[0\].pe__2144_/B
+ g_row\[1\].g_col\[0\].pe__2135_/A VGND VGND VPWR VPWR g_row\[1\].g_col\[0\].pe__2186_/B
+ sky130_fd_sc_hd__o21a_2
XFILLER_21_637 VGND VGND VPWR VPWR sky130_fd_sc_hd__fill_2
XFILLER_61_795 VGND VGND VPWR VPWR sky130_fd_sc_hd__fill_2
Xg_row\[0\].g_col\[0\].pe__2332_ g_row\[0\].g_col\[0\].pe__2304_/A g_row\[0\].g_col\[0\].pe__2304_/B
+ g_row\[0\].g_col\[0\].pe__2304_/C g_row\[0\].g_col\[0\].pe__2329_/Y g_row\[0\].g_col\[0\].pe__2305_/A
+ VGND VGND VPWR VPWR g_row\[0\].g_col\[0\].pe__2358_/A sky130_fd_sc_hd__a311o_4
Xg_row\[0\].g_col\[0\].pe__2263_ g_row\[0\].g_col\[0\].pe__2261_/Y g_row\[0\].g_col\[0\].pe__2263_/B
+ VGND VGND VPWR VPWR g_row\[0\].g_col\[0\].pe__2263_/X sky130_fd_sc_hd__and2b_2
Xg_row\[0\].g_col\[0\].pe_hold2273 g_row\[0\].g_col\[0\].pe__2642_/X VGND VGND VPWR
+ VPWR g_row\[0\].g_col\[0\].pe__2706_/D sky130_fd_sc_hd__clkbuf_2
Xg_row\[0\].g_col\[0\].pe_hold2284 g_row\[0\].g_col\[0\].pe_hold3084/X VGND VGND VPWR
+ VPWR g_row\[0\].g_col\[0\].pe__1380_/A1 sky130_fd_sc_hd__clkbuf_2
Xg_row\[0\].g_col\[0\].pe_hold2295 g_row\[0\].g_col\[0\].pe__2640_/X VGND VGND VPWR
+ VPWR g_row\[0\].g_col\[0\].pe__2705_/D sky130_fd_sc_hd__clkbuf_2
Xg_row\[0\].g_col\[1\].pe_place854 g_row\[0\].g_col\[1\].pe__2010_/A VGND VGND VPWR
+ VPWR g_row\[0\].g_col\[1\].pe__2404_/B2 sky130_fd_sc_hd__buf_6
XTAP_TAPCELL_ROW_31_676 VGND VPWR sky130_fd_sc_hd__tapvpwrvgnd_1
Xg_row\[0\].g_col\[0\].pe__2194_ g_row\[0\].g_col\[0\].pe__2202_/A g_row\[0\].g_col\[0\].pe__2202_/B
+ VGND VGND VPWR VPWR g_row\[0\].g_col\[0\].pe__2231_/B sky130_fd_sc_hd__xor2_2
Xg_row\[1\].g_col\[1\].pe__1985_ g_row\[1\].g_col\[1\].pe__2094_/A g_row\[1\].g_col\[1\].pe__1985_/B
+ g_row\[1\].g_col\[1\].pe__1985_/C VGND VGND VPWR VPWR g_row\[1\].g_col\[1\].pe__1988_/B
+ sky130_fd_sc_hd__nand3b_2
Xg_row\[1\].g_col\[0\].pe__1969_ g_row\[1\].g_col\[0\].pe__1968_/B g_row\[1\].g_col\[0\].pe__1968_/C
+ g_row\[1\].g_col\[0\].pe__1460_/B VGND VGND VPWR VPWR g_row\[1\].g_col\[0\].pe__1974_/B
+ sky130_fd_sc_hd__a21bo_2
Xhold3403 b_inputs_flat[10] VGND VGND VPWR VPWR hold3403/X sky130_fd_sc_hd__clkbuf_2
Xhold3425 hold3425/A VGND VGND VPWR VPWR hold3425/X sky130_fd_sc_hd__clkbuf_2
Xhold3414 hold3414/A VGND VGND VPWR VPWR hold3414/X sky130_fd_sc_hd__clkbuf_2
Xhold2702 hold3487/X VGND VGND VPWR VPWR hold3488/A sky130_fd_sc_hd__clkbuf_2
Xhold2713 hold2713/A VGND VGND VPWR VPWR _282_/D sky130_fd_sc_hd__clkbuf_2
Xoutput1386 output1386/A VGND VGND VPWR VPWR results_flat[38] sky130_fd_sc_hd__buf_2
Xoutput1375 output1375/A VGND VGND VPWR VPWR results_flat[28] sky130_fd_sc_hd__buf_2
Xoutput1364 output1364/A VGND VGND VPWR VPWR results_flat[18] sky130_fd_sc_hd__buf_2
Xhold3458 hold3458/A VGND VGND VPWR VPWR hold3458/X sky130_fd_sc_hd__clkbuf_2
Xhold3447 hold3447/A VGND VGND VPWR VPWR hold3447/X sky130_fd_sc_hd__clkbuf_2
Xhold3436 hold3436/A VGND VGND VPWR VPWR hold3436/X sky130_fd_sc_hd__clkbuf_2
Xhold2724 _183_/Y VGND VGND VPWR VPWR hold2724/X sky130_fd_sc_hd__clkbuf_2
Xhold2735 hold3500/X VGND VGND VPWR VPWR _217_/B_N sky130_fd_sc_hd__clkbuf_2
Xhold2746 hold3526/X VGND VGND VPWR VPWR hold3527/A sky130_fd_sc_hd__clkbuf_2
Xoutput1397 output1397/A VGND VGND VPWR VPWR results_flat[48] sky130_fd_sc_hd__buf_2
Xhold3469 hold3469/A VGND VGND VPWR VPWR hold3469/X sky130_fd_sc_hd__clkbuf_2
Xg_row\[1\].g_col\[1\].pe__2606_ g_row\[1\].g_col\[1\].pe__2633_/A1 place1102/X g_row\[1\].g_col\[1\].pe__2683_/C1
+ g_row\[1\].g_col\[1\].pe__2605_/X VGND VGND VPWR VPWR g_row\[1\].g_col\[1\].pe__2606_/X
+ sky130_fd_sc_hd__o211a_2
XFILLER_56_501 VGND VGND VPWR VPWR sky130_fd_sc_hd__fill_2
XFILLER_56_523 VGND VGND VPWR VPWR sky130_fd_sc_hd__fill_1
XFILLER_84_810 VGND VGND VPWR VPWR sky130_fd_sc_hd__fill_2
Xg_row\[0\].g_col\[0\].pe__1978_ g_row\[0\].g_col\[0\].pe__1978_/A g_row\[0\].g_col\[0\].pe__1978_/B
+ g_row\[0\].g_col\[0\].pe__1978_/C VGND VGND VPWR VPWR g_row\[0\].g_col\[0\].pe__1991_/A
+ sky130_fd_sc_hd__or3_4
Xhold2757 hold3549/X VGND VGND VPWR VPWR hold3550/A sky130_fd_sc_hd__clkbuf_2
Xhold2768 hold3541/X VGND VGND VPWR VPWR hold3542/A sky130_fd_sc_hd__clkbuf_2
Xhold2779 hold2779/A VGND VGND VPWR VPWR _277_/D sky130_fd_sc_hd__clkbuf_2
Xg_row\[0\].g_col\[1\].pe__1994_ g_row\[0\].g_col\[1\].pe__1994_/A g_row\[0\].g_col\[1\].pe__1994_/B
+ VGND VGND VPWR VPWR g_row\[0\].g_col\[1\].pe__1994_/Y sky130_fd_sc_hd__nor2_2
Xg_row\[1\].g_col\[1\].pe__2468_ g_row\[1\].g_col\[1\].pe__2538_/A g_row\[1\].g_col\[1\].pe__2538_/B
+ g_row\[1\].g_col\[1\].pe__2538_/C g_row\[1\].g_col\[1\].pe__2466_/X g_row\[1\].g_col\[1\].pe__2497_/A
+ VGND VGND VPWR VPWR g_row\[1\].g_col\[1\].pe__2551_/C sky130_fd_sc_hd__a311o_2
XFILLER_56_578 VGND VGND VPWR VPWR sky130_fd_sc_hd__fill_1
XFILLER_56_589 VGND VGND VPWR VPWR sky130_fd_sc_hd__decap_3
Xg_row\[1\].g_col\[1\].pe__1419_ g_row\[1\].g_col\[1\].pe__1730_/A g_row\[1\].g_col\[1\].pe__1419_/B
+ VGND VGND VPWR VPWR g_row\[1\].g_col\[1\].pe__1428_/B sky130_fd_sc_hd__xor2_2
XFILLER_37_792 VGND VGND VPWR VPWR sky130_fd_sc_hd__fill_1
XFILLER_71_526 VGND VGND VPWR VPWR sky130_fd_sc_hd__fill_2
XTAP_TAPCELL_ROW_39_798 VGND VPWR sky130_fd_sc_hd__tapvpwrvgnd_1
Xg_row\[1\].g_col\[1\].pe__2399_ g_row\[1\].g_col\[1\].pe__2754_/Q VGND VGND VPWR
+ VPWR g_row\[1\].g_col\[1\].pe__2399_/Y sky130_fd_sc_hd__inv_2
Xg_row\[0\].g_col\[1\].pe__2615_ g_row\[0\].g_col\[1\].pe__2624_/A1 place1209/X g_row\[0\].g_col\[1\].pe__2626_/B1
+ g_row\[0\].g_col\[1\].pe__2615_/C1 VGND VGND VPWR VPWR g_row\[0\].g_col\[1\].pe__2615_/X
+ sky130_fd_sc_hd__o211a_2
XFILLER_12_604 VGND VGND VPWR VPWR sky130_fd_sc_hd__decap_3
XFILLER_52_762 VGND VGND VPWR VPWR sky130_fd_sc_hd__fill_1
XFILLER_11_103 VGND VGND VPWR VPWR sky130_fd_sc_hd__fill_1
XFILLER_24_475 VGND VGND VPWR VPWR sky130_fd_sc_hd__fill_1
XFILLER_24_486 VGND VGND VPWR VPWR sky130_fd_sc_hd__fill_1
XTAP_TAPCELL_ROW_61_1118 VGND VPWR sky130_fd_sc_hd__tapvpwrvgnd_1
XTAP_TAPCELL_ROW_61_1129 VGND VPWR sky130_fd_sc_hd__tapvpwrvgnd_1
Xg_row\[0\].g_col\[1\].pe__2546_ g_row\[0\].g_col\[1\].pe__2546_/A g_row\[0\].g_col\[1\].pe__2546_/B
+ VGND VGND VPWR VPWR g_row\[0\].g_col\[1\].pe__2546_/Y sky130_fd_sc_hd__nand2_2
Xg_row\[0\].g_col\[1\].pe__2477_ g_row\[0\].g_col\[1\].pe__2487_/B g_row\[0\].g_col\[1\].pe__2490_/A
+ g_row\[0\].g_col\[1\].pe__2487_/A VGND VGND VPWR VPWR g_row\[0\].g_col\[1\].pe__2579_/C
+ sky130_fd_sc_hd__o21ai_2
XFILLER_11_169 VGND VGND VPWR VPWR sky130_fd_sc_hd__fill_2
XTAP_TAPCELL_ROW_50_963 VGND VPWR sky130_fd_sc_hd__tapvpwrvgnd_1
Xg_row\[0\].g_col\[1\].pe__1428_ g_row\[0\].g_col\[1\].pe__1428_/A g_row\[0\].g_col\[1\].pe__1428_/B
+ VGND VGND VPWR VPWR g_row\[0\].g_col\[1\].pe__1428_/X sky130_fd_sc_hd__and2_2
Xg_row\[0\].g_col\[1\].pe__1359_ g_row\[0\].g_col\[1\].pe__2765_/Q g_row\[0\].g_col\[1\].pe__1359_/B
+ VGND VGND VPWR VPWR output1372/A sky130_fd_sc_hd__xor2_2
XTAP_TAPCELL_ROW_76_1350 VGND VPWR sky130_fd_sc_hd__tapvpwrvgnd_1
XFILLER_3_346 VGND VGND VPWR VPWR sky130_fd_sc_hd__fill_1
XFILLER_79_615 VGND VGND VPWR VPWR sky130_fd_sc_hd__fill_1
XPHY_EDGE_ROW_5_Left_99 VGND VGND VPWR VPWR sky130_fd_sc_hd__decap_3
XFILLER_79_659 VGND VGND VPWR VPWR sky130_fd_sc_hd__decap_3
XFILLER_66_309 VGND VGND VPWR VPWR sky130_fd_sc_hd__fill_2
XFILLER_47_501 VGND VGND VPWR VPWR sky130_fd_sc_hd__decap_3
XFILLER_47_51 VGND VGND VPWR VPWR sky130_fd_sc_hd__fill_1
XFILLER_90_813 VGND VGND VPWR VPWR sky130_fd_sc_hd__decap_3
Xg_row\[0\].g_col\[1\].pe_hold2381 g_row\[0\].g_col\[1\].pe__2430_/A VGND VGND VPWR
+ VPWR g_row\[0\].g_col\[1\].pe__2334_/A2 sky130_fd_sc_hd__clkbuf_2
Xg_row\[0\].g_col\[1\].pe_hold2370 g_row\[0\].g_col\[1\].pe__1406_/Y VGND VGND VPWR
+ VPWR g_row\[0\].g_col\[1\].pe__2404_/B1 sky130_fd_sc_hd__clkbuf_2
XFILLER_27_291 VGND VGND VPWR VPWR sky130_fd_sc_hd__fill_2
XTAP_TAPCELL_ROW_17_459 VGND VPWR sky130_fd_sc_hd__tapvpwrvgnd_1
Xg_row\[0\].g_col\[1\].pe_hold2392 g_row\[0\].g_col\[1\].pe__2336_/Y VGND VGND VPWR
+ VPWR g_row\[0\].g_col\[1\].pe__2360_/A2 sky130_fd_sc_hd__clkbuf_2
XFILLER_30_456 VGND VGND VPWR VPWR sky130_fd_sc_hd__fill_1
X_159_ _165_/A _159_/B_N VGND VGND VPWR VPWR _159_/Y sky130_fd_sc_hd__nor2b_4
Xg_row\[1\].g_col\[0\].pe__1823_ g_row\[1\].g_col\[0\].pe__1823_/A g_row\[1\].g_col\[0\].pe__1823_/B
+ VGND VGND VPWR VPWR g_row\[1\].g_col\[0\].pe__1828_/A sky130_fd_sc_hd__xnor2_2
Xg_row\[1\].g_col\[1\].pe__1770_ g_row\[1\].g_col\[1\].pe__1770_/A g_row\[1\].g_col\[1\].pe__1770_/B
+ VGND VGND VPWR VPWR g_row\[1\].g_col\[1\].pe__1793_/A sky130_fd_sc_hd__xnor2_2
Xg_row\[1\].g_col\[0\].pe__1754_ place1104/A g_row\[1\].g_col\[0\].pe__1982_/B g_row\[1\].g_col\[0\].pe__1424_/Y
+ place1106/A VGND VGND VPWR VPWR g_row\[1\].g_col\[0\].pe__1755_/B sky130_fd_sc_hd__a22o_2
XFILLER_33_3 VGND VGND VPWR VPWR sky130_fd_sc_hd__decap_3
Xg_row\[1\].g_col\[0\].pe__1685_ g_row\[1\].g_col\[0\].pe__1733_/A g_row\[1\].g_col\[0\].pe__1685_/B
+ VGND VGND VPWR VPWR g_row\[1\].g_col\[0\].pe__1713_/B sky130_fd_sc_hd__xor2_2
Xg_row\[0\].g_col\[0\].pe__1901_ g_row\[0\].g_col\[0\].pe__1957_/B2 g_row\[0\].g_col\[0\].pe__2363_/A2
+ g_row\[0\].g_col\[0\].pe__2388_/B place1218/A VGND VGND VPWR VPWR g_row\[0\].g_col\[0\].pe__1905_/A
+ sky130_fd_sc_hd__a22o_2
Xg_row\[1\].g_col\[0\].pe_hold2900 g_row\[1\].g_col\[0\].pe_hold2900/A VGND VGND VPWR
+ VPWR g_row\[1\].g_col\[0\].pe__2615_/A2 sky130_fd_sc_hd__clkbuf_2
Xg_row\[0\].g_col\[0\].pe__1832_ g_row\[0\].g_col\[0\].pe__1840_/A g_row\[0\].g_col\[0\].pe__1832_/B
+ g_row\[0\].g_col\[0\].pe__1832_/C VGND VGND VPWR VPWR g_row\[0\].g_col\[0\].pe__1832_/Y
+ sky130_fd_sc_hd__nand3_2
Xg_row\[1\].g_col\[0\].pe_hold2966 g_row\[1\].g_col\[0\].pe_hold2966/A VGND VGND VPWR
+ VPWR g_row\[1\].g_col\[0\].pe__2608_/A2 sky130_fd_sc_hd__clkbuf_2
Xg_row\[1\].g_col\[1\].pe__2322_ g_row\[1\].g_col\[1\].pe__2337_/B g_row\[1\].g_col\[1\].pe__2337_/C
+ VGND VGND VPWR VPWR g_row\[1\].g_col\[1\].pe__2323_/B sky130_fd_sc_hd__nor2_2
XFILLER_38_578 VGND VGND VPWR VPWR sky130_fd_sc_hd__decap_3
XFILLER_81_813 VGND VGND VPWR VPWR sky130_fd_sc_hd__fill_2
XFILLER_93_651 VGND VGND VPWR VPWR sky130_fd_sc_hd__fill_1
Xg_row\[0\].g_col\[0\].pe__1763_ hold2363/A g_row\[0\].g_col\[0\].pe__1784_/A2 g_row\[0\].g_col\[0\].pe__1784_/A3
+ g_row\[0\].g_col\[0\].pe__1784_/B1 place1218/X VGND VGND VPWR VPWR g_row\[0\].g_col\[0\].pe__1764_/B
+ sky130_fd_sc_hd__a32o_2
Xg_row\[1\].g_col\[0\].pe__2306_ g_row\[1\].g_col\[0\].pe__2663_/A g_row\[1\].g_col\[0\].pe__2306_/A2
+ g_row\[1\].g_col\[0\].pe__2010_/A g_row\[1\].g_col\[0\].pe__2305_/Y VGND VGND VPWR
+ VPWR g_row\[1\].g_col\[0\].pe__2306_/X sky130_fd_sc_hd__o22a_2
XFILLER_81_835 VGND VGND VPWR VPWR sky130_fd_sc_hd__fill_1
Xg_row\[0\].g_col\[0\].pe__1694_ g_row\[0\].g_col\[0\].pe__1695_/A g_row\[0\].g_col\[0\].pe__1695_/B
+ VGND VGND VPWR VPWR g_row\[0\].g_col\[0\].pe__1703_/B sky130_fd_sc_hd__xor2_2
Xg_row\[1\].g_col\[1\].pe__2253_ g_row\[1\].g_col\[1\].pe__2253_/A g_row\[1\].g_col\[1\].pe__2253_/B
+ VGND VGND VPWR VPWR g_row\[1\].g_col\[1\].pe__2253_/Y sky130_fd_sc_hd__nand2_2
Xg_row\[1\].g_col\[0\].pe__2237_ place1271/X g_row\[1\].g_col\[0\].pe__2237_/B VGND
+ VGND VPWR VPWR g_row\[1\].g_col\[0\].pe__2747_/D sky130_fd_sc_hd__nor2_2
XFILLER_34_740 VGND VGND VPWR VPWR sky130_fd_sc_hd__fill_1
XTAP_TAPCELL_ROW_36_746 VGND VPWR sky130_fd_sc_hd__tapvpwrvgnd_1
XTAP_TAPCELL_ROW_36_757 VGND VPWR sky130_fd_sc_hd__tapvpwrvgnd_1
Xg_row\[1\].g_col\[1\].pe__2184_ g_row\[1\].g_col\[1\].pe__2222_/A g_row\[1\].g_col\[1\].pe__2184_/B
+ g_row\[1\].g_col\[1\].pe__2184_/C VGND VGND VPWR VPWR g_row\[1\].g_col\[1\].pe__2184_/X
+ sky130_fd_sc_hd__and3b_2
XFILLER_61_581 VGND VGND VPWR VPWR sky130_fd_sc_hd__fill_2
Xg_row\[1\].g_col\[0\].pe__2168_ g_row\[1\].g_col\[0\].pe__2167_/B g_row\[1\].g_col\[0\].pe__2167_/C
+ g_row\[1\].g_col\[0\].pe__2167_/A VGND VGND VPWR VPWR g_row\[1\].g_col\[0\].pe__2169_/B
+ sky130_fd_sc_hd__a21o_2
Xg_row\[0\].g_col\[0\].pe__2315_ g_row\[0\].g_col\[0\].pe__2316_/A g_row\[0\].g_col\[0\].pe__2316_/B
+ VGND VGND VPWR VPWR g_row\[0\].g_col\[0\].pe__2347_/A sky130_fd_sc_hd__and2_2
Xg_row\[1\].g_col\[0\].pe__2099_ g_row\[1\].g_col\[0\].pe__2099_/A g_row\[1\].g_col\[0\].pe__2184_/B
+ g_row\[1\].g_col\[0\].pe__2099_/C VGND VGND VPWR VPWR g_row\[1\].g_col\[0\].pe__2145_/A
+ sky130_fd_sc_hd__and3_4
Xg_row\[0\].g_col\[1\].pe__2331_ g_row\[0\].g_col\[1\].pe__2305_/A g_row\[0\].g_col\[1\].pe__2305_/B
+ g_row\[0\].g_col\[1\].pe__2329_/Y g_row\[0\].g_col\[1\].pe__2330_/X VGND VGND VPWR
+ VPWR g_row\[0\].g_col\[1\].pe__2331_/X sky130_fd_sc_hd__o211a_2
XFILLER_21_478 VGND VGND VPWR VPWR sky130_fd_sc_hd__decap_3
Xg_row\[0\].g_col\[1\].pe__2262_ g_row\[0\].g_col\[1\].pe__2262_/A g_row\[0\].g_col\[1\].pe__2262_/B
+ VGND VGND VPWR VPWR g_row\[0\].g_col\[1\].pe__2263_/B sky130_fd_sc_hd__nand2_2
Xg_row\[0\].g_col\[0\].pe__2246_ g_row\[0\].g_col\[0\].pe__2246_/A g_row\[0\].g_col\[0\].pe__2246_/B
+ VGND VGND VPWR VPWR g_row\[0\].g_col\[0\].pe__2273_/A sky130_fd_sc_hd__xnor2_2
Xg_row\[0\].g_col\[0\].pe__2177_ g_row\[0\].g_col\[0\].pe__2215_/B2 g_row\[0\].g_col\[0\].pe__2278_/A2
+ g_row\[0\].g_col\[0\].pe__2278_/B1 place1208/A VGND VGND VPWR VPWR g_row\[0\].g_col\[0\].pe__2213_/A
+ sky130_fd_sc_hd__a22o_2
Xg_row\[0\].g_col\[1\].pe__2193_ g_row\[0\].g_col\[1\].pe__2147_/A g_row\[0\].g_col\[1\].pe__2147_/B
+ g_row\[0\].g_col\[1\].pe__2192_/Y VGND VGND VPWR VPWR g_row\[0\].g_col\[1\].pe__2202_/B
+ sky130_fd_sc_hd__a21oi_4
Xhold3200 b_inputs_flat[31] VGND VGND VPWR VPWR hold3200/X sky130_fd_sc_hd__clkbuf_2
Xg_row\[1\].g_col\[1\].pe_hold1817 g_row\[1\].g_col\[1\].pe__2548_/X VGND VGND VPWR
+ VPWR g_row\[1\].g_col\[1\].pe__2549_/B sky130_fd_sc_hd__clkbuf_2
Xg_row\[1\].g_col\[1\].pe_hold1806 g_row\[1\].g_col\[1\].pe__2759_/Q VGND VGND VPWR
+ VPWR g_row\[1\].g_col\[1\].pe__2535_/A1 sky130_fd_sc_hd__clkbuf_2
Xg_row\[1\].g_col\[1\].pe__1968_ g_row\[1\].g_col\[1\].pe__2126_/B2 g_row\[1\].g_col\[1\].pe__1968_/B
+ g_row\[1\].g_col\[1\].pe__1968_/C VGND VGND VPWR VPWR g_row\[1\].g_col\[1\].pe__1974_/A
+ sky130_fd_sc_hd__nand3b_2
XTAP_TAPCELL_ROW_58_1080 VGND VPWR sky130_fd_sc_hd__tapvpwrvgnd_1
Xhold3211 hold3211/A VGND VGND VPWR VPWR hold3211/X sky130_fd_sc_hd__clkbuf_2
Xhold3222 hold3222/A VGND VGND VPWR VPWR hold3222/X sky130_fd_sc_hd__clkbuf_2
Xhold3233 hold3233/A VGND VGND VPWR VPWR hold3233/X sky130_fd_sc_hd__clkbuf_2
Xg_row\[1\].g_col\[1\].pe__1899_ g_row\[1\].g_col\[1\].pe__1899_/A g_row\[1\].g_col\[1\].pe__1899_/B
+ VGND VGND VPWR VPWR g_row\[1\].g_col\[1\].pe__1899_/X sky130_fd_sc_hd__and2_2
Xhold2510 hold3298/X VGND VGND VPWR VPWR hold3299/A sky130_fd_sc_hd__clkbuf_2
Xhold2521 hold2521/A VGND VGND VPWR VPWR _279_/D sky130_fd_sc_hd__clkbuf_2
Xhold3244 hold3244/A VGND VGND VPWR VPWR hold3244/X sky130_fd_sc_hd__clkbuf_2
Xhold3255 hold3255/A VGND VGND VPWR VPWR hold3255/X sky130_fd_sc_hd__clkbuf_2
Xhold3266 hold3266/A VGND VGND VPWR VPWR hold3266/X sky130_fd_sc_hd__clkbuf_2
XFILLER_48_309 VGND VGND VPWR VPWR sky130_fd_sc_hd__decap_3
XTAP_TAPCELL_ROW_71_1280 VGND VPWR sky130_fd_sc_hd__tapvpwrvgnd_1
Xhold2532 _239_/Y VGND VGND VPWR VPWR hold2532/X sky130_fd_sc_hd__clkbuf_2
Xhold2543 hold3290/X VGND VGND VPWR VPWR _237_/B_N sky130_fd_sc_hd__clkbuf_2
Xhold2554 hold3316/X VGND VGND VPWR VPWR hold3317/A sky130_fd_sc_hd__clkbuf_2
Xhold2565 hold3321/X VGND VGND VPWR VPWR hold3322/A sky130_fd_sc_hd__clkbuf_2
Xhold3277 b_inputs_flat[16] VGND VGND VPWR VPWR hold3277/X sky130_fd_sc_hd__clkbuf_2
Xhold3288 hold3288/A VGND VGND VPWR VPWR hold3288/X sky130_fd_sc_hd__clkbuf_2
Xhold3299 hold3299/A VGND VGND VPWR VPWR hold3299/X sky130_fd_sc_hd__clkbuf_2
XFILLER_29_534 VGND VGND VPWR VPWR sky130_fd_sc_hd__decap_3
XFILLER_56_320 VGND VGND VPWR VPWR sky130_fd_sc_hd__decap_3
Xhold2576 hold3305/X VGND VGND VPWR VPWR hold3306/A sky130_fd_sc_hd__clkbuf_2
Xhold2587 hold2587/A VGND VGND VPWR VPWR _323_/D sky130_fd_sc_hd__clkbuf_2
Xhold2598 _231_/Y VGND VGND VPWR VPWR hold2598/X sky130_fd_sc_hd__clkbuf_2
XFILLER_17_729 VGND VGND VPWR VPWR sky130_fd_sc_hd__fill_1
XFILLER_29_589 VGND VGND VPWR VPWR sky130_fd_sc_hd__decap_3
Xg_row\[0\].g_col\[1\].pe__1977_ g_row\[0\].g_col\[1\].pe__1977_/A g_row\[0\].g_col\[1\].pe__1977_/B
+ VGND VGND VPWR VPWR g_row\[0\].g_col\[1\].pe__1978_/C sky130_fd_sc_hd__xnor2_2
XFILLER_44_537 VGND VGND VPWR VPWR sky130_fd_sc_hd__fill_1
XFILLER_84_695 VGND VGND VPWR VPWR sky130_fd_sc_hd__fill_1
XFILLER_25_751 VGND VGND VPWR VPWR sky130_fd_sc_hd__decap_3
XFILLER_44_559 VGND VGND VPWR VPWR sky130_fd_sc_hd__fill_2
XTAP_TAPCELL_ROW_14_418 VGND VPWR sky130_fd_sc_hd__tapvpwrvgnd_1
Xg_row\[0\].g_col\[1\].pe__2529_ g_row\[0\].g_col\[1\].pe__2595_/A g_row\[0\].g_col\[1\].pe__2529_/B
+ VGND VGND VPWR VPWR g_row\[0\].g_col\[1\].pe__2758_/D sky130_fd_sc_hd__and2_2
XFILLER_33_97 VGND VGND VPWR VPWR sky130_fd_sc_hd__fill_2
XFILLER_79_434 VGND VGND VPWR VPWR sky130_fd_sc_hd__fill_1
XFILLER_79_467 VGND VGND VPWR VPWR sky130_fd_sc_hd__fill_1
XFILLER_66_117 VGND VGND VPWR VPWR sky130_fd_sc_hd__fill_1
Xg_row\[1\].g_col\[0\].pe__1470_ g_row\[1\].g_col\[0\].pe__2733_/Q g_row\[1\].g_col\[0\].pe__2250_/A
+ VGND VGND VPWR VPWR g_row\[1\].g_col\[0\].pe__1471_/B sky130_fd_sc_hd__or2_2
XFILLER_66_139 VGND VGND VPWR VPWR sky130_fd_sc_hd__fill_1
XTAP_TAPCELL_ROW_89_1541 VGND VPWR sky130_fd_sc_hd__tapvpwrvgnd_1
XFILLER_74_150 VGND VGND VPWR VPWR sky130_fd_sc_hd__fill_1
XFILLER_75_673 VGND VGND VPWR VPWR sky130_fd_sc_hd__fill_1
XTAP_TAPCELL_ROW_89_1552 VGND VPWR sky130_fd_sc_hd__tapvpwrvgnd_1
XFILLER_74_161 VGND VGND VPWR VPWR sky130_fd_sc_hd__decap_3
XFILLER_35_559 VGND VGND VPWR VPWR sky130_fd_sc_hd__fill_1
Xg_row\[1\].g_col\[0\].pe__2022_ g_row\[1\].g_col\[0\].pe__2071_/A g_row\[1\].g_col\[0\].pe__2071_/B
+ VGND VGND VPWR VPWR g_row\[1\].g_col\[0\].pe__2023_/B sky130_fd_sc_hd__xor2_2
XTAP_TAPCELL_ROW_33_705 VGND VPWR sky130_fd_sc_hd__tapvpwrvgnd_1
XFILLER_30_253 VGND VGND VPWR VPWR sky130_fd_sc_hd__decap_3
Xg_row\[0\].g_col\[0\].pe__2100_ g_row\[0\].g_col\[0\].pe__2099_/A g_row\[0\].g_col\[0\].pe__2184_/B
+ g_row\[0\].g_col\[0\].pe__2099_/C VGND VGND VPWR VPWR g_row\[0\].g_col\[0\].pe__2101_/C
+ sky130_fd_sc_hd__a21oi_2
Xg_row\[0\].g_col\[0\].pe__2031_ g_row\[0\].g_col\[0\].pe__1461_/A g_row\[0\].g_col\[0\].pe__1461_/B
+ g_row\[0\].g_col\[0\].pe__1970_/A VGND VGND VPWR VPWR g_row\[0\].g_col\[0\].pe__2032_/C
+ sky130_fd_sc_hd__a21bo_2
Xplace1104 place1104/A VGND VGND VPWR VPWR place1104/X sky130_fd_sc_hd__buf_6
Xg_row\[1\].g_col\[1\].pe__1822_ g_row\[1\].g_col\[1\].pe__1818_/B g_row\[1\].g_col\[1\].pe__1819_/B
+ g_row\[1\].g_col\[1\].pe__1822_/C g_row\[1\].g_col\[1\].pe__1822_/D VGND VGND VPWR
+ VPWR g_row\[1\].g_col\[1\].pe__1822_/X sky130_fd_sc_hd__and4bb_2
Xg_row\[1\].g_col\[0\].pe__1806_ g_row\[1\].g_col\[0\].pe__1801_/C g_row\[1\].g_col\[0\].pe__1806_/B
+ VGND VGND VPWR VPWR g_row\[1\].g_col\[0\].pe__1808_/C sky130_fd_sc_hd__and2b_2
Xg_row\[1\].g_col\[1\].pe__1753_ g_row\[1\].g_col\[1\].pe__1756_/A g_row\[1\].g_col\[1\].pe__1756_/B
+ VGND VGND VPWR VPWR g_row\[1\].g_col\[1\].pe__1770_/A sky130_fd_sc_hd__xor2_2
Xg_row\[1\].g_col\[0\].pe__1737_ g_row\[1\].g_col\[0\].pe__1740_/A g_row\[1\].g_col\[0\].pe__1740_/B
+ VGND VGND VPWR VPWR g_row\[1\].g_col\[0\].pe__1776_/A sky130_fd_sc_hd__xor2_2
Xg_row\[1\].g_col\[1\].pe__1684_ g_row\[1\].g_col\[1\].pe__1761_/A2 g_row\[1\].g_col\[1\].pe__1732_/A2
+ g_row\[1\].g_col\[1\].pe__1732_/B1 g_row\[1\].g_col\[1\].pe__1782_/A2 VGND VGND
+ VPWR VPWR g_row\[1\].g_col\[1\].pe__1685_/B sky130_fd_sc_hd__a22o_2
XFILLER_85_426 VGND VGND VPWR VPWR sky130_fd_sc_hd__fill_1
Xg_row\[1\].g_col\[0\].pe__1668_ g_row\[1\].g_col\[0\].pe__1701_/A g_row\[1\].g_col\[0\].pe__1701_/B
+ VGND VGND VPWR VPWR g_row\[1\].g_col\[0\].pe__1831_/A sky130_fd_sc_hd__or2_2
Xg_row\[0\].g_col\[1\].pe__1900_ g_row\[0\].g_col\[1\].pe__1868_/A g_row\[0\].g_col\[1\].pe__1868_/B
+ g_row\[0\].g_col\[1\].pe__1899_/X VGND VGND VPWR VPWR g_row\[0\].g_col\[1\].pe__1907_/A
+ sky130_fd_sc_hd__a21o_2
Xg_row\[0\].g_col\[1\].pe__1831_ g_row\[0\].g_col\[1\].pe__1831_/A g_row\[0\].g_col\[1\].pe__1831_/B
+ VGND VGND VPWR VPWR g_row\[0\].g_col\[1\].pe__1832_/C sky130_fd_sc_hd__nand2_2
Xg_row\[0\].g_col\[0\].pe__1815_ g_row\[0\].g_col\[0\].pe__1815_/A g_row\[0\].g_col\[0\].pe__1815_/B
+ VGND VGND VPWR VPWR g_row\[0\].g_col\[0\].pe__1822_/D sky130_fd_sc_hd__xnor2_2
Xg_row\[0\].g_col\[0\].pe__1746_ g_row\[0\].g_col\[0\].pe__1819_/A g_row\[0\].g_col\[0\].pe__1819_/B
+ VGND VGND VPWR VPWR g_row\[0\].g_col\[0\].pe__1820_/B sky130_fd_sc_hd__nor2_2
Xg_row\[1\].g_col\[1\].pe__2305_ g_row\[1\].g_col\[1\].pe__2305_/A g_row\[1\].g_col\[1\].pe__2305_/B
+ VGND VGND VPWR VPWR g_row\[1\].g_col\[1\].pe__2305_/Y sky130_fd_sc_hd__xnor2_2
Xg_row\[0\].g_col\[1\].pe__1762_ g_row\[0\].g_col\[1\].pe__1808_/A g_row\[0\].g_col\[1\].pe__1762_/B
+ VGND VGND VPWR VPWR g_row\[0\].g_col\[1\].pe__1766_/A sky130_fd_sc_hd__xnor2_2
Xg_row\[0\].g_col\[1\].pe__1693_ g_row\[0\].g_col\[1\].pe__1693_/A g_row\[0\].g_col\[1\].pe__1693_/B
+ VGND VGND VPWR VPWR g_row\[0\].g_col\[1\].pe__1695_/B sky130_fd_sc_hd__xor2_2
Xg_row\[1\].g_col\[1\].pe__2236_ g_row\[1\].g_col\[1\].pe__2394_/B1 g_row\[1\].g_col\[1\].pe__2233_/X
+ g_row\[1\].g_col\[1\].pe__2234_/Y g_row\[1\].g_col\[1\].pe__2236_/B1 g_row\[1\].g_col\[1\].pe__2334_/A1
+ VGND VGND VPWR VPWR g_row\[1\].g_col\[1\].pe__2236_/X sky130_fd_sc_hd__o32a_2
XFILLER_22_710 VGND VGND VPWR VPWR sky130_fd_sc_hd__fill_2
XFILLER_53_378 VGND VGND VPWR VPWR sky130_fd_sc_hd__decap_3
Xg_row\[0\].g_col\[0\].pe__1677_ g_row\[0\].g_col\[0\].pe__1823_/A g_row\[0\].g_col\[0\].pe__1677_/B
+ VGND VGND VPWR VPWR g_row\[0\].g_col\[0\].pe__1703_/A sky130_fd_sc_hd__or2_2
XFILLER_80_197 VGND VGND VPWR VPWR sky130_fd_sc_hd__fill_1
Xg_row\[1\].g_col\[1\].pe__2167_ g_row\[1\].g_col\[1\].pe__2167_/A g_row\[1\].g_col\[1\].pe__2167_/B
+ g_row\[1\].g_col\[1\].pe__2167_/C VGND VGND VPWR VPWR g_row\[1\].g_col\[1\].pe__2167_/X
+ sky130_fd_sc_hd__and3_2
Xg_row\[1\].g_col\[1\].pe__2098_ g_row\[1\].g_col\[1\].pe__2048_/A g_row\[1\].g_col\[1\].pe__2048_/B
+ g_row\[1\].g_col\[1\].pe__2048_/C g_row\[1\].g_col\[1\].pe__2047_/B g_row\[1\].g_col\[1\].pe__2047_/A
+ VGND VGND VPWR VPWR g_row\[1\].g_col\[1\].pe__2099_/C sky130_fd_sc_hd__a32o_2
XFILLER_21_297 VGND VGND VPWR VPWR sky130_fd_sc_hd__fill_1
Xg_row\[0\].g_col\[1\].pe__2314_ g_row\[0\].g_col\[1\].pe__2364_/A g_row\[0\].g_col\[1\].pe__2314_/B
+ VGND VGND VPWR VPWR g_row\[0\].g_col\[1\].pe__2316_/B sky130_fd_sc_hd__xnor2_2
Xg_row\[0\].g_col\[0\].pe__2229_ g_row\[0\].g_col\[0\].pe__2262_/A g_row\[0\].g_col\[0\].pe__2229_/B
+ VGND VGND VPWR VPWR g_row\[0\].g_col\[0\].pe__2238_/B sky130_fd_sc_hd__and2_2
Xg_row\[0\].g_col\[1\].pe__2245_ g_row\[0\].g_col\[1\].pe__2288_/A g_row\[0\].g_col\[1\].pe__2288_/B
+ VGND VGND VPWR VPWR g_row\[0\].g_col\[1\].pe__2246_/B sky130_fd_sc_hd__xnor2_2
Xg_row\[1\].g_col\[1\].pe_hold3027 hold2119/X VGND VGND VPWR VPWR g_row\[1\].g_col\[1\].pe__2685_/A1
+ sky130_fd_sc_hd__clkbuf_2
Xg_row\[0\].g_col\[1\].pe__2176_ g_row\[0\].g_col\[1\].pe__2175_/X g_row\[0\].g_col\[1\].pe__2132_/B
+ g_row\[0\].g_col\[1\].pe__2129_/B VGND VGND VPWR VPWR g_row\[0\].g_col\[1\].pe__2181_/A
+ sky130_fd_sc_hd__a21o_2
XFILLER_1_636 VGND VGND VPWR VPWR sky130_fd_sc_hd__decap_3
XFILLER_1_669 VGND VGND VPWR VPWR sky130_fd_sc_hd__decap_3
Xg_row\[1\].g_col\[1\].pe_hold1669 g_row\[1\].g_col\[1\].pe__1836_/X VGND VGND VPWR
+ VPWR g_row\[1\].g_col\[1\].pe__2739_/D sky130_fd_sc_hd__clkbuf_2
Xg_row\[1\].g_col\[1\].pe_hold1647 g_row\[1\].g_col\[1\].pe__2445_/A VGND VGND VPWR
+ VPWR g_row\[1\].g_col\[1\].pe__2114_/A2 sky130_fd_sc_hd__clkbuf_2
XFILLER_89_776 VGND VGND VPWR VPWR sky130_fd_sc_hd__decap_3
Xhold2340 hold2340/A VGND VGND VPWR VPWR hold2340/X sky130_fd_sc_hd__clkbuf_2
Xhold3085 hold3085/A VGND VGND VPWR VPWR hold3085/X sky130_fd_sc_hd__clkbuf_2
XTAP_TAPCELL_ROW_84_1471 VGND VPWR sky130_fd_sc_hd__tapvpwrvgnd_1
XFILLER_13_721 VGND VGND VPWR VPWR sky130_fd_sc_hd__decap_3
XFILLER_13_743 VGND VGND VPWR VPWR sky130_fd_sc_hd__decap_3
XFILLER_9_714 VGND VGND VPWR VPWR sky130_fd_sc_hd__decap_3
XFILLER_8_235 VGND VGND VPWR VPWR sky130_fd_sc_hd__fill_2
XFILLER_9_747 VGND VGND VPWR VPWR sky130_fd_sc_hd__decap_3
XFILLER_8_268 VGND VGND VPWR VPWR sky130_fd_sc_hd__fill_1
Xg_row\[0\].g_col\[0\].pe_place1231 g_row\[0\].g_col\[0\].pe__2677_/B1 VGND VGND VPWR
+ VPWR g_row\[0\].g_col\[0\].pe__2555_/A sky130_fd_sc_hd__buf_6
Xg_row\[0\].g_col\[0\].pe_place1253 g_row\[0\].g_col\[0\].pe__2639_/A VGND VGND VPWR
+ VPWR g_row\[0\].g_col\[0\].pe__2599_/A sky130_fd_sc_hd__buf_6
Xg_row\[0\].g_col\[0\].pe_place1264 _165_/A VGND VGND VPWR VPWR g_row\[0\].g_col\[0\].pe__2335_/A
+ sky130_fd_sc_hd__buf_6
XFILLER_4_441 VGND VGND VPWR VPWR sky130_fd_sc_hd__fill_1
Xg_row\[1\].g_col\[0\].pe__2640_ g_row\[1\].g_col\[0\].pe__2640_/A1 g_row\[1\].g_col\[0\].pe__2640_/A2
+ g_row\[1\].g_col\[0\].pe__2639_/X g_row\[1\].g_col\[0\].pe__2640_/C1 VGND VGND VPWR
+ VPWR g_row\[1\].g_col\[0\].pe__2640_/X sky130_fd_sc_hd__o211a_2
XFILLER_5_57 VGND VGND VPWR VPWR sky130_fd_sc_hd__fill_1
Xg_row\[1\].g_col\[1\].pe_hold2871 g_row\[1\].g_col\[1\].pe_hold2871/A VGND VGND VPWR
+ VPWR g_row\[1\].g_col\[1\].pe__2718_/D sky130_fd_sc_hd__clkbuf_2
Xg_row\[1\].g_col\[0\].pe__2571_ g_row\[1\].g_col\[0\].pe__2571_/A g_row\[1\].g_col\[0\].pe__2590_/A
+ VGND VGND VPWR VPWR g_row\[1\].g_col\[0\].pe__2571_/X sky130_fd_sc_hd__or2_2
Xg_row\[1\].g_col\[0\].pe__1522_ g_row\[1\].g_col\[0\].pe__1733_/A g_row\[1\].g_col\[0\].pe__1522_/B
+ VGND VGND VPWR VPWR g_row\[1\].g_col\[0\].pe__1523_/B sky130_fd_sc_hd__xor2_2
Xg_row\[1\].g_col\[0\].pe_hold2059 g_row\[1\].g_col\[0\].pe__2667_/X VGND VGND VPWR
+ VPWR g_row\[1\].g_col\[0\].pe__2668_/C1 sky130_fd_sc_hd__clkbuf_2
Xg_row\[1\].g_col\[0\].pe__1453_ g_row\[1\].g_col\[0\].pe__2250_/A VGND VGND VPWR
+ VPWR g_row\[1\].g_col\[0\].pe__1453_/Y sky130_fd_sc_hd__inv_2
XFILLER_36_813 VGND VGND VPWR VPWR sky130_fd_sc_hd__fill_1
Xg_row\[0\].g_col\[0\].pe__2580_ g_row\[0\].g_col\[0\].pe__2479_/X g_row\[0\].g_col\[0\].pe__2579_/Y
+ g_row\[0\].g_col\[0\].pe__2590_/A VGND VGND VPWR VPWR g_row\[0\].g_col\[0\].pe__2580_/X
+ sky130_fd_sc_hd__a21o_2
Xg_row\[1\].g_col\[0\].pe__1384_ g_row\[1\].g_col\[0\].pe__1384_/A1 g_row\[1\].g_col\[0\].pe__2686_/B
+ g_row\[1\].g_col\[0\].pe__1383_/X g_row\[1\].g_col\[0\].pe__2679_/C1 VGND VGND VPWR
+ VPWR g_row\[1\].g_col\[0\].pe__1384_/X sky130_fd_sc_hd__o211a_2
XFILLER_63_654 VGND VGND VPWR VPWR sky130_fd_sc_hd__fill_2
Xg_row\[0\].g_col\[0\].pe__1531_ g_row\[0\].g_col\[0\].pe__1676_/A g_row\[0\].g_col\[0\].pe__1531_/B
+ VGND VGND VPWR VPWR g_row\[0\].g_col\[0\].pe__1555_/B sky130_fd_sc_hd__xnor2_2
Xg_row\[1\].g_col\[1\].pe__2021_ g_row\[1\].g_col\[1\].pe__2075_/A g_row\[1\].g_col\[1\].pe__2021_/B
+ VGND VGND VPWR VPWR g_row\[1\].g_col\[1\].pe__2071_/B sky130_fd_sc_hd__xnor2_2
XFILLER_16_592 VGND VGND VPWR VPWR sky130_fd_sc_hd__fill_2
XFILLER_62_197 VGND VGND VPWR VPWR sky130_fd_sc_hd__fill_1
XTAP_TAPCELL_ROW_46_896 VGND VPWR sky130_fd_sc_hd__tapvpwrvgnd_1
Xg_row\[1\].g_col\[0\].pe__2005_ g_row\[1\].g_col\[0\].pe__2005_/A g_row\[1\].g_col\[0\].pe__2005_/B
+ VGND VGND VPWR VPWR g_row\[1\].g_col\[0\].pe__2009_/B sky130_fd_sc_hd__or2_2
Xg_row\[0\].g_col\[0\].pe__1393_ ANTENNA_182/DIODE g_row\[0\].g_col\[0\].pe__1399_/A2
+ g_row\[0\].g_col\[0\].pe__1393_/B1 g_row\[0\].g_col\[0\].pe__2633_/B1 VGND VGND
+ VPWR VPWR g_row\[0\].g_col\[0\].pe__1393_/X sky130_fd_sc_hd__o211a_2
Xg_row\[0\].g_col\[1\].pe__2030_ g_row\[0\].g_col\[1\].pe__2030_/A g_row\[0\].g_col\[1\].pe__2163_/B
+ VGND VGND VPWR VPWR g_row\[0\].g_col\[1\].pe__2032_/B sky130_fd_sc_hd__nand2_2
Xg_row\[0\].g_col\[0\].pe__2014_ g_row\[0\].g_col\[0\].pe__2001_/B g_row\[0\].g_col\[0\].pe__2014_/B
+ VGND VGND VPWR VPWR g_row\[0\].g_col\[0\].pe__2014_/X sky130_fd_sc_hd__and2b_2
Xg_row\[1\].g_col\[1\].pe__1805_ g_row\[1\].g_col\[1\].pe__1804_/A g_row\[1\].g_col\[1\].pe__1805_/A2
+ g_row\[1\].g_col\[1\].pe__2690_/Q g_row\[1\].g_col\[1\].pe__1804_/X g_row\[1\].g_col\[1\].pe__1801_/X
+ VGND VGND VPWR VPWR g_row\[1\].g_col\[1\].pe__1808_/B sky130_fd_sc_hd__a221o_2
Xg_row\[1\].g_col\[0\].pe__2769_ clkbuf_leaf_53_clk/X g_row\[1\].g_col\[0\].pe__2769_/D
+ VGND VGND VPWR VPWR g_row\[1\].g_col\[0\].pe__2769_/Q sky130_fd_sc_hd__dfxtp_2
Xg_row\[1\].g_col\[1\].pe__1736_ g_row\[1\].g_col\[1\].pe__1736_/A g_row\[1\].g_col\[1\].pe__1736_/B
+ VGND VGND VPWR VPWR g_row\[1\].g_col\[1\].pe__1740_/B sky130_fd_sc_hd__xnor2_2
Xg_row\[1\].g_col\[1\].pe__1667_ g_row\[1\].g_col\[1\].pe__1663_/A g_row\[1\].g_col\[1\].pe__1663_/B
+ g_row\[1\].g_col\[1\].pe__1666_/Y VGND VGND VPWR VPWR g_row\[1\].g_col\[1\].pe__1701_/B
+ sky130_fd_sc_hd__a21boi_2
XFILLER_86_779 VGND VGND VPWR VPWR sky130_fd_sc_hd__fill_2
Xg_row\[1\].g_col\[1\].pe__1598_ g_row\[1\].g_col\[1\].pe__1853_/B2 g_row\[1\].g_col\[1\].pe__1558_/B
+ g_row\[1\].g_col\[1\].pe__2388_/B g_row\[1\].g_col\[1\].pe__1657_/A VGND VGND VPWR
+ VPWR g_row\[1\].g_col\[1\].pe__1604_/A sky130_fd_sc_hd__a22o_2
XFILLER_85_278 VGND VGND VPWR VPWR sky130_fd_sc_hd__fill_2
Xg_row\[1\].g_col\[0\].pe_hold1870 g_row\[1\].g_col\[0\].pe_hold2902/X VGND VGND VPWR
+ VPWR g_row\[1\].g_col\[0\].pe_hold2903/A sky130_fd_sc_hd__clkbuf_2
Xg_row\[0\].g_col\[1\].pe__1814_ g_row\[0\].g_col\[1\].pe__1779_/Y g_row\[0\].g_col\[1\].pe__1812_/X
+ g_row\[0\].g_col\[1\].pe__1813_/Y VGND VGND VPWR VPWR g_row\[0\].g_col\[1\].pe__1821_/B
+ sky130_fd_sc_hd__o21ai_2
XANTENNA_108 hold3152/A VGND VGND VPWR VPWR sky130_fd_sc_hd__diode_2
XANTENNA_119 hold3201/X VGND VGND VPWR VPWR sky130_fd_sc_hd__diode_2
Xg_row\[0\].g_col\[1\].pe__1745_ g_row\[0\].g_col\[1\].pe__1745_/A g_row\[0\].g_col\[1\].pe__1745_/B
+ VGND VGND VPWR VPWR g_row\[0\].g_col\[1\].pe__1819_/B sky130_fd_sc_hd__xnor2_2
Xg_row\[1\].g_col\[0\].pe_hold1892 g_row\[1\].g_col\[0\].pe_hold2880/X VGND VGND VPWR
+ VPWR g_row\[1\].g_col\[0\].pe_hold2881/A sky130_fd_sc_hd__clkbuf_2
Xg_row\[0\].g_col\[1\].pe_hold2969 g_row\[0\].g_col\[1\].pe__2650_/X VGND VGND VPWR
+ VPWR g_row\[0\].g_col\[1\].pe_hold2969/X sky130_fd_sc_hd__clkbuf_2
Xg_row\[0\].g_col\[0\].pe__1729_ hold3118/A g_row\[0\].g_col\[0\].pe__1784_/A2 g_row\[0\].g_col\[0\].pe__1784_/A3
+ g_row\[0\].g_col\[0\].pe__1801_/B place1214/A VGND VGND VPWR VPWR g_row\[0\].g_col\[0\].pe__1730_/B
+ sky130_fd_sc_hd__a32o_2
XFILLER_41_337 VGND VGND VPWR VPWR sky130_fd_sc_hd__fill_2
Xg_row\[0\].g_col\[1\].pe__1676_ g_row\[0\].g_col\[1\].pe__1676_/A g_row\[0\].g_col\[1\].pe__1676_/B
+ VGND VGND VPWR VPWR g_row\[0\].g_col\[1\].pe__1677_/B sky130_fd_sc_hd__and2_2
Xg_row\[1\].g_col\[1\].pe__2219_ g_row\[1\].g_col\[1\].pe__2219_/A g_row\[1\].g_col\[1\].pe__2219_/B
+ VGND VGND VPWR VPWR g_row\[1\].g_col\[1\].pe__2220_/B sky130_fd_sc_hd__xor2_2
XTAP_TAPCELL_ROW_24_568 VGND VPWR sky130_fd_sc_hd__tapvpwrvgnd_1
XFILLER_10_724 VGND VGND VPWR VPWR sky130_fd_sc_hd__decap_3
XFILLER_22_584 VGND VGND VPWR VPWR sky130_fd_sc_hd__decap_3
XFILLER_10_757 VGND VGND VPWR VPWR sky130_fd_sc_hd__decap_3
XFILLER_6_728 VGND VGND VPWR VPWR sky130_fd_sc_hd__decap_3
Xg_row\[0\].g_col\[1\].pe__2228_ g_row\[0\].g_col\[1\].pe__2228_/A g_row\[0\].g_col\[1\].pe__2228_/B
+ g_row\[0\].g_col\[1\].pe__2228_/C VGND VGND VPWR VPWR g_row\[0\].g_col\[1\].pe__2229_/B
+ sky130_fd_sc_hd__or3_2
Xg_row\[1\].g_col\[1\].pe_hold2123 g_row\[1\].g_col\[1\].pe_hold3101/X VGND VGND VPWR
+ VPWR g_row\[1\].g_col\[1\].pe__1395_/A1 sky130_fd_sc_hd__clkbuf_2
Xg_row\[0\].g_col\[1\].pe__2159_ _199_/A g_row\[0\].g_col\[1\].pe__2159_/B VGND VGND
+ VPWR VPWR g_row\[0\].g_col\[1\].pe__2745_/D sky130_fd_sc_hd__nor2_2
XFILLER_49_437 VGND VGND VPWR VPWR sky130_fd_sc_hd__fill_1
XFILLER_77_757 VGND VGND VPWR VPWR sky130_fd_sc_hd__fill_1
XFILLER_18_802 VGND VGND VPWR VPWR sky130_fd_sc_hd__decap_3
Xhold2170 hold2170/A VGND VGND VPWR VPWR hold2170/X sky130_fd_sc_hd__clkbuf_2
XFILLER_45_621 VGND VGND VPWR VPWR sky130_fd_sc_hd__fill_1
XFILLER_57_470 VGND VGND VPWR VPWR sky130_fd_sc_hd__decap_3
XTAP_TAPCELL_ROW_4_271 VGND VPWR sky130_fd_sc_hd__tapvpwrvgnd_1
XTAP_TAPCELL_ROW_86_1500 VGND VPWR sky130_fd_sc_hd__tapvpwrvgnd_1
Xhold1480 hold3292/X VGND VGND VPWR VPWR hold3293/A sky130_fd_sc_hd__clkbuf_2
Xhold1491 hold2520/X VGND VGND VPWR VPWR hold2521/A sky130_fd_sc_hd__clkbuf_2
Xg_row\[1\].g_col\[0\].pe_place841 g_row\[1\].g_col\[0\].pe_place841/A VGND VGND VPWR
+ VPWR g_row\[1\].g_col\[0\].pe__1641_/B2 sky130_fd_sc_hd__buf_6
XFILLER_32_348 VGND VGND VPWR VPWR sky130_fd_sc_hd__decap_3
XFILLER_60_624 VGND VGND VPWR VPWR sky130_fd_sc_hd__fill_1
XTAP_TAPCELL_ROW_43_855 VGND VPWR sky130_fd_sc_hd__tapvpwrvgnd_1
Xg_row\[0\].g_col\[0\].pe_hold1935 g_row\[0\].g_col\[0\].pe__1893_/Y VGND VGND VPWR
+ VPWR g_row\[0\].g_col\[0\].pe__2740_/D sky130_fd_sc_hd__clkbuf_2
XFILLER_40_392 VGND VGND VPWR VPWR sky130_fd_sc_hd__decap_3
XFILLER_72_7 VGND VGND VPWR VPWR sky130_fd_sc_hd__fill_2
Xg_row\[1\].g_col\[0\].pe__2623_ place1246/X place1086/A VGND VGND VPWR VPWR g_row\[1\].g_col\[0\].pe__2623_/X
+ sky130_fd_sc_hd__or2_2
XFILLER_68_713 VGND VGND VPWR VPWR sky130_fd_sc_hd__decap_3
Xg_row\[1\].g_col\[0\].pe__2554_ g_row\[1\].g_col\[0\].pe__2554_/A1 g_row\[1\].g_col\[0\].pe__2560_/A2
+ g_row\[1\].g_col\[0\].pe__2560_/B1 g_row\[1\].g_col\[0\].pe__2553_/X VGND VGND VPWR
+ VPWR g_row\[1\].g_col\[0\].pe__2554_/X sky130_fd_sc_hd__a22o_2
Xg_row\[1\].g_col\[1\].pe__1521_ g_row\[1\].g_col\[1\].pe__1608_/A1 g_row\[1\].g_col\[1\].pe__1732_/A2
+ g_row\[1\].g_col\[1\].pe__1732_/B1 g_row\[1\].g_col\[1\].pe__2215_/B2 VGND VGND
+ VPWR VPWR g_row\[1\].g_col\[1\].pe__1522_/B sky130_fd_sc_hd__a22o_2
Xg_row\[0\].g_col\[0\].pe__2701_ clkbuf_leaf_20_clk/X g_row\[0\].g_col\[0\].pe__2701_/D
+ VGND VGND VPWR VPWR hold2229/A sky130_fd_sc_hd__dfxtp_2
Xg_row\[1\].g_col\[1\].pe__1452_ g_row\[1\].g_col\[1\].pe__1739_/A g_row\[1\].g_col\[1\].pe__1452_/B
+ VGND VGND VPWR VPWR g_row\[1\].g_col\[1\].pe__1507_/A sky130_fd_sc_hd__xor2_2
Xg_row\[1\].g_col\[0\].pe__2485_ g_row\[1\].g_col\[0\].pe__2754_/Q g_row\[1\].g_col\[0\].pe__2422_/A
+ g_row\[1\].g_col\[0\].pe__2484_/Y g_row\[1\].g_col\[0\].pe__2594_/B2 VGND VGND VPWR
+ VPWR g_row\[1\].g_col\[0\].pe__2486_/B sky130_fd_sc_hd__o211a_2
Xg_row\[0\].g_col\[0\].pe__2632_ g_row\[0\].g_col\[0\].pe__2639_/A g_row\[0\].g_col\[0\].pe__2632_/B
+ VGND VGND VPWR VPWR g_row\[0\].g_col\[0\].pe__2632_/X sky130_fd_sc_hd__or2_2
Xg_row\[1\].g_col\[0\].pe__1436_ place1089/X g_row\[1\].g_col\[0\].pe__1729_/A2 g_row\[1\].g_col\[0\].pe__1729_/A3
+ g_row\[1\].g_col\[0\].pe__1729_/B1 place1087/X VGND VGND VPWR VPWR g_row\[1\].g_col\[0\].pe__1437_/B
+ sky130_fd_sc_hd__a32o_2
XFILLER_36_643 VGND VGND VPWR VPWR sky130_fd_sc_hd__fill_1
Xg_row\[1\].g_col\[1\].pe__1383_ hold2141/X g_row\[1\].g_col\[1\].pe__1402_/B VGND
+ VGND VPWR VPWR g_row\[1\].g_col\[1\].pe__1383_/X sky130_fd_sc_hd__or2_2
Xg_row\[1\].g_col\[0\].pe__1367_ g_row\[1\].g_col\[0\].pe__2768_/Q g_row\[1\].g_col\[0\].pe__1366_/B
+ g_row\[1\].g_col\[0\].pe__2594_/B2 VGND VGND VPWR VPWR g_row\[1\].g_col\[0\].pe__1368_/B
+ sky130_fd_sc_hd__o21ai_2
XFILLER_51_613 VGND VGND VPWR VPWR sky130_fd_sc_hd__decap_3
Xg_row\[0\].g_col\[0\].pe__2563_ g_row\[0\].g_col\[0\].pe__2590_/A g_row\[0\].g_col\[0\].pe__2505_/X
+ VGND VGND VPWR VPWR g_row\[0\].g_col\[0\].pe__2563_/X sky130_fd_sc_hd__or2b_2
XFILLER_50_123 VGND VGND VPWR VPWR sky130_fd_sc_hd__fill_2
Xg_row\[0\].g_col\[0\].pe__1514_ g_row\[0\].g_col\[0\].pe__1514_/A g_row\[0\].g_col\[0\].pe__1514_/B
+ VGND VGND VPWR VPWR g_row\[0\].g_col\[0\].pe__1514_/X sky130_fd_sc_hd__and2_2
Xg_row\[0\].g_col\[0\].pe__2494_ g_row\[0\].g_col\[0\].pe__2494_/A g_row\[0\].g_col\[0\].pe__2494_/B
+ VGND VGND VPWR VPWR g_row\[0\].g_col\[0\].pe__2585_/B sky130_fd_sc_hd__or2_4
Xg_row\[0\].g_col\[1\].pe__1530_ g_row\[0\].g_col\[1\].pe__1957_/B2 g_row\[0\].g_col\[1\].pe__1657_/B
+ g_row\[0\].g_col\[1\].pe__2247_/B1 g_row\[0\].g_col\[1\].pe__2605_/B VGND VGND VPWR
+ VPWR g_row\[0\].g_col\[1\].pe__1531_/B sky130_fd_sc_hd__a22o_2
Xg_row\[0\].g_col\[1\].pe__1461_ g_row\[0\].g_col\[1\].pe__1461_/A g_row\[0\].g_col\[1\].pe__1461_/B
+ VGND VGND VPWR VPWR g_row\[0\].g_col\[1\].pe__1461_/Y sky130_fd_sc_hd__nand2_2
Xg_row\[1\].g_col\[1\].pe__2004_ g_row\[1\].g_col\[1\].pe__2005_/A g_row\[1\].g_col\[1\].pe__2005_/B
+ VGND VGND VPWR VPWR g_row\[1\].g_col\[1\].pe__2006_/A sky130_fd_sc_hd__and2_2
XFILLER_31_370 VGND VGND VPWR VPWR sky130_fd_sc_hd__decap_3
XTAP_TAPCELL_ROW_21_527 VGND VPWR sky130_fd_sc_hd__tapvpwrvgnd_1
Xg_row\[0\].g_col\[1\].pe__1392_ g_row\[0\].g_col\[1\].pe__1392_/A g_row\[0\].g_col\[1\].pe__2680_/B
+ VGND VGND VPWR VPWR g_row\[0\].g_col\[1\].pe__1392_/X sky130_fd_sc_hd__or2_2
Xg_row\[0\].g_col\[0\].pe__1376_ g_row\[0\].g_col\[0\].pe__1376_/A g_row\[0\].g_col\[0\].pe__1385_/B
+ VGND VGND VPWR VPWR g_row\[0\].g_col\[0\].pe__1376_/X sky130_fd_sc_hd__or2_2
Xg_row\[0\].g_col\[1\].pe__2013_ g_row\[0\].g_col\[1\].pe__2013_/A g_row\[0\].g_col\[1\].pe__2013_/B
+ VGND VGND VPWR VPWR g_row\[0\].g_col\[1\].pe__2153_/A sky130_fd_sc_hd__nor2_2
XTAP_TAPCELL_ROW_53_1009 VGND VPWR sky130_fd_sc_hd__tapvpwrvgnd_1
Xg_row\[1\].g_col\[1\].pe__2768_ _301_/CLK g_row\[1\].g_col\[1\].pe__2768_/D VGND
+ VGND VPWR VPWR g_row\[1\].g_col\[1\].pe__2768_/Q sky130_fd_sc_hd__dfxtp_2
Xg_row\[1\].g_col\[1\].pe__1719_ g_row\[1\].g_col\[1\].pe__1714_/A g_row\[1\].g_col\[1\].pe__1714_/B
+ g_row\[1\].g_col\[1\].pe__1714_/C VGND VGND VPWR VPWR g_row\[1\].g_col\[1\].pe__1719_/Y
+ sky130_fd_sc_hd__a21oi_2
Xg_row\[1\].g_col\[1\].pe__2699_ clkbuf_leaf_69_clk/X g_row\[1\].g_col\[1\].pe__2699_/D
+ VGND VGND VPWR VPWR g_row\[1\].g_col\[1\].pe__2699_/Q sky130_fd_sc_hd__dfxtp_2
XFILLER_73_237 VGND VGND VPWR VPWR sky130_fd_sc_hd__fill_1
XTAP_TAPCELL_ROW_1_230 VGND VPWR sky130_fd_sc_hd__tapvpwrvgnd_1
XTAP_TAPCELL_ROW_29_638 VGND VPWR sky130_fd_sc_hd__tapvpwrvgnd_1
XTAP_TAPCELL_ROW_29_649 VGND VPWR sky130_fd_sc_hd__tapvpwrvgnd_1
XTAP_TAPCELL_ROW_68_1230 VGND VPWR sky130_fd_sc_hd__tapvpwrvgnd_1
XFILLER_27_676 VGND VGND VPWR VPWR sky130_fd_sc_hd__decap_3
XFILLER_54_462 VGND VGND VPWR VPWR sky130_fd_sc_hd__decap_3
XFILLER_54_473 VGND VGND VPWR VPWR sky130_fd_sc_hd__decap_3
XFILLER_25_54 VGND VGND VPWR VPWR sky130_fd_sc_hd__fill_2
XFILLER_26_175 VGND VGND VPWR VPWR sky130_fd_sc_hd__fill_1
XFILLER_26_197 VGND VGND VPWR VPWR sky130_fd_sc_hd__fill_1
XFILLER_81_281 VGND VGND VPWR VPWR sky130_fd_sc_hd__fill_1
X_330_ _340_/CLK _330_/D VGND VGND VPWR VPWR _330_/Q sky130_fd_sc_hd__dfxtp_2
Xg_row\[0\].g_col\[1\].pe__1728_ g_row\[0\].g_col\[1\].pe__1728_/A g_row\[0\].g_col\[1\].pe__1728_/B
+ VGND VGND VPWR VPWR g_row\[0\].g_col\[1\].pe__1734_/A sky130_fd_sc_hd__xnor2_2
XTAP_TAPCELL_ROW_40_803 VGND VPWR sky130_fd_sc_hd__tapvpwrvgnd_1
XTAP_TAPCELL_ROW_81_1430 VGND VPWR sky130_fd_sc_hd__tapvpwrvgnd_1
Xg_row\[0\].g_col\[1\].pe__1659_ g_row\[0\].g_col\[1\].pe__1659_/A g_row\[0\].g_col\[1\].pe__1664_/A
+ VGND VGND VPWR VPWR g_row\[0\].g_col\[1\].pe__1693_/B sky130_fd_sc_hd__xnor2_2
XTAP_TAPCELL_ROW_40_814 VGND VPWR sky130_fd_sc_hd__tapvpwrvgnd_1
X_261_ _271_/A _261_/B_N VGND VGND VPWR VPWR _261_/Y sky130_fd_sc_hd__nor2b_4
XFILLER_6_525 VGND VGND VPWR VPWR sky130_fd_sc_hd__fill_1
XTAP_TAPCELL_ROW_79_1392 VGND VPWR sky130_fd_sc_hd__tapvpwrvgnd_1
XTAP_TAPCELL_ROW_9_341 VGND VPWR sky130_fd_sc_hd__tapvpwrvgnd_1
XTAP_TAPCELL_ROW_9_352 VGND VPWR sky130_fd_sc_hd__tapvpwrvgnd_1
XFILLER_2_764 VGND VGND VPWR VPWR sky130_fd_sc_hd__fill_1
XFILLER_77_532 VGND VGND VPWR VPWR sky130_fd_sc_hd__fill_2
XTAP_TAPCELL_ROW_92_1592 VGND VPWR sky130_fd_sc_hd__tapvpwrvgnd_1
XTAP_TAPCELL_ROW_48_925 VGND VPWR sky130_fd_sc_hd__tapvpwrvgnd_1
XTAP_TAPCELL_ROW_48_936 VGND VPWR sky130_fd_sc_hd__tapvpwrvgnd_1
Xg_row\[1\].g_col\[0\].pe__2270_ g_row\[1\].g_col\[0\].pe__2330_/A g_row\[1\].g_col\[0\].pe__2330_/B
+ VGND VGND VPWR VPWR g_row\[1\].g_col\[0\].pe__2297_/A sky130_fd_sc_hd__nor2_2
XFILLER_18_643 VGND VGND VPWR VPWR sky130_fd_sc_hd__fill_1
XFILLER_17_164 VGND VGND VPWR VPWR sky130_fd_sc_hd__decap_3
XFILLER_45_462 VGND VGND VPWR VPWR sky130_fd_sc_hd__fill_2
Xg_row\[0\].g_col\[0\].pe_hold3112 g_row\[0\].g_col\[0\].pe__2724_/Q VGND VGND VPWR
+ VPWR g_row\[0\].g_col\[0\].pe__2682_/A sky130_fd_sc_hd__clkbuf_2
XFILLER_17_175 VGND VGND VPWR VPWR sky130_fd_sc_hd__decap_3
XFILLER_60_421 VGND VGND VPWR VPWR sky130_fd_sc_hd__decap_3
XANTENNA_19 b_inputs_flat[1] VGND VGND VPWR VPWR sky130_fd_sc_hd__diode_2
Xg_row\[0\].g_col\[0\].pe_hold1721 g_row\[0\].g_col\[0\].pe__2747_/Q VGND VGND VPWR
+ VPWR g_row\[0\].g_col\[0\].pe__2235_/A sky130_fd_sc_hd__clkbuf_2
Xg_row\[0\].g_col\[0\].pe_hold1754 g_row\[0\].g_col\[0\].pe__2445_/A VGND VGND VPWR
+ VPWR g_row\[0\].g_col\[0\].pe__2114_/A2 sky130_fd_sc_hd__clkbuf_2
Xg_row\[0\].g_col\[0\].pe_hold1798 g_row\[0\].g_col\[0\].pe__1403_/X VGND VGND VPWR
+ VPWR g_row\[0\].g_col\[0\].pe__2737_/D sky130_fd_sc_hd__clkbuf_2
XFILLER_63_3 VGND VGND VPWR VPWR sky130_fd_sc_hd__fill_1
Xg_row\[1\].g_col\[0\].pe__1985_ g_row\[1\].g_col\[0\].pe__1924_/A g_row\[1\].g_col\[0\].pe__1985_/B
+ g_row\[1\].g_col\[0\].pe__1985_/C VGND VGND VPWR VPWR g_row\[1\].g_col\[0\].pe__1988_/B
+ sky130_fd_sc_hd__nand3b_2
Xg_row\[1\].g_col\[1\].pe__2622_ g_row\[1\].g_col\[1\].pe__2626_/A1 place1087/X g_row\[1\].g_col\[1\].pe__2626_/B1
+ g_row\[1\].g_col\[1\].pe__2622_/C1 VGND VGND VPWR VPWR g_row\[1\].g_col\[1\].pe__2622_/X
+ sky130_fd_sc_hd__o211a_2
Xg_row\[1\].g_col\[0\].pe__2606_ g_row\[1\].g_col\[0\].pe__2640_/A1 g_row\[1\].g_col\[0\].pe__2606_/A2
+ g_row\[1\].g_col\[0\].pe__2640_/C1 g_row\[1\].g_col\[0\].pe__2605_/X VGND VGND VPWR
+ VPWR g_row\[1\].g_col\[0\].pe__2606_/X sky130_fd_sc_hd__o211a_2
Xg_row\[1\].g_col\[1\].pe__2553_ g_row\[1\].g_col\[1\].pe__2551_/Y g_row\[1\].g_col\[1\].pe__2552_/X
+ g_row\[1\].g_col\[1\].pe__2559_/A VGND VGND VPWR VPWR g_row\[1\].g_col\[1\].pe__2553_/X
+ sky130_fd_sc_hd__a21o_2
XFILLER_68_543 VGND VGND VPWR VPWR sky130_fd_sc_hd__decap_3
Xg_row\[0\].g_col\[0\].pe__1994_ g_row\[0\].g_col\[0\].pe__1994_/A g_row\[0\].g_col\[0\].pe__1994_/B
+ VGND VGND VPWR VPWR g_row\[0\].g_col\[0\].pe__1994_/Y sky130_fd_sc_hd__nor2_2
Xg_row\[1\].g_col\[1\].pe__1504_ g_row\[1\].g_col\[1\].pe__1504_/A g_row\[1\].g_col\[1\].pe__2341_/B
+ VGND VGND VPWR VPWR g_row\[1\].g_col\[1\].pe__1504_/Y sky130_fd_sc_hd__nor2_2
XFILLER_68_587 VGND VGND VPWR VPWR sky130_fd_sc_hd__fill_1
Xg_row\[1\].g_col\[1\].pe__2484_ g_row\[1\].g_col\[1\].pe__2484_/A VGND VGND VPWR
+ VPWR g_row\[1\].g_col\[1\].pe__2484_/Y sky130_fd_sc_hd__inv_2
Xg_row\[1\].g_col\[0\].pe__2468_ g_row\[1\].g_col\[0\].pe__2538_/A g_row\[1\].g_col\[0\].pe__2538_/B
+ g_row\[1\].g_col\[0\].pe__2538_/C g_row\[1\].g_col\[0\].pe__2466_/X g_row\[1\].g_col\[0\].pe__2497_/A
+ VGND VGND VPWR VPWR g_row\[1\].g_col\[0\].pe__2551_/C sky130_fd_sc_hd__a311o_2
Xg_row\[0\].g_col\[1\].pe__2700_ clkbuf_leaf_10_clk/X g_row\[0\].g_col\[1\].pe__2700_/D
+ VGND VGND VPWR VPWR g_row\[0\].g_col\[1\].pe__2700_/Q sky130_fd_sc_hd__dfxtp_2
XFILLER_55_237 VGND VGND VPWR VPWR sky130_fd_sc_hd__fill_1
Xg_row\[1\].g_col\[0\].pe__1419_ g_row\[1\].g_col\[0\].pe__1730_/A g_row\[1\].g_col\[0\].pe__1419_/B
+ VGND VGND VPWR VPWR g_row\[1\].g_col\[0\].pe__1428_/B sky130_fd_sc_hd__xor2_2
Xg_row\[0\].g_col\[1\].pe_hold2029 g_row\[0\].g_col\[1\].pe__2767_/Q VGND VGND VPWR
+ VPWR g_row\[0\].g_col\[1\].pe__2576_/A1 sky130_fd_sc_hd__clkbuf_2
XFILLER_55_259 VGND VGND VPWR VPWR sky130_fd_sc_hd__decap_3
Xg_row\[0\].g_col\[0\].pe__2615_ g_row\[0\].g_col\[0\].pe__2628_/A1 g_row\[0\].g_col\[0\].pe__2615_/A2
+ g_row\[0\].g_col\[0\].pe__2628_/B1 g_row\[0\].g_col\[0\].pe__2614_/X VGND VGND VPWR
+ VPWR g_row\[0\].g_col\[0\].pe__2615_/X sky130_fd_sc_hd__o211a_2
Xg_row\[1\].g_col\[1\].pe__1366_ g_row\[1\].g_col\[1\].pe__2478_/A g_row\[1\].g_col\[1\].pe__1366_/B
+ VGND VGND VPWR VPWR output1411/A sky130_fd_sc_hd__xnor2_2
Xg_row\[1\].g_col\[0\].pe__2399_ g_row\[1\].g_col\[0\].pe__2754_/Q VGND VGND VPWR
+ VPWR g_row\[1\].g_col\[0\].pe__2399_/Y sky130_fd_sc_hd__inv_2
Xg_row\[0\].g_col\[1\].pe__2631_ g_row\[0\].g_col\[1\].pe__1838_/A g_row\[0\].g_col\[1\].pe__2631_/A2
+ g_row\[0\].g_col\[1\].pe__2381_/A g_row\[0\].g_col\[1\].pe__2630_/X VGND VGND VPWR
+ VPWR g_row\[0\].g_col\[1\].pe__2703_/D sky130_fd_sc_hd__o211a_2
XFILLER_63_281 VGND VGND VPWR VPWR sky130_fd_sc_hd__decap_3
Xg_row\[0\].g_col\[0\].pe__2546_ g_row\[0\].g_col\[0\].pe__2546_/A g_row\[0\].g_col\[0\].pe__2546_/B
+ VGND VGND VPWR VPWR g_row\[0\].g_col\[0\].pe__2546_/Y sky130_fd_sc_hd__nand2_2
XFILLER_23_145 VGND VGND VPWR VPWR sky130_fd_sc_hd__fill_2
Xg_row\[0\].g_col\[1\].pe__1513_ g_row\[0\].g_col\[1\].pe__1500_/A g_row\[0\].g_col\[1\].pe__1500_/B
+ g_row\[0\].g_col\[1\].pe__1512_/Y VGND VGND VPWR VPWR g_row\[0\].g_col\[1\].pe__1588_/A
+ sky130_fd_sc_hd__a21oi_2
XFILLER_51_498 VGND VGND VPWR VPWR sky130_fd_sc_hd__decap_3
XTAP_TAPCELL_ROW_63_1160 VGND VPWR sky130_fd_sc_hd__tapvpwrvgnd_1
Xg_row\[0\].g_col\[0\].pe__2477_ g_row\[0\].g_col\[0\].pe__2487_/B g_row\[0\].g_col\[0\].pe__2490_/A
+ g_row\[0\].g_col\[0\].pe__2487_/A VGND VGND VPWR VPWR g_row\[0\].g_col\[0\].pe__2579_/C
+ sky130_fd_sc_hd__o21ai_2
Xg_row\[0\].g_col\[1\].pe__2493_ g_row\[0\].g_col\[1\].pe__2422_/A g_row\[0\].g_col\[1\].pe__2484_/Y
+ g_row\[0\].g_col\[1\].pe__1348_/A g_row\[0\].g_col\[1\].pe__2754_/Q VGND VGND VPWR
+ VPWR g_row\[0\].g_col\[1\].pe__2503_/B sky130_fd_sc_hd__a211oi_2
XFILLER_20_841 VGND VGND VPWR VPWR sky130_fd_sc_hd__fill_1
Xg_row\[0\].g_col\[0\].pe__1428_ g_row\[0\].g_col\[0\].pe__1428_/A g_row\[0\].g_col\[0\].pe__1428_/B
+ VGND VGND VPWR VPWR g_row\[0\].g_col\[0\].pe__1428_/X sky130_fd_sc_hd__and2_2
Xg_row\[0\].g_col\[1\].pe__1444_ g_row\[0\].g_col\[1\].pe__2729_/Q g_row\[0\].g_col\[1\].pe__2125_/C
+ VGND VGND VPWR VPWR g_row\[0\].g_col\[1\].pe__2079_/B sky130_fd_sc_hd__xor2_2
Xg_row\[0\].g_col\[0\].pe__1359_ g_row\[0\].g_col\[0\].pe__2765_/Q g_row\[0\].g_col\[0\].pe__1359_/B
+ VGND VGND VPWR VPWR output1418/A sky130_fd_sc_hd__xor2_2
Xclkbuf_4_2_0_clk clkbuf_0_clk/X VGND VGND VPWR VPWR clkbuf_4_2_0_clk/X sky130_fd_sc_hd__clkbuf_16
XTAP_TAPCELL_ROW_6_300 VGND VPWR sky130_fd_sc_hd__tapvpwrvgnd_1
XFILLER_59_521 VGND VGND VPWR VPWR sky130_fd_sc_hd__decap_3
XFILLER_59_554 VGND VGND VPWR VPWR sky130_fd_sc_hd__fill_1
XFILLER_87_841 VGND VGND VPWR VPWR sky130_fd_sc_hd__fill_1
XFILLER_36_20 VGND VGND VPWR VPWR sky130_fd_sc_hd__fill_2
XFILLER_74_579 VGND VGND VPWR VPWR sky130_fd_sc_hd__fill_1
XFILLER_14_112 VGND VGND VPWR VPWR sky130_fd_sc_hd__decap_3
XFILLER_15_624 VGND VGND VPWR VPWR sky130_fd_sc_hd__decap_3
XFILLER_42_421 VGND VGND VPWR VPWR sky130_fd_sc_hd__decap_3
XFILLER_70_730 VGND VGND VPWR VPWR sky130_fd_sc_hd__fill_1
Xg_row\[0\].g_col\[1\].pe_hold1851 g_row\[0\].g_col\[1\].pe__2554_/X VGND VGND VPWR
+ VPWR g_row\[0\].g_col\[1\].pe__2555_/B sky130_fd_sc_hd__clkbuf_2
XFILLER_70_752 VGND VGND VPWR VPWR sky130_fd_sc_hd__decap_3
XFILLER_42_487 VGND VGND VPWR VPWR sky130_fd_sc_hd__decap_3
X_313_ _318_/CLK _313_/D VGND VGND VPWR VPWR _313_/Q sky130_fd_sc_hd__dfxtp_2
XFILLER_11_841 VGND VGND VPWR VPWR sky130_fd_sc_hd__fill_1
X_175_ _189_/A _175_/B_N VGND VGND VPWR VPWR _175_/Y sky130_fd_sc_hd__nor2b_4
Xg_row\[1\].g_col\[0\].pe__1770_ g_row\[1\].g_col\[0\].pe__1770_/A g_row\[1\].g_col\[0\].pe__1770_/B
+ VGND VGND VPWR VPWR g_row\[1\].g_col\[0\].pe__1793_/A sky130_fd_sc_hd__xnor2_2
Xg_row\[1\].g_col\[0\].pe__2322_ g_row\[1\].g_col\[0\].pe__2337_/B g_row\[1\].g_col\[0\].pe__2337_/C
+ VGND VGND VPWR VPWR g_row\[1\].g_col\[0\].pe__2323_/B sky130_fd_sc_hd__nor2_2
XFILLER_65_557 VGND VGND VPWR VPWR sky130_fd_sc_hd__decap_3
Xg_row\[1\].g_col\[0\].pe__2253_ g_row\[1\].g_col\[0\].pe__2253_/A g_row\[1\].g_col\[0\].pe__2253_/B
+ VGND VGND VPWR VPWR g_row\[1\].g_col\[0\].pe__2253_/Y sky130_fd_sc_hd__nand2_2
XFILLER_65_579 VGND VGND VPWR VPWR sky130_fd_sc_hd__decap_3
Xg_row\[1\].g_col\[0\].pe__2184_ g_row\[1\].g_col\[0\].pe__2222_/A g_row\[1\].g_col\[0\].pe__2184_/B
+ g_row\[1\].g_col\[0\].pe__2184_/C VGND VGND VPWR VPWR g_row\[1\].g_col\[0\].pe__2184_/X
+ sky130_fd_sc_hd__and3b_2
Xg_row\[0\].g_col\[0\].pe__2331_ g_row\[0\].g_col\[0\].pe__2305_/A g_row\[0\].g_col\[0\].pe__2305_/B
+ g_row\[0\].g_col\[0\].pe__2329_/Y g_row\[0\].g_col\[0\].pe__2330_/X VGND VGND VPWR
+ VPWR g_row\[0\].g_col\[0\].pe__2331_/X sky130_fd_sc_hd__o211a_2
XFILLER_20_137 VGND VGND VPWR VPWR sky130_fd_sc_hd__decap_3
Xg_row\[0\].g_col\[0\].pe__2262_ g_row\[0\].g_col\[0\].pe__2262_/A g_row\[0\].g_col\[0\].pe__2262_/B
+ VGND VGND VPWR VPWR g_row\[0\].g_col\[0\].pe__2263_/B sky130_fd_sc_hd__nand2_2
Xg_row\[0\].g_col\[0\].pe_hold2274 g_row\[0\].g_col\[0\].pe_hold3032/X VGND VGND VPWR
+ VPWR g_row\[0\].g_col\[0\].pe__1376_/A sky130_fd_sc_hd__clkbuf_2
Xg_row\[0\].g_col\[0\].pe_hold2285 g_row\[0\].g_col\[0\].pe__1380_/X VGND VGND VPWR
+ VPWR g_row\[0\].g_col\[0\].pe__2727_/D sky130_fd_sc_hd__clkbuf_2
Xg_row\[0\].g_col\[1\].pe_place855 g_row\[0\].g_col\[1\].pe__1541_/X VGND VGND VPWR
+ VPWR g_row\[0\].g_col\[1\].pe__2216_/B1 sky130_fd_sc_hd__buf_6
XTAP_TAPCELL_ROW_31_677 VGND VPWR sky130_fd_sc_hd__tapvpwrvgnd_1
Xg_row\[0\].g_col\[0\].pe_hold2296 g_row\[0\].g_col\[0\].pe_hold3066/X VGND VGND VPWR
+ VPWR g_row\[0\].g_col\[0\].pe__2619_/A2 sky130_fd_sc_hd__clkbuf_2
Xg_row\[0\].g_col\[0\].pe__2193_ g_row\[0\].g_col\[0\].pe__2147_/A g_row\[0\].g_col\[0\].pe__2147_/B
+ g_row\[0\].g_col\[0\].pe__2192_/Y VGND VGND VPWR VPWR g_row\[0\].g_col\[0\].pe__2202_/B
+ sky130_fd_sc_hd__a21oi_4
Xg_row\[1\].g_col\[1\].pe__1984_ g_row\[1\].g_col\[1\].pe__1424_/A g_row\[1\].g_col\[1\].pe__1424_/B
+ g_row\[1\].g_col\[1\].pe__1983_/Y VGND VGND VPWR VPWR g_row\[1\].g_col\[1\].pe__1985_/C
+ sky130_fd_sc_hd__a21o_2
Xg_row\[1\].g_col\[0\].pe__1968_ g_row\[1\].g_col\[0\].pe__1460_/B g_row\[1\].g_col\[0\].pe__1968_/B
+ g_row\[1\].g_col\[0\].pe__1968_/C VGND VGND VPWR VPWR g_row\[1\].g_col\[0\].pe__1974_/A
+ sky130_fd_sc_hd__nand3b_2
Xhold3404 hold3404/A VGND VGND VPWR VPWR hold3404/X sky130_fd_sc_hd__clkbuf_2
Xhold3415 hold3415/A VGND VGND VPWR VPWR hold3415/X sky130_fd_sc_hd__clkbuf_2
Xg_row\[1\].g_col\[0\].pe__1899_ g_row\[1\].g_col\[0\].pe__1899_/A g_row\[1\].g_col\[0\].pe__1899_/B
+ VGND VGND VPWR VPWR g_row\[1\].g_col\[0\].pe__1899_/X sky130_fd_sc_hd__and2_2
Xhold2703 hold3489/X VGND VGND VPWR VPWR hold3490/A sky130_fd_sc_hd__clkbuf_2
Xhold2714 hold3466/X VGND VGND VPWR VPWR hold3467/A sky130_fd_sc_hd__clkbuf_2
Xoutput1376 output1376/A VGND VGND VPWR VPWR results_flat[29] sky130_fd_sc_hd__buf_2
Xoutput1365 output1365/A VGND VGND VPWR VPWR results_flat[19] sky130_fd_sc_hd__buf_2
Xoutput1354 _136_/Y VGND VGND VPWR VPWR ready sky130_fd_sc_hd__buf_2
Xhold3448 hold3448/A VGND VGND VPWR VPWR hold3448/X sky130_fd_sc_hd__clkbuf_2
Xhold3437 hold3437/A VGND VGND VPWR VPWR hold3437/X sky130_fd_sc_hd__clkbuf_2
Xhold3426 hold3426/A VGND VGND VPWR VPWR hold3426/X sky130_fd_sc_hd__clkbuf_2
Xg_row\[1\].g_col\[1\].pe__2605_ place1247/X g_row\[1\].g_col\[1\].pe__2605_/B VGND
+ VGND VPWR VPWR g_row\[1\].g_col\[1\].pe__2605_/X sky130_fd_sc_hd__or2_2
XFILLER_69_841 VGND VGND VPWR VPWR sky130_fd_sc_hd__fill_1
Xhold2725 hold2725/A VGND VGND VPWR VPWR _297_/D sky130_fd_sc_hd__clkbuf_2
Xhold2736 _217_/Y VGND VGND VPWR VPWR hold2736/X sky130_fd_sc_hd__clkbuf_2
Xhold2747 hold3528/X VGND VGND VPWR VPWR _197_/B_N sky130_fd_sc_hd__clkbuf_2
Xoutput1398 output1398/A VGND VGND VPWR VPWR results_flat[49] sky130_fd_sc_hd__buf_2
Xoutput1387 output1387/A VGND VGND VPWR VPWR results_flat[39] sky130_fd_sc_hd__buf_2
Xhold3459 b_inputs_flat[4] VGND VGND VPWR VPWR hold3459/X sky130_fd_sc_hd__clkbuf_2
Xg_row\[0\].g_col\[0\].pe__1977_ g_row\[0\].g_col\[0\].pe__2345_/A g_row\[0\].g_col\[0\].pe__1977_/B
+ VGND VGND VPWR VPWR g_row\[0\].g_col\[0\].pe__1978_/C sky130_fd_sc_hd__xnor2_2
Xhold2758 hold3551/X VGND VGND VPWR VPWR hold3552/A sky130_fd_sc_hd__clkbuf_2
Xhold2769 hold3543/X VGND VGND VPWR VPWR hold3544/A sky130_fd_sc_hd__clkbuf_2
Xg_row\[1\].g_col\[1\].pe__2536_ g_row\[1\].g_col\[1\].pe__2569_/A g_row\[1\].g_col\[1\].pe__2536_/B
+ VGND VGND VPWR VPWR g_row\[1\].g_col\[1\].pe__2759_/D sky130_fd_sc_hd__and2_2
Xg_row\[0\].g_col\[1\].pe__1993_ g_row\[0\].g_col\[1\].pe__1991_/X g_row\[0\].g_col\[1\].pe__1993_/B
+ VGND VGND VPWR VPWR g_row\[0\].g_col\[1\].pe__2055_/A sky130_fd_sc_hd__nand2b_4
XFILLER_28_215 VGND VGND VPWR VPWR sky130_fd_sc_hd__decap_3
XFILLER_56_546 VGND VGND VPWR VPWR sky130_fd_sc_hd__decap_3
Xg_row\[1\].g_col\[1\].pe__2467_ g_row\[1\].g_col\[1\].pe__2446_/B g_row\[1\].g_col\[1\].pe__2761_/Q
+ VGND VGND VPWR VPWR g_row\[1\].g_col\[1\].pe__2497_/A sky130_fd_sc_hd__and2b_2
Xg_row\[1\].g_col\[1\].pe__1418_ g_row\[1\].g_col\[1\].pe__1704_/A2 g_row\[1\].g_col\[1\].pe__1729_/A2
+ g_row\[1\].g_col\[1\].pe__1729_/A3 g_row\[1\].g_col\[1\].pe__1729_/B1 g_row\[1\].g_col\[1\].pe__2698_/Q
+ VGND VGND VPWR VPWR g_row\[1\].g_col\[1\].pe__1419_/B sky130_fd_sc_hd__a32o_2
XFILLER_52_730 VGND VGND VPWR VPWR sky130_fd_sc_hd__fill_2
XTAP_TAPCELL_ROW_39_788 VGND VPWR sky130_fd_sc_hd__tapvpwrvgnd_1
XTAP_TAPCELL_ROW_39_799 VGND VPWR sky130_fd_sc_hd__tapvpwrvgnd_1
Xg_row\[1\].g_col\[1\].pe__2398_ g_row\[1\].g_col\[1\].pe__2722_/Q g_row\[1\].g_col\[1\].pe__2639_/B
+ VGND VGND VPWR VPWR g_row\[1\].g_col\[1\].pe__2398_/X sky130_fd_sc_hd__and2_2
Xg_row\[0\].g_col\[1\].pe__2614_ g_row\[0\].g_col\[1\].pe__2663_/A g_row\[0\].g_col\[1\].pe__2614_/B
+ VGND VGND VPWR VPWR g_row\[0\].g_col\[1\].pe__2614_/X sky130_fd_sc_hd__or2_2
XTAP_TAPCELL_ROW_19_490 VGND VPWR sky130_fd_sc_hd__tapvpwrvgnd_1
Xg_row\[1\].g_col\[1\].pe__1349_ g_row\[1\].g_col\[1\].pe__2760_/Q g_row\[1\].g_col\[1\].pe__1349_/B
+ VGND VGND VPWR VPWR output1402/A sky130_fd_sc_hd__xnor2_2
XTAP_TAPCELL_ROW_61_1119 VGND VPWR sky130_fd_sc_hd__tapvpwrvgnd_1
Xg_row\[0\].g_col\[0\].pe__2529_ g_row\[0\].g_col\[0\].pe__2595_/A g_row\[0\].g_col\[0\].pe__2529_/B
+ VGND VGND VPWR VPWR g_row\[0\].g_col\[0\].pe__2758_/D sky130_fd_sc_hd__and2_2
Xg_row\[0\].g_col\[1\].pe__2545_ g_row\[0\].g_col\[1\].pe__2546_/A g_row\[0\].g_col\[1\].pe__2546_/B
+ VGND VGND VPWR VPWR g_row\[0\].g_col\[1\].pe__2547_/B sky130_fd_sc_hd__nor2_2
XTAP_TAPCELL_ROW_50_953 VGND VPWR sky130_fd_sc_hd__tapvpwrvgnd_1
Xg_row\[0\].g_col\[1\].pe__2476_ g_row\[0\].g_col\[1\].pe__2767_/Q g_row\[0\].g_col\[1\].pe__2476_/B
+ VGND VGND VPWR VPWR g_row\[0\].g_col\[1\].pe__2487_/A sky130_fd_sc_hd__xnor2_2
XTAP_TAPCELL_ROW_50_964 VGND VPWR sky130_fd_sc_hd__tapvpwrvgnd_1
Xg_row\[0\].g_col\[1\].pe__1427_ g_row\[0\].g_col\[1\].pe__1789_/A g_row\[0\].g_col\[1\].pe__1427_/B
+ VGND VGND VPWR VPWR g_row\[0\].g_col\[1\].pe__1650_/B sky130_fd_sc_hd__xor2_2
XFILLER_22_44 VGND VGND VPWR VPWR sky130_fd_sc_hd__fill_2
Xg_row\[0\].g_col\[1\].pe__1358_ g_row\[0\].g_col\[1\].pe__2764_/Q g_row\[0\].g_col\[1\].pe__1357_/B
+ ANTENNA_146/DIODE VGND VGND VPWR VPWR g_row\[0\].g_col\[1\].pe__1359_/B sky130_fd_sc_hd__o21a_2
XFILLER_4_837 VGND VGND VPWR VPWR sky130_fd_sc_hd__decap_3
XTAP_TAPCELL_ROW_76_1351 VGND VPWR sky130_fd_sc_hd__tapvpwrvgnd_1
XFILLER_87_671 VGND VGND VPWR VPWR sky130_fd_sc_hd__fill_1
XFILLER_47_535 VGND VGND VPWR VPWR sky130_fd_sc_hd__decap_3
XFILLER_47_557 VGND VGND VPWR VPWR sky130_fd_sc_hd__decap_3
XFILLER_47_96 VGND VGND VPWR VPWR sky130_fd_sc_hd__fill_2
Xg_row\[0\].g_col\[1\].pe_hold3083 g_row\[0\].g_col\[1\].pe__2743_/Q VGND VGND VPWR
+ VPWR g_row\[0\].g_col\[1\].pe_hold3083/X sky130_fd_sc_hd__clkbuf_2
Xg_row\[0\].g_col\[1\].pe_hold3050 g_row\[0\].g_col\[1\].pe_hold3050/A VGND VGND VPWR
+ VPWR g_row\[0\].g_col\[1\].pe__1399_/A1 sky130_fd_sc_hd__clkbuf_2
XFILLER_62_549 VGND VGND VPWR VPWR sky130_fd_sc_hd__decap_3
XFILLER_74_387 VGND VGND VPWR VPWR sky130_fd_sc_hd__fill_2
Xg_row\[0\].g_col\[1\].pe_hold2371 g_row\[0\].g_col\[1\].pe__1407_/X VGND VGND VPWR
+ VPWR g_row\[0\].g_col\[1\].pe__1408_/B sky130_fd_sc_hd__clkbuf_2
Xg_row\[0\].g_col\[1\].pe_hold2360 place1198/X VGND VGND VPWR VPWR g_row\[0\].g_col\[1\].pe__2628_/A2
+ sky130_fd_sc_hd__clkbuf_2
XFILLER_27_281 VGND VGND VPWR VPWR sky130_fd_sc_hd__fill_1
Xg_row\[0\].g_col\[1\].pe_hold2393 g_row\[0\].g_col\[1\].pe__2360_/X VGND VGND VPWR
+ VPWR g_row\[0\].g_col\[1\].pe__2361_/B sky130_fd_sc_hd__clkbuf_2
Xg_row\[0\].g_col\[1\].pe_hold2382 g_row\[0\].g_col\[1\].pe__2334_/X VGND VGND VPWR
+ VPWR g_row\[0\].g_col\[1\].pe__2335_/B sky130_fd_sc_hd__clkbuf_2
XFILLER_11_660 VGND VGND VPWR VPWR sky130_fd_sc_hd__decap_3
XFILLER_7_620 VGND VGND VPWR VPWR sky130_fd_sc_hd__decap_3
X_227_ _237_/A _227_/B_N VGND VGND VPWR VPWR _227_/Y sky130_fd_sc_hd__nor2b_4
Xg_row\[1\].g_col\[0\].pe__1822_ g_row\[1\].g_col\[0\].pe__1818_/B g_row\[1\].g_col\[0\].pe__1819_/B
+ g_row\[1\].g_col\[0\].pe__1822_/C g_row\[1\].g_col\[0\].pe__1822_/D VGND VGND VPWR
+ VPWR g_row\[1\].g_col\[0\].pe__1822_/X sky130_fd_sc_hd__and4bb_2
XFILLER_7_697 VGND VGND VPWR VPWR sky130_fd_sc_hd__decap_3
Xg_row\[1\].g_col\[0\].pe__1753_ g_row\[1\].g_col\[0\].pe__1756_/A g_row\[1\].g_col\[0\].pe__1756_/B
+ VGND VGND VPWR VPWR g_row\[1\].g_col\[0\].pe__1770_/A sky130_fd_sc_hd__xor2_2
Xg_row\[0\].g_col\[0\].pe__1900_ g_row\[0\].g_col\[0\].pe__1868_/A g_row\[0\].g_col\[0\].pe__1868_/B
+ g_row\[0\].g_col\[0\].pe__1899_/X VGND VGND VPWR VPWR g_row\[0\].g_col\[0\].pe__1907_/A
+ sky130_fd_sc_hd__a21o_2
Xg_row\[1\].g_col\[0\].pe__1684_ place1098/X g_row\[1\].g_col\[0\].pe__1732_/A2 g_row\[1\].g_col\[0\].pe__1732_/B1
+ place1100/X VGND VGND VPWR VPWR g_row\[1\].g_col\[0\].pe__1685_/B sky130_fd_sc_hd__a22o_2
Xg_row\[1\].g_col\[0\].pe_hold2901 g_row\[1\].g_col\[0\].pe__2615_/X VGND VGND VPWR
+ VPWR g_row\[1\].g_col\[0\].pe_hold2901/X sky130_fd_sc_hd__clkbuf_2
Xg_row\[0\].g_col\[0\].pe__1831_ g_row\[0\].g_col\[0\].pe__1831_/A g_row\[0\].g_col\[0\].pe__1831_/B
+ VGND VGND VPWR VPWR g_row\[0\].g_col\[0\].pe__1832_/C sky130_fd_sc_hd__nand2_2
Xg_row\[0\].g_col\[0\].pe__1762_ g_row\[0\].g_col\[0\].pe__1808_/A g_row\[0\].g_col\[0\].pe__1762_/B
+ VGND VGND VPWR VPWR g_row\[0\].g_col\[0\].pe__1766_/A sky130_fd_sc_hd__xnor2_2
Xg_row\[1\].g_col\[1\].pe__2321_ g_row\[1\].g_col\[1\].pe__2368_/A g_row\[1\].g_col\[1\].pe__2348_/B
+ VGND VGND VPWR VPWR g_row\[1\].g_col\[1\].pe__2337_/C sky130_fd_sc_hd__and2_2
Xg_row\[1\].g_col\[0\].pe__2305_ g_row\[1\].g_col\[0\].pe__2305_/A g_row\[1\].g_col\[0\].pe__2305_/B
+ VGND VGND VPWR VPWR g_row\[1\].g_col\[0\].pe__2305_/Y sky130_fd_sc_hd__xnor2_2
XFILLER_53_538 VGND VGND VPWR VPWR sky130_fd_sc_hd__fill_1
Xg_row\[0\].g_col\[0\].pe__1693_ g_row\[0\].g_col\[0\].pe__1693_/A g_row\[0\].g_col\[0\].pe__1693_/B
+ VGND VGND VPWR VPWR g_row\[0\].g_col\[0\].pe__1695_/B sky130_fd_sc_hd__xor2_2
Xg_row\[1\].g_col\[1\].pe__2252_ g_row\[1\].g_col\[1\].pe__2273_/A g_row\[1\].g_col\[1\].pe__2273_/B
+ VGND VGND VPWR VPWR g_row\[1\].g_col\[1\].pe__2271_/A sky130_fd_sc_hd__xnor2_2
Xg_row\[1\].g_col\[0\].pe__2236_ g_row\[1\].g_col\[0\].pe__2236_/A1 g_row\[1\].g_col\[0\].pe__2233_/X
+ g_row\[1\].g_col\[0\].pe__2234_/Y g_row\[1\].g_col\[0\].pe__2236_/B1 g_row\[1\].g_col\[0\].pe__2404_/A1
+ VGND VGND VPWR VPWR g_row\[1\].g_col\[0\].pe__2236_/X sky130_fd_sc_hd__o32a_2
XTAP_TAPCELL_ROW_36_747 VGND VPWR sky130_fd_sc_hd__tapvpwrvgnd_1
Xg_row\[1\].g_col\[1\].pe__2183_ g_row\[1\].g_col\[1\].pe__2183_/A g_row\[1\].g_col\[1\].pe__2183_/B
+ VGND VGND VPWR VPWR g_row\[1\].g_col\[1\].pe__2203_/B sky130_fd_sc_hd__xor2_2
Xg_row\[1\].g_col\[0\].pe__2167_ g_row\[1\].g_col\[0\].pe__2167_/A g_row\[1\].g_col\[0\].pe__2167_/B
+ g_row\[1\].g_col\[0\].pe__2167_/C VGND VGND VPWR VPWR g_row\[1\].g_col\[0\].pe__2167_/X
+ sky130_fd_sc_hd__and3_2
XFILLER_34_785 VGND VGND VPWR VPWR sky130_fd_sc_hd__fill_2
Xg_row\[0\].g_col\[0\].pe__2314_ g_row\[0\].g_col\[0\].pe__2364_/A g_row\[0\].g_col\[0\].pe__2314_/B
+ VGND VGND VPWR VPWR g_row\[0\].g_col\[0\].pe__2316_/B sky130_fd_sc_hd__xnor2_2
Xg_row\[1\].g_col\[0\].pe__2098_ g_row\[1\].g_col\[0\].pe__2048_/A g_row\[1\].g_col\[0\].pe__2048_/B
+ g_row\[1\].g_col\[0\].pe__2048_/C g_row\[1\].g_col\[0\].pe__2047_/B g_row\[1\].g_col\[0\].pe__2047_/A
+ VGND VGND VPWR VPWR g_row\[1\].g_col\[0\].pe__2099_/C sky130_fd_sc_hd__a32o_2
Xg_row\[0\].g_col\[1\].pe__2330_ g_row\[0\].g_col\[1\].pe__2330_/A g_row\[0\].g_col\[1\].pe__2330_/B
+ g_row\[0\].g_col\[1\].pe__2330_/C VGND VGND VPWR VPWR g_row\[0\].g_col\[1\].pe__2330_/X
+ sky130_fd_sc_hd__or3_2
Xg_row\[0\].g_col\[1\].pe__2261_ g_row\[0\].g_col\[1\].pe__2262_/A g_row\[0\].g_col\[1\].pe__2262_/B
+ VGND VGND VPWR VPWR g_row\[0\].g_col\[1\].pe__2261_/Y sky130_fd_sc_hd__nor2_2
Xg_row\[0\].g_col\[0\].pe__2245_ g_row\[0\].g_col\[0\].pe__2288_/A g_row\[0\].g_col\[0\].pe__2288_/B
+ VGND VGND VPWR VPWR g_row\[0\].g_col\[0\].pe__2246_/B sky130_fd_sc_hd__xnor2_2
Xg_row\[0\].g_col\[0\].pe__2176_ g_row\[0\].g_col\[0\].pe__2175_/X g_row\[0\].g_col\[0\].pe__2132_/B
+ g_row\[0\].g_col\[0\].pe__2129_/B VGND VGND VPWR VPWR g_row\[0\].g_col\[0\].pe__2181_/A
+ sky130_fd_sc_hd__a21o_2
Xg_row\[0\].g_col\[1\].pe__2192_ g_row\[0\].g_col\[1\].pe__2192_/A g_row\[0\].g_col\[1\].pe__2192_/B
+ VGND VGND VPWR VPWR g_row\[0\].g_col\[1\].pe__2192_/Y sky130_fd_sc_hd__nor2_2
XFILLER_1_807 VGND VGND VPWR VPWR sky130_fd_sc_hd__fill_1
Xg_row\[1\].g_col\[1\].pe_hold1818 g_row\[1\].g_col\[1\].pe__2758_/Q VGND VGND VPWR
+ VPWR g_row\[1\].g_col\[1\].pe__2528_/A1 sky130_fd_sc_hd__clkbuf_2
Xg_row\[1\].g_col\[1\].pe_hold1807 g_row\[1\].g_col\[1\].pe__2535_/X VGND VGND VPWR
+ VPWR g_row\[1\].g_col\[1\].pe__2536_/B sky130_fd_sc_hd__clkbuf_2
Xg_row\[1\].g_col\[1\].pe__1967_ g_row\[1\].g_col\[1\].pe__1449_/A g_row\[1\].g_col\[1\].pe__1449_/B
+ g_row\[1\].g_col\[1\].pe__1966_/Y VGND VGND VPWR VPWR g_row\[1\].g_col\[1\].pe__1968_/C
+ sky130_fd_sc_hd__a21o_2
XTAP_TAPCELL_ROW_58_1081 VGND VPWR sky130_fd_sc_hd__tapvpwrvgnd_1
Xhold3201 hold3201/A VGND VGND VPWR VPWR hold3201/X sky130_fd_sc_hd__clkbuf_2
Xhold3212 hold3212/A VGND VGND VPWR VPWR hold3212/X sky130_fd_sc_hd__clkbuf_2
Xhold3223 hold3223/A VGND VGND VPWR VPWR hold3223/X sky130_fd_sc_hd__clkbuf_2
Xg_row\[1\].g_col\[1\].pe__1898_ g_row\[1\].g_col\[1\].pe__1604_/A g_row\[1\].g_col\[1\].pe__1604_/B
+ g_row\[1\].g_col\[1\].pe__1860_/B g_row\[1\].g_col\[1\].pe__1859_/B g_row\[1\].g_col\[1\].pe__1859_/A
+ VGND VGND VPWR VPWR g_row\[1\].g_col\[1\].pe__1939_/A sky130_fd_sc_hd__a32o_2
Xhold2500 hold3239/X VGND VGND VPWR VPWR hold3240/A sky130_fd_sc_hd__clkbuf_2
Xhold2511 hold3300/X VGND VGND VPWR VPWR hold3301/A sky130_fd_sc_hd__clkbuf_2
Xhold2522 hold3291/X VGND VGND VPWR VPWR hold3292/A sky130_fd_sc_hd__clkbuf_2
Xhold3234 hold3234/A VGND VGND VPWR VPWR hold3234/X sky130_fd_sc_hd__clkbuf_2
Xhold3245 hold3245/A VGND VGND VPWR VPWR hold3245/X sky130_fd_sc_hd__clkbuf_2
Xhold3256 b_inputs_flat[22] VGND VGND VPWR VPWR hold3256/X sky130_fd_sc_hd__clkbuf_2
Xhold3267 hold3267/A VGND VGND VPWR VPWR hold3267/X sky130_fd_sc_hd__clkbuf_2
XTAP_TAPCELL_ROW_71_1270 VGND VPWR sky130_fd_sc_hd__tapvpwrvgnd_1
XTAP_TAPCELL_ROW_71_1281 VGND VPWR sky130_fd_sc_hd__tapvpwrvgnd_1
Xhold2533 hold2533/A VGND VGND VPWR VPWR _325_/D sky130_fd_sc_hd__clkbuf_2
Xhold2544 _237_/Y VGND VGND VPWR VPWR hold2544/X sky130_fd_sc_hd__clkbuf_2
Xhold2555 hold3318/X VGND VGND VPWR VPWR _241_/B_N sky130_fd_sc_hd__clkbuf_2
Xhold3278 hold3278/A VGND VGND VPWR VPWR hold3278/X sky130_fd_sc_hd__clkbuf_2
Xhold3289 hold3289/A VGND VGND VPWR VPWR hold3289/X sky130_fd_sc_hd__clkbuf_2
XFILLER_84_641 VGND VGND VPWR VPWR sky130_fd_sc_hd__decap_3
Xclkbuf_leaf_95_clk clkbuf_4_2_0_clk/X VGND VGND VPWR VPWR clkbuf_leaf_95_clk/X sky130_fd_sc_hd__clkbuf_16
Xhold2566 hold3323/X VGND VGND VPWR VPWR hold3324/A sky130_fd_sc_hd__clkbuf_2
Xhold2577 hold3307/X VGND VGND VPWR VPWR hold3308/A sky130_fd_sc_hd__clkbuf_2
Xhold2588 hold3340/X VGND VGND VPWR VPWR hold3341/A sky130_fd_sc_hd__clkbuf_2
Xg_row\[1\].g_col\[1\].pe__2519_ g_row\[1\].g_col\[1\].pe__2519_/A g_row\[1\].g_col\[1\].pe__2519_/B
+ VGND VGND VPWR VPWR g_row\[1\].g_col\[1\].pe__2519_/Y sky130_fd_sc_hd__nand2_2
Xg_row\[0\].g_col\[1\].pe__1976_ g_row\[0\].g_col\[1\].pe__2177_/A1 g_row\[0\].g_col\[1\].pe__1657_/B
+ g_row\[0\].g_col\[1\].pe__2247_/B1 g_row\[0\].g_col\[1\].pe__2616_/B VGND VGND VPWR
+ VPWR g_row\[0\].g_col\[1\].pe__1977_/B sky130_fd_sc_hd__a22o_2
XFILLER_17_719 VGND VGND VPWR VPWR sky130_fd_sc_hd__decap_3
XFILLER_56_343 VGND VGND VPWR VPWR sky130_fd_sc_hd__decap_3
Xhold1876 hold3023/X VGND VGND VPWR VPWR hold1876/X sky130_fd_sc_hd__clkbuf_2
Xhold1887 hold3003/X VGND VGND VPWR VPWR hold1887/X sky130_fd_sc_hd__clkbuf_2
Xhold2599 hold2599/A VGND VGND VPWR VPWR _321_/D sky130_fd_sc_hd__clkbuf_2
XFILLER_83_173 VGND VGND VPWR VPWR sky130_fd_sc_hd__fill_2
Xhold1898 hold3029/X VGND VGND VPWR VPWR hold1898/X sky130_fd_sc_hd__clkbuf_2
XFILLER_71_335 VGND VGND VPWR VPWR sky130_fd_sc_hd__fill_1
XFILLER_25_785 VGND VGND VPWR VPWR sky130_fd_sc_hd__fill_2
XTAP_TAPCELL_ROW_14_419 VGND VPWR sky130_fd_sc_hd__tapvpwrvgnd_1
XFILLER_40_755 VGND VGND VPWR VPWR sky130_fd_sc_hd__fill_1
Xg_row\[0\].g_col\[1\].pe__2528_ g_row\[0\].g_col\[1\].pe__2528_/A1 g_row\[0\].g_col\[1\].pe__2591_/A2
+ g_row\[0\].g_col\[1\].pe__2591_/B1 g_row\[0\].g_col\[1\].pe__2527_/X VGND VGND VPWR
+ VPWR g_row\[0\].g_col\[1\].pe__2528_/X sky130_fd_sc_hd__a22o_2
XFILLER_8_406 VGND VGND VPWR VPWR sky130_fd_sc_hd__fill_1
Xg_row\[0\].g_col\[1\].pe__2459_ g_row\[0\].g_col\[1\].pe__2754_/Q g_row\[0\].g_col\[1\].pe__2739_/Q
+ VGND VGND VPWR VPWR g_row\[0\].g_col\[1\].pe__2460_/B sky130_fd_sc_hd__and2b_2
XFILLER_4_645 VGND VGND VPWR VPWR sky130_fd_sc_hd__decap_3
XFILLER_4_678 VGND VGND VPWR VPWR sky130_fd_sc_hd__decap_3
Xclkbuf_leaf_86_clk clkbuf_4_8_0_clk/X VGND VGND VPWR VPWR clkload14/A sky130_fd_sc_hd__clkbuf_16
XFILLER_35_505 VGND VGND VPWR VPWR sky130_fd_sc_hd__decap_3
XFILLER_47_332 VGND VGND VPWR VPWR sky130_fd_sc_hd__decap_3
XTAP_TAPCELL_ROW_89_1542 VGND VPWR sky130_fd_sc_hd__tapvpwrvgnd_1
XFILLER_35_516 VGND VGND VPWR VPWR sky130_fd_sc_hd__decap_3
XFILLER_62_324 VGND VGND VPWR VPWR sky130_fd_sc_hd__fill_1
XFILLER_74_61 VGND VGND VPWR VPWR sky130_fd_sc_hd__fill_1
XFILLER_16_730 VGND VGND VPWR VPWR sky130_fd_sc_hd__fill_2
XFILLER_16_752 VGND VGND VPWR VPWR sky130_fd_sc_hd__decap_3
XFILLER_74_83 VGND VGND VPWR VPWR sky130_fd_sc_hd__fill_1
Xg_row\[1\].g_col\[0\].pe__2021_ g_row\[1\].g_col\[0\].pe__2021_/A g_row\[1\].g_col\[0\].pe__2021_/B
+ VGND VGND VPWR VPWR g_row\[1\].g_col\[0\].pe__2071_/B sky130_fd_sc_hd__xnor2_2
XFILLER_15_262 VGND VGND VPWR VPWR sky130_fd_sc_hd__fill_1
XFILLER_62_379 VGND VGND VPWR VPWR sky130_fd_sc_hd__fill_2
XTAP_TAPCELL_ROW_33_706 VGND VPWR sky130_fd_sc_hd__tapvpwrvgnd_1
Xg_row\[0\].g_col\[1\].pe_hold2190 g_row\[0\].g_col\[1\].pe__2615_/X VGND VGND VPWR
+ VPWR g_row\[0\].g_col\[1\].pe__2696_/D sky130_fd_sc_hd__clkbuf_2
XFILLER_90_82 VGND VGND VPWR VPWR sky130_fd_sc_hd__fill_2
Xclkbuf_leaf_10_clk clkload0/A VGND VGND VPWR VPWR clkbuf_leaf_10_clk/X sky130_fd_sc_hd__clkbuf_16
Xg_row\[0\].g_col\[0\].pe__2030_ g_row\[0\].g_col\[0\].pe__2030_/A g_row\[0\].g_col\[0\].pe__2163_/B
+ VGND VGND VPWR VPWR g_row\[0\].g_col\[0\].pe__2032_/B sky130_fd_sc_hd__nand2_2
Xg_row\[1\].g_col\[1\].pe__1821_ g_row\[1\].g_col\[1\].pe__1822_/C g_row\[1\].g_col\[1\].pe__1821_/B
+ g_row\[1\].g_col\[1\].pe__1821_/C g_row\[1\].g_col\[1\].pe__1821_/D VGND VGND VPWR
+ VPWR g_row\[1\].g_col\[1\].pe__1821_/X sky130_fd_sc_hd__and4_2
Xg_row\[1\].g_col\[0\].pe__1805_ g_row\[1\].g_col\[0\].pe__1804_/A place1104/X place1106/X
+ g_row\[1\].g_col\[0\].pe__1804_/X g_row\[1\].g_col\[0\].pe__1801_/X VGND VGND VPWR
+ VPWR g_row\[1\].g_col\[0\].pe__1808_/B sky130_fd_sc_hd__a221o_2
Xg_row\[1\].g_col\[1\].pe__1752_ g_row\[1\].g_col\[1\].pe__1785_/A g_row\[1\].g_col\[1\].pe__1752_/B
+ VGND VGND VPWR VPWR g_row\[1\].g_col\[1\].pe__1756_/B sky130_fd_sc_hd__xor2_2
Xg_row\[1\].g_col\[0\].pe__1736_ g_row\[1\].g_col\[0\].pe__1736_/A g_row\[1\].g_col\[0\].pe__1736_/B
+ VGND VGND VPWR VPWR g_row\[1\].g_col\[0\].pe__1740_/B sky130_fd_sc_hd__xnor2_2
Xg_row\[1\].g_col\[1\].pe__1683_ g_row\[1\].g_col\[1\].pe__1686_/A g_row\[1\].g_col\[1\].pe__1686_/B
+ VGND VGND VPWR VPWR g_row\[1\].g_col\[1\].pe__1713_/A sky130_fd_sc_hd__xor2_2
Xg_row\[1\].g_col\[0\].pe__1667_ g_row\[1\].g_col\[0\].pe__1663_/A g_row\[1\].g_col\[0\].pe__1663_/B
+ g_row\[1\].g_col\[0\].pe__1666_/Y VGND VGND VPWR VPWR g_row\[1\].g_col\[0\].pe__1701_/B
+ sky130_fd_sc_hd__a21boi_2
XFILLER_57_118 VGND VGND VPWR VPWR sky130_fd_sc_hd__fill_2
Xclkbuf_leaf_77_clk clkbuf_4_10_0_clk/X VGND VGND VPWR VPWR clkbuf_leaf_77_clk/X sky130_fd_sc_hd__clkbuf_16
Xg_row\[1\].g_col\[0\].pe__1598_ g_row\[1\].g_col\[0\].pe__2603_/B g_row\[1\].g_col\[0\].pe__1901_/A2
+ g_row\[1\].g_col\[0\].pe__2177_/B1 g_row\[1\].g_col\[0\].pe__2599_/B VGND VGND VPWR
+ VPWR g_row\[1\].g_col\[0\].pe__1604_/A sky130_fd_sc_hd__a22o_2
Xg_row\[0\].g_col\[1\].pe__1830_ g_row\[0\].g_col\[1\].pe__1830_/A g_row\[0\].g_col\[1\].pe__1830_/B
+ g_row\[0\].g_col\[1\].pe__1830_/C VGND VGND VPWR VPWR g_row\[0\].g_col\[1\].pe__1832_/B
+ sky130_fd_sc_hd__or3_2
XFILLER_26_505 VGND VGND VPWR VPWR sky130_fd_sc_hd__decap_3
XFILLER_66_641 VGND VGND VPWR VPWR sky130_fd_sc_hd__decap_3
Xg_row\[0\].g_col\[0\].pe__1814_ g_row\[0\].g_col\[0\].pe__1779_/Y g_row\[0\].g_col\[0\].pe__1812_/X
+ g_row\[0\].g_col\[0\].pe__1813_/Y VGND VGND VPWR VPWR g_row\[0\].g_col\[0\].pe__1821_/B
+ sky130_fd_sc_hd__o21ai_2
XFILLER_38_365 VGND VGND VPWR VPWR sky130_fd_sc_hd__fill_1
XFILLER_38_398 VGND VGND VPWR VPWR sky130_fd_sc_hd__fill_1
XFILLER_53_302 VGND VGND VPWR VPWR sky130_fd_sc_hd__decap_3
XFILLER_81_633 VGND VGND VPWR VPWR sky130_fd_sc_hd__decap_3
Xg_row\[0\].g_col\[0\].pe__1745_ g_row\[0\].g_col\[0\].pe__1745_/A g_row\[0\].g_col\[0\].pe__1745_/B
+ VGND VGND VPWR VPWR g_row\[0\].g_col\[0\].pe__1819_/B sky130_fd_sc_hd__xnor2_2
Xg_row\[1\].g_col\[1\].pe__2304_ g_row\[1\].g_col\[1\].pe__2304_/A g_row\[1\].g_col\[1\].pe__2304_/B
+ g_row\[1\].g_col\[1\].pe__2304_/C VGND VGND VPWR VPWR g_row\[1\].g_col\[1\].pe__2305_/B
+ sky130_fd_sc_hd__and3_2
Xg_row\[0\].g_col\[1\].pe__1761_ g_row\[0\].g_col\[1\].pe__1804_/A g_row\[0\].g_col\[1\].pe__1761_/A2
+ g_row\[0\].g_col\[1\].pe__1782_/A2 g_row\[0\].g_col\[1\].pe__1804_/B VGND VGND VPWR
+ VPWR g_row\[0\].g_col\[1\].pe__1762_/B sky130_fd_sc_hd__a22o_2
XFILLER_53_346 VGND VGND VPWR VPWR sky130_fd_sc_hd__fill_1
Xg_row\[0\].g_col\[0\].pe__1676_ g_row\[0\].g_col\[0\].pe__1676_/A g_row\[0\].g_col\[0\].pe__1676_/B
+ VGND VGND VPWR VPWR g_row\[0\].g_col\[0\].pe__1677_/B sky130_fd_sc_hd__and2_2
Xg_row\[0\].g_col\[1\].pe__1692_ g_row\[0\].g_col\[1\].pe__1689_/Y g_row\[0\].g_col\[1\].pe__1722_/B
+ g_row\[0\].g_col\[1\].pe__1691_/Y VGND VGND VPWR VPWR g_row\[0\].g_col\[1\].pe__1695_/A
+ sky130_fd_sc_hd__a21o_2
Xg_row\[1\].g_col\[1\].pe__2235_ g_row\[1\].g_col\[1\].pe__2235_/A VGND VGND VPWR
+ VPWR g_row\[1\].g_col\[1\].pe__2436_/A sky130_fd_sc_hd__inv_2
Xg_row\[1\].g_col\[0\].pe__2219_ g_row\[1\].g_col\[0\].pe__2219_/A g_row\[1\].g_col\[0\].pe__2219_/B
+ VGND VGND VPWR VPWR g_row\[1\].g_col\[0\].pe__2220_/B sky130_fd_sc_hd__xor2_2
XFILLER_22_733 VGND VGND VPWR VPWR sky130_fd_sc_hd__decap_3
Xg_row\[1\].g_col\[1\].pe__2166_ g_row\[1\].g_col\[1\].pe__2165_/B g_row\[1\].g_col\[1\].pe__2165_/C
+ g_row\[1\].g_col\[1\].pe__2165_/A VGND VGND VPWR VPWR g_row\[1\].g_col\[1\].pe__2167_/C
+ sky130_fd_sc_hd__a21o_2
XPHY_EDGE_ROW_3_Right_3 VGND VGND VPWR VPWR sky130_fd_sc_hd__decap_3
Xg_row\[1\].g_col\[1\].pe__2097_ g_row\[1\].g_col\[1\].pe__2097_/A g_row\[1\].g_col\[1\].pe__2097_/B
+ g_row\[1\].g_col\[1\].pe__2097_/C VGND VGND VPWR VPWR g_row\[1\].g_col\[1\].pe__2184_/B
+ sky130_fd_sc_hd__or3_4
Xg_row\[0\].g_col\[1\].pe__2313_ g_row\[0\].g_col\[1\].pe__2632_/B g_row\[0\].g_col\[1\].pe__2313_/A2
+ g_row\[0\].g_col\[1\].pe__1541_/X g_row\[0\].g_col\[1\].pe__2630_/B VGND VGND VPWR
+ VPWR g_row\[0\].g_col\[1\].pe__2314_/B sky130_fd_sc_hd__a22o_2
Xg_row\[0\].g_col\[0\].pe__2228_ g_row\[0\].g_col\[0\].pe__2228_/A g_row\[0\].g_col\[0\].pe__2228_/B
+ g_row\[0\].g_col\[0\].pe__2228_/C VGND VGND VPWR VPWR g_row\[0\].g_col\[0\].pe__2229_/B
+ sky130_fd_sc_hd__or3_2
Xg_row\[0\].g_col\[1\].pe__2244_ g_row\[0\].g_col\[1\].pe__2277_/A g_row\[0\].g_col\[1\].pe__2277_/B
+ VGND VGND VPWR VPWR g_row\[0\].g_col\[1\].pe__2288_/B sky130_fd_sc_hd__xor2_2
Xg_row\[1\].g_col\[1\].pe_hold3028 g_row\[1\].g_col\[1\].pe__2646_/X VGND VGND VPWR
+ VPWR g_row\[1\].g_col\[1\].pe_hold3028/X sky130_fd_sc_hd__clkbuf_2
Xg_row\[0\].g_col\[1\].pe__2175_ g_row\[0\].g_col\[1\].pe__2128_/B g_row\[0\].g_col\[1\].pe__2128_/C
+ g_row\[0\].g_col\[1\].pe__2128_/A VGND VGND VPWR VPWR g_row\[0\].g_col\[1\].pe__2175_/X
+ sky130_fd_sc_hd__a21o_2
Xg_row\[0\].g_col\[0\].pe__2159_ g_row\[0\].g_col\[0\].pe__2335_/A g_row\[0\].g_col\[0\].pe__2159_/B
+ VGND VGND VPWR VPWR g_row\[0\].g_col\[0\].pe__2745_/D sky130_fd_sc_hd__nor2_2
XTAP_TAPCELL_ROW_73_1310 VGND VPWR sky130_fd_sc_hd__tapvpwrvgnd_1
Xg_row\[1\].g_col\[1\].pe_hold1648 g_row\[1\].g_col\[1\].pe__2114_/X VGND VGND VPWR
+ VPWR g_row\[1\].g_col\[1\].pe__2115_/B sky130_fd_sc_hd__clkbuf_2
XFILLER_0_169 VGND VGND VPWR VPWR sky130_fd_sc_hd__fill_1
XFILLER_76_438 VGND VGND VPWR VPWR sky130_fd_sc_hd__fill_1
Xhold2363 hold2363/A VGND VGND VPWR VPWR hold2363/X sky130_fd_sc_hd__clkbuf_2
XFILLER_57_663 VGND VGND VPWR VPWR sky130_fd_sc_hd__decap_3
Xclkbuf_leaf_68_clk clkload5/A VGND VGND VPWR VPWR _302_/CLK sky130_fd_sc_hd__clkbuf_16
Xhold1640 hold1640/A VGND VGND VPWR VPWR hold1640/X sky130_fd_sc_hd__clkbuf_2
XFILLER_17_505 VGND VGND VPWR VPWR sky130_fd_sc_hd__decap_3
XFILLER_72_611 VGND VGND VPWR VPWR sky130_fd_sc_hd__decap_3
Xg_row\[0\].g_col\[1\].pe__1959_ g_row\[0\].g_col\[1\].pe__2179_/A g_row\[0\].g_col\[1\].pe__1959_/B
+ VGND VGND VPWR VPWR g_row\[0\].g_col\[1\].pe__1961_/B sky130_fd_sc_hd__xnor2_2
XFILLER_29_398 VGND VGND VPWR VPWR sky130_fd_sc_hd__decap_3
XFILLER_44_346 VGND VGND VPWR VPWR sky130_fd_sc_hd__decap_3
XFILLER_71_110 VGND VGND VPWR VPWR sky130_fd_sc_hd__fill_2
XFILLER_13_700 VGND VGND VPWR VPWR sky130_fd_sc_hd__fill_2
XFILLER_44_42 VGND VGND VPWR VPWR sky130_fd_sc_hd__decap_3
XFILLER_71_165 VGND VGND VPWR VPWR sky130_fd_sc_hd__decap_3
XFILLER_72_677 VGND VGND VPWR VPWR sky130_fd_sc_hd__decap_3
XFILLER_72_699 VGND VGND VPWR VPWR sky130_fd_sc_hd__fill_1
XFILLER_12_210 VGND VGND VPWR VPWR sky130_fd_sc_hd__decap_3
XTAP_TAPCELL_ROW_84_1472 VGND VPWR sky130_fd_sc_hd__tapvpwrvgnd_1
XFILLER_40_541 VGND VGND VPWR VPWR sky130_fd_sc_hd__fill_1
XFILLER_9_726 VGND VGND VPWR VPWR sky130_fd_sc_hd__fill_2
Xg_row\[0\].g_col\[0\].pe_place1232 g_row\[0\].g_col\[0\].pe__1377_/Y VGND VGND VPWR
+ VPWR g_row\[0\].g_col\[0\].pe__2677_/B1 sky130_fd_sc_hd__buf_6
XFILLER_60_85 VGND VGND VPWR VPWR sky130_fd_sc_hd__fill_2
Xg_row\[0\].g_col\[0\].pe_place1254 _273_/Q VGND VGND VPWR VPWR g_row\[0\].g_col\[0\].pe__2639_/A
+ sky130_fd_sc_hd__buf_6
Xg_row\[1\].g_col\[1\].pe_hold2872 g_row\[1\].g_col\[1\].pe__2715_/Q VGND VGND VPWR
+ VPWR g_row\[1\].g_col\[1\].pe__2659_/B sky130_fd_sc_hd__clkbuf_2
Xg_row\[1\].g_col\[1\].pe_hold2883 g_row\[1\].g_col\[1\].pe__2721_/Q VGND VGND VPWR
+ VPWR g_row\[1\].g_col\[1\].pe_hold2883/X sky130_fd_sc_hd__clkbuf_2
Xg_row\[1\].g_col\[0\].pe__1521_ place1087/X g_row\[1\].g_col\[0\].pe__1732_/A2 g_row\[1\].g_col\[0\].pe__1732_/B1
+ place1089/X VGND VGND VPWR VPWR g_row\[1\].g_col\[0\].pe__1522_/B sky130_fd_sc_hd__a22o_2
XFILLER_48_630 VGND VGND VPWR VPWR sky130_fd_sc_hd__decap_3
XFILLER_67_449 VGND VGND VPWR VPWR sky130_fd_sc_hd__decap_3
Xg_row\[1\].g_col\[0\].pe_hold2049 g_row\[1\].g_col\[0\].pe__2685_/X VGND VGND VPWR
+ VPWR g_row\[1\].g_col\[0\].pe__2725_/D sky130_fd_sc_hd__clkbuf_2
Xg_row\[1\].g_col\[0\].pe__1452_ g_row\[1\].g_col\[0\].pe__1816_/A g_row\[1\].g_col\[0\].pe__1452_/B
+ VGND VGND VPWR VPWR g_row\[1\].g_col\[0\].pe__1507_/A sky130_fd_sc_hd__xor2_2
XFILLER_48_652 VGND VGND VPWR VPWR sky130_fd_sc_hd__fill_1
Xclkbuf_leaf_59_clk clkload7/A VGND VGND VPWR VPWR clkbuf_leaf_59_clk/X sky130_fd_sc_hd__clkbuf_16
Xg_row\[1\].g_col\[0\].pe__1383_ hold1896/X g_row\[1\].g_col\[0\].pe__1387_/B VGND
+ VGND VPWR VPWR g_row\[1\].g_col\[0\].pe__1383_/X sky130_fd_sc_hd__or2_2
XFILLER_63_633 VGND VGND VPWR VPWR sky130_fd_sc_hd__fill_2
Xg_row\[0\].g_col\[0\].pe__1530_ g_row\[0\].g_col\[0\].pe__1957_/B2 g_row\[0\].g_col\[0\].pe__1657_/B
+ g_row\[0\].g_col\[0\].pe__2247_/B1 place1218/X VGND VGND VPWR VPWR g_row\[0\].g_col\[0\].pe__1531_/B
+ sky130_fd_sc_hd__a22o_2
XFILLER_16_560 VGND VGND VPWR VPWR sky130_fd_sc_hd__decap_3
XFILLER_51_806 VGND VGND VPWR VPWR sky130_fd_sc_hd__fill_1
XFILLER_51_839 VGND VGND VPWR VPWR sky130_fd_sc_hd__fill_1
XFILLER_62_165 VGND VGND VPWR VPWR sky130_fd_sc_hd__fill_1
Xg_row\[1\].g_col\[1\].pe__2020_ g_row\[1\].g_col\[1\].pe__2177_/B2 g_row\[1\].g_col\[1\].pe__2313_/A2
+ g_row\[1\].g_col\[1\].pe__2313_/B1 g_row\[1\].g_col\[1\].pe__2138_/B2 VGND VGND
+ VPWR VPWR g_row\[1\].g_col\[1\].pe__2021_/B sky130_fd_sc_hd__a22o_2
XTAP_TAPCELL_ROW_46_897 VGND VPWR sky130_fd_sc_hd__tapvpwrvgnd_1
Xg_row\[0\].g_col\[0\].pe__1461_ g_row\[0\].g_col\[0\].pe__1461_/A g_row\[0\].g_col\[0\].pe__1461_/B
+ VGND VGND VPWR VPWR g_row\[0\].g_col\[0\].pe__1461_/Y sky130_fd_sc_hd__nand2_2
Xg_row\[1\].g_col\[0\].pe__2004_ g_row\[1\].g_col\[0\].pe__2005_/A g_row\[1\].g_col\[0\].pe__2005_/B
+ VGND VGND VPWR VPWR g_row\[1\].g_col\[0\].pe__2006_/A sky130_fd_sc_hd__and2_2
XFILLER_93_3 VGND VGND VPWR VPWR sky130_fd_sc_hd__fill_1
Xg_row\[0\].g_col\[0\].pe__1392_ g_row\[0\].g_col\[0\].pe__1392_/A g_row\[0\].g_col\[0\].pe__1402_/B
+ VGND VGND VPWR VPWR g_row\[0\].g_col\[0\].pe__1392_/X sky130_fd_sc_hd__or2_2
Xg_row\[0\].g_col\[0\].pe__2013_ g_row\[0\].g_col\[0\].pe__2013_/A g_row\[0\].g_col\[0\].pe__2013_/B
+ VGND VGND VPWR VPWR g_row\[0\].g_col\[0\].pe__2153_/A sky130_fd_sc_hd__nor2_2
Xg_row\[1\].g_col\[1\].pe__1804_ g_row\[1\].g_col\[1\].pe__1804_/A g_row\[1\].g_col\[1\].pe__1804_/B
+ VGND VGND VPWR VPWR g_row\[1\].g_col\[1\].pe__1804_/X sky130_fd_sc_hd__or2_2
XTAP_TAPCELL_ROW_55_1040 VGND VPWR sky130_fd_sc_hd__tapvpwrvgnd_1
Xg_row\[1\].g_col\[1\].pe__1735_ g_row\[1\].g_col\[1\].pe__1758_/A g_row\[1\].g_col\[1\].pe__1758_/B
+ g_row\[1\].g_col\[1\].pe__1734_/X VGND VGND VPWR VPWR g_row\[1\].g_col\[1\].pe__1740_/A
+ sky130_fd_sc_hd__a21oi_2
Xg_row\[1\].g_col\[0\].pe__2768_ clkbuf_leaf_53_clk/X g_row\[1\].g_col\[0\].pe__2768_/D
+ VGND VGND VPWR VPWR g_row\[1\].g_col\[0\].pe__2768_/Q sky130_fd_sc_hd__dfxtp_2
Xg_row\[1\].g_col\[0\].pe__2699_ clkbuf_leaf_67_clk/X g_row\[1\].g_col\[0\].pe__2699_/D
+ VGND VGND VPWR VPWR hold3129/A sky130_fd_sc_hd__dfxtp_2
Xg_row\[1\].g_col\[0\].pe__1719_ g_row\[1\].g_col\[0\].pe__1714_/A g_row\[1\].g_col\[0\].pe__1714_/B
+ g_row\[1\].g_col\[0\].pe__1714_/C VGND VGND VPWR VPWR g_row\[1\].g_col\[0\].pe__1719_/Y
+ sky130_fd_sc_hd__a21oi_2
Xg_row\[1\].g_col\[1\].pe__1666_ g_row\[1\].g_col\[1\].pe__1697_/B g_row\[1\].g_col\[1\].pe__1697_/A
+ VGND VGND VPWR VPWR g_row\[1\].g_col\[1\].pe__1666_/Y sky130_fd_sc_hd__nand2b_2
Xg_row\[1\].g_col\[1\].pe__1597_ g_row\[1\].g_col\[1\].pe__1571_/A g_row\[1\].g_col\[1\].pe__1571_/B
+ g_row\[1\].g_col\[1\].pe__1596_/X VGND VGND VPWR VPWR g_row\[1\].g_col\[1\].pe__1606_/A
+ sky130_fd_sc_hd__a21oi_2
Xg_row\[1\].g_col\[0\].pe_hold1871 g_row\[1\].g_col\[0\].pe__2606_/X VGND VGND VPWR
+ VPWR g_row\[1\].g_col\[0\].pe__2692_/D sky130_fd_sc_hd__clkbuf_2
Xg_row\[1\].g_col\[0\].pe_hold1860 g_row\[1\].g_col\[0\].pe_hold3078/X VGND VGND VPWR
+ VPWR g_row\[1\].g_col\[0\].pe__1395_/A1 sky130_fd_sc_hd__clkbuf_2
Xg_row\[0\].g_col\[1\].pe__1813_ g_row\[0\].g_col\[1\].pe__1813_/A g_row\[0\].g_col\[1\].pe__1813_/B
+ VGND VGND VPWR VPWR g_row\[0\].g_col\[1\].pe__1813_/Y sky130_fd_sc_hd__nand2_2
XANTENNA_109 _340_/D VGND VGND VPWR VPWR sky130_fd_sc_hd__diode_2
Xg_row\[0\].g_col\[1\].pe__1744_ g_row\[0\].g_col\[1\].pe__1815_/B g_row\[0\].g_col\[1\].pe__1815_/A
+ VGND VGND VPWR VPWR g_row\[0\].g_col\[1\].pe__1819_/A sky130_fd_sc_hd__nand2b_2
Xg_row\[1\].g_col\[0\].pe_hold1893 g_row\[1\].g_col\[0\].pe_hold2882/X VGND VGND VPWR
+ VPWR g_row\[1\].g_col\[0\].pe__2721_/D sky130_fd_sc_hd__clkbuf_2
XFILLER_42_839 VGND VGND VPWR VPWR sky130_fd_sc_hd__decap_3
XFILLER_54_666 VGND VGND VPWR VPWR sky130_fd_sc_hd__decap_3
Xg_row\[0\].g_col\[0\].pe__1728_ g_row\[0\].g_col\[0\].pe__1808_/A g_row\[0\].g_col\[0\].pe__1728_/B
+ VGND VGND VPWR VPWR g_row\[0\].g_col\[0\].pe__1734_/A sky130_fd_sc_hd__xnor2_2
Xg_row\[0\].g_col\[0\].pe__1659_ g_row\[0\].g_col\[0\].pe__1659_/A g_row\[0\].g_col\[0\].pe__1664_/A
+ VGND VGND VPWR VPWR g_row\[0\].g_col\[0\].pe__1693_/B sky130_fd_sc_hd__xnor2_2
Xg_row\[0\].g_col\[1\].pe__1675_ g_row\[0\].g_col\[1\].pe__1676_/A g_row\[0\].g_col\[1\].pe__1676_/B
+ VGND VGND VPWR VPWR g_row\[0\].g_col\[1\].pe__1823_/A sky130_fd_sc_hd__nor2_2
Xg_row\[1\].g_col\[1\].pe__2218_ g_row\[1\].g_col\[1\].pe__2239_/A g_row\[1\].g_col\[1\].pe__2239_/B
+ VGND VGND VPWR VPWR g_row\[1\].g_col\[1\].pe__2219_/B sky130_fd_sc_hd__xor2_2
XFILLER_22_552 VGND VGND VPWR VPWR sky130_fd_sc_hd__decap_3
XTAP_TAPCELL_ROW_24_569 VGND VPWR sky130_fd_sc_hd__tapvpwrvgnd_1
Xg_row\[1\].g_col\[1\].pe__2149_ g_row\[1\].g_col\[1\].pe__2161_/A g_row\[1\].g_col\[1\].pe__2161_/B
+ VGND VGND VPWR VPWR g_row\[1\].g_col\[1\].pe__2200_/A sky130_fd_sc_hd__xnor2_2
Xg_row\[0\].g_col\[1\].pe__2227_ g_row\[0\].g_col\[1\].pe__2228_/A g_row\[0\].g_col\[1\].pe__2228_/B
+ g_row\[0\].g_col\[1\].pe__2228_/C VGND VGND VPWR VPWR g_row\[0\].g_col\[1\].pe__2262_/A
+ sky130_fd_sc_hd__o21ai_2
Xg_row\[1\].g_col\[1\].pe_hold2124 g_row\[1\].g_col\[1\].pe__1395_/X VGND VGND VPWR
+ VPWR g_row\[1\].g_col\[1\].pe__2733_/D sky130_fd_sc_hd__clkbuf_2
Xg_row\[0\].g_col\[1\].pe__2158_ place1250/X g_row\[0\].g_col\[1\].pe__2158_/A2 g_row\[0\].g_col\[1\].pe__2155_/X
+ g_row\[0\].g_col\[1\].pe__2157_/Y VGND VGND VPWR VPWR g_row\[0\].g_col\[1\].pe__2158_/X
+ sky130_fd_sc_hd__o22a_2
Xg_row\[0\].g_col\[1\].pe__2089_ g_row\[0\].g_col\[1\].pe__2241_/A1 g_row\[0\].g_col\[1\].pe__1471_/X
+ g_row\[0\].g_col\[1\].pe__1474_/Y g_row\[0\].g_col\[1\].pe__2699_/Q VGND VGND VPWR
+ VPWR g_row\[0\].g_col\[1\].pe__2090_/B sky130_fd_sc_hd__a22o_2
XFILLER_49_427 VGND VGND VPWR VPWR sky130_fd_sc_hd__fill_2
XFILLER_76_213 VGND VGND VPWR VPWR sky130_fd_sc_hd__decap_3
XTAP_TAPCELL_ROW_4_272 VGND VPWR sky130_fd_sc_hd__tapvpwrvgnd_1
XTAP_TAPCELL_ROW_86_1501 VGND VPWR sky130_fd_sc_hd__tapvpwrvgnd_1
Xhold1470 hold2496/X VGND VGND VPWR VPWR hold2497/A sky130_fd_sc_hd__clkbuf_2
XFILLER_29_173 VGND VGND VPWR VPWR sky130_fd_sc_hd__decap_3
Xhold1481 hold3296/X VGND VGND VPWR VPWR hold3297/A sky130_fd_sc_hd__clkbuf_2
Xhold1492 hold3257/X VGND VGND VPWR VPWR hold3258/A sky130_fd_sc_hd__clkbuf_2
Xg_row\[1\].g_col\[0\].pe_place842 g_row\[1\].g_col\[0\].pe__2010_/A VGND VGND VPWR
+ VPWR g_row\[1\].g_col\[0\].pe__2236_/A1 sky130_fd_sc_hd__buf_6
XFILLER_33_839 VGND VGND VPWR VPWR sky130_fd_sc_hd__fill_1
XFILLER_45_699 VGND VGND VPWR VPWR sky130_fd_sc_hd__fill_2
XTAP_TAPCELL_ROW_43_856 VGND VPWR sky130_fd_sc_hd__tapvpwrvgnd_1
Xg_row\[0\].g_col\[0\].pe_hold1958 g_row\[0\].g_col\[0\].pe__2752_/Q VGND VGND VPWR
+ VPWR g_row\[0\].g_col\[0\].pe__2380_/B1 sky130_fd_sc_hd__clkbuf_2
XFILLER_9_589 VGND VGND VPWR VPWR sky130_fd_sc_hd__decap_3
XFILLER_5_751 VGND VGND VPWR VPWR sky130_fd_sc_hd__decap_3
Xg_row\[1\].g_col\[0\].pe__2622_ g_row\[1\].g_col\[0\].pe__2626_/A1 g_row\[1\].g_col\[0\].pe__2622_/A2
+ g_row\[1\].g_col\[0\].pe__2626_/B1 g_row\[1\].g_col\[0\].pe__2621_/X VGND VGND VPWR
+ VPWR g_row\[1\].g_col\[0\].pe__2622_/X sky130_fd_sc_hd__o211a_2
Xg_row\[1\].g_col\[0\].pe__2553_ g_row\[1\].g_col\[0\].pe__2551_/Y g_row\[1\].g_col\[0\].pe__2552_/X
+ g_row\[1\].g_col\[0\].pe__2559_/A VGND VGND VPWR VPWR g_row\[1\].g_col\[0\].pe__2553_/X
+ sky130_fd_sc_hd__a21o_2
Xg_row\[1\].g_col\[1\].pe_hold1990 g_row\[1\].g_col\[1\].pe_hold3097/X VGND VGND VPWR
+ VPWR g_row\[1\].g_col\[1\].pe__2704_/D sky130_fd_sc_hd__clkbuf_2
Xg_row\[1\].g_col\[1\].pe__1520_ g_row\[1\].g_col\[1\].pe__1580_/A g_row\[1\].g_col\[1\].pe__1580_/B
+ VGND VGND VPWR VPWR g_row\[1\].g_col\[1\].pe__1523_/A sky130_fd_sc_hd__xor2_2
Xg_row\[1\].g_col\[0\].pe__2484_ g_row\[1\].g_col\[0\].pe__2484_/A VGND VGND VPWR
+ VPWR g_row\[1\].g_col\[0\].pe__2484_/Y sky130_fd_sc_hd__inv_2
Xg_row\[1\].g_col\[0\].pe__1504_ g_row\[1\].g_col\[0\].pe__1504_/A g_row\[1\].g_col\[0\].pe__2341_/B
+ VGND VGND VPWR VPWR g_row\[1\].g_col\[0\].pe__1504_/Y sky130_fd_sc_hd__nor2_2
Xg_row\[0\].g_col\[0\].pe__2700_ clkbuf_leaf_20_clk/X g_row\[0\].g_col\[0\].pe__2700_/D
+ VGND VGND VPWR VPWR place1201/A sky130_fd_sc_hd__dfxtp_2
Xg_row\[1\].g_col\[1\].pe__1451_ g_row\[1\].g_col\[1\].pe__2612_/B g_row\[1\].g_col\[1\].pe__1748_/B
+ g_row\[1\].g_col\[1\].pe__1738_/B1 g_row\[1\].g_col\[1\].pe__2694_/Q VGND VGND VPWR
+ VPWR g_row\[1\].g_col\[1\].pe__1452_/B sky130_fd_sc_hd__a22o_2
Xg_row\[0\].g_col\[0\].pe__2631_ g_row\[0\].g_col\[0\].pe__2640_/A1 g_row\[0\].g_col\[0\].pe__2631_/A2
+ g_row\[0\].g_col\[0\].pe__2640_/C1 g_row\[0\].g_col\[0\].pe__2630_/X VGND VGND VPWR
+ VPWR g_row\[0\].g_col\[0\].pe__2631_/X sky130_fd_sc_hd__o211a_2
XFILLER_36_622 VGND VGND VPWR VPWR sky130_fd_sc_hd__decap_3
Xg_row\[1\].g_col\[0\].pe__1366_ g_row\[1\].g_col\[0\].pe__2478_/A g_row\[1\].g_col\[0\].pe__1366_/B
+ VGND VGND VPWR VPWR output1393/A sky130_fd_sc_hd__xnor2_2
XFILLER_35_132 VGND VGND VPWR VPWR sky130_fd_sc_hd__fill_2
XFILLER_91_783 VGND VGND VPWR VPWR sky130_fd_sc_hd__fill_1
XFILLER_35_187 VGND VGND VPWR VPWR sky130_fd_sc_hd__decap_3
XFILLER_35_198 VGND VGND VPWR VPWR sky130_fd_sc_hd__decap_3
XFILLER_36_699 VGND VGND VPWR VPWR sky130_fd_sc_hd__fill_1
XFILLER_51_636 VGND VGND VPWR VPWR sky130_fd_sc_hd__decap_3
Xg_row\[0\].g_col\[0\].pe__1513_ g_row\[0\].g_col\[0\].pe__1500_/A g_row\[0\].g_col\[0\].pe__1500_/B
+ g_row\[0\].g_col\[0\].pe__1512_/Y VGND VGND VPWR VPWR g_row\[0\].g_col\[0\].pe__1588_/A
+ sky130_fd_sc_hd__a21oi_2
Xg_row\[0\].g_col\[0\].pe__2493_ g_row\[0\].g_col\[0\].pe__2422_/A g_row\[0\].g_col\[0\].pe__2484_/Y
+ g_row\[0\].g_col\[0\].pe__1348_/A g_row\[0\].g_col\[0\].pe__2754_/Q VGND VGND VPWR
+ VPWR g_row\[0\].g_col\[0\].pe__2503_/B sky130_fd_sc_hd__a211oi_2
Xg_row\[0\].g_col\[0\].pe__1444_ g_row\[0\].g_col\[0\].pe__2729_/Q g_row\[0\].g_col\[0\].pe__2094_/A
+ VGND VGND VPWR VPWR g_row\[0\].g_col\[0\].pe__2079_/B sky130_fd_sc_hd__xor2_2
Xg_row\[0\].g_col\[1\].pe__1460_ g_row\[0\].g_col\[1\].pe__2731_/Q g_row\[0\].g_col\[1\].pe__2730_/Q
+ g_row\[0\].g_col\[1\].pe__2732_/Q VGND VGND VPWR VPWR g_row\[0\].g_col\[1\].pe__1461_/B
+ sky130_fd_sc_hd__or3b_4
Xg_row\[1\].g_col\[1\].pe__2003_ g_row\[1\].g_col\[1\].pe__2013_/A g_row\[1\].g_col\[1\].pe__2013_/B
+ VGND VGND VPWR VPWR g_row\[1\].g_col\[1\].pe__2005_/B sky130_fd_sc_hd__xor2_2
XTAP_TAPCELL_ROW_21_528 VGND VPWR sky130_fd_sc_hd__tapvpwrvgnd_1
Xg_row\[0\].g_col\[1\].pe__1391_ g_row\[0\].g_col\[1\].pe__1391_/A1 g_row\[0\].g_col\[1\].pe__1372_/X
+ g_row\[0\].g_col\[1\].pe__1391_/B1 g_row\[0\].g_col\[1\].pe__2656_/B1 VGND VGND
+ VPWR VPWR g_row\[0\].g_col\[1\].pe__1391_/X sky130_fd_sc_hd__o211a_2
XFILLER_31_393 VGND VGND VPWR VPWR sky130_fd_sc_hd__fill_1
Xg_row\[0\].g_col\[1\].pe__2012_ g_row\[0\].g_col\[1\].pe__1951_/A g_row\[0\].g_col\[1\].pe__1951_/B
+ g_row\[0\].g_col\[1\].pe__2009_/B g_row\[0\].g_col\[1\].pe__2006_/A VGND VGND VPWR
+ VPWR g_row\[0\].g_col\[1\].pe__2062_/C sky130_fd_sc_hd__a31o_2
Xg_row\[1\].g_col\[1\].pe__2767_ _308_/CLK g_row\[1\].g_col\[1\].pe__2767_/D VGND
+ VGND VPWR VPWR g_row\[1\].g_col\[1\].pe__2767_/Q sky130_fd_sc_hd__dfxtp_2
XFILLER_76_29 VGND VGND VPWR VPWR sky130_fd_sc_hd__fill_2
XFILLER_86_533 VGND VGND VPWR VPWR sky130_fd_sc_hd__decap_3
Xg_row\[1\].g_col\[1\].pe__2698_ clkload17/A g_row\[1\].g_col\[1\].pe__2698_/D VGND
+ VGND VPWR VPWR g_row\[1\].g_col\[1\].pe__2698_/Q sky130_fd_sc_hd__dfxtp_2
Xg_row\[1\].g_col\[1\].pe__1718_ g_row\[1\].g_col\[1\].pe__1724_/S g_row\[1\].g_col\[1\].pe__1718_/B
+ VGND VGND VPWR VPWR g_row\[1\].g_col\[1\].pe__1743_/B sky130_fd_sc_hd__xnor2_2
XFILLER_58_246 VGND VGND VPWR VPWR sky130_fd_sc_hd__fill_1
XFILLER_59_769 VGND VGND VPWR VPWR sky130_fd_sc_hd__decap_3
XFILLER_86_544 VGND VGND VPWR VPWR sky130_fd_sc_hd__fill_1
Xg_row\[1\].g_col\[1\].pe__1649_ g_row\[1\].g_col\[1\].pe__1688_/A g_row\[1\].g_col\[1\].pe__1688_/B
+ g_row\[1\].g_col\[1\].pe__1648_/X VGND VGND VPWR VPWR g_row\[1\].g_col\[1\].pe__1660_/A
+ sky130_fd_sc_hd__a21oi_2
Xg_row\[1\].g_col\[0\].pe_hold3081 g_row\[1\].g_col\[0\].pe__2725_/Q VGND VGND VPWR
+ VPWR g_row\[1\].g_col\[0\].pe__2684_/A sky130_fd_sc_hd__clkbuf_2
Xg_row\[1\].g_col\[0\].pe_hold3070 g_row\[1\].g_col\[0\].pe__2730_/Q VGND VGND VPWR
+ VPWR g_row\[1\].g_col\[0\].pe_hold3070/X sky130_fd_sc_hd__clkbuf_2
XFILLER_27_633 VGND VGND VPWR VPWR sky130_fd_sc_hd__decap_3
XTAP_TAPCELL_ROW_1_220 VGND VPWR sky130_fd_sc_hd__tapvpwrvgnd_1
XTAP_TAPCELL_ROW_1_231 VGND VPWR sky130_fd_sc_hd__tapvpwrvgnd_1
XTAP_TAPCELL_ROW_29_639 VGND VPWR sky130_fd_sc_hd__tapvpwrvgnd_1
XTAP_TAPCELL_ROW_68_1231 VGND VPWR sky130_fd_sc_hd__tapvpwrvgnd_1
Xg_row\[1\].g_col\[0\].pe_hold1690 g_row\[1\].g_col\[0\].pe__2266_/Y VGND VGND VPWR
+ VPWR g_row\[1\].g_col\[0\].pe__2267_/B1 sky130_fd_sc_hd__clkbuf_2
XFILLER_27_688 VGND VGND VPWR VPWR sky130_fd_sc_hd__decap_3
Xg_row\[0\].g_col\[1\].pe__2776_ ANTENNA_146/DIODE VGND VGND VPWR VPWR output1379/A
+ sky130_fd_sc_hd__buf_2
XFILLER_14_305 VGND VGND VPWR VPWR sky130_fd_sc_hd__decap_3
XFILLER_42_636 VGND VGND VPWR VPWR sky130_fd_sc_hd__fill_2
Xg_row\[0\].g_col\[1\].pe__1727_ g_row\[0\].g_col\[1\].pe__1804_/A g_row\[0\].g_col\[1\].pe__1727_/A2
+ g_row\[0\].g_col\[1\].pe__1749_/A2 g_row\[0\].g_col\[1\].pe__1727_/B2 VGND VGND
+ VPWR VPWR g_row\[0\].g_col\[1\].pe__1728_/B sky130_fd_sc_hd__a22o_2
XFILLER_14_349 VGND VGND VPWR VPWR sky130_fd_sc_hd__decap_3
XFILLER_25_66 VGND VGND VPWR VPWR sky130_fd_sc_hd__fill_2
XTAP_TAPCELL_ROW_81_1420 VGND VPWR sky130_fd_sc_hd__tapvpwrvgnd_1
XTAP_TAPCELL_ROW_81_1431 VGND VPWR sky130_fd_sc_hd__tapvpwrvgnd_1
Xg_row\[0\].g_col\[1\].pe__1658_ g_row\[0\].g_col\[1\].pe__1676_/A g_row\[0\].g_col\[1\].pe__1658_/B
+ VGND VGND VPWR VPWR g_row\[0\].g_col\[1\].pe__1664_/A sky130_fd_sc_hd__xnor2_2
XTAP_TAPCELL_ROW_40_804 VGND VPWR sky130_fd_sc_hd__tapvpwrvgnd_1
XTAP_TAPCELL_ROW_40_815 VGND VPWR sky130_fd_sc_hd__tapvpwrvgnd_1
X_191_ _205_/A _191_/B_N VGND VGND VPWR VPWR _191_/Y sky130_fd_sc_hd__nor2b_4
Xg_row\[0\].g_col\[1\].pe__1589_ g_row\[0\].g_col\[1\].pe__1547_/A g_row\[0\].g_col\[1\].pe__1547_/B
+ g_row\[0\].g_col\[1\].pe__1588_/Y VGND VGND VPWR VPWR g_row\[0\].g_col\[1\].pe__1594_/B
+ sky130_fd_sc_hd__a21o_2
XTAP_TAPCELL_ROW_79_1393 VGND VPWR sky130_fd_sc_hd__tapvpwrvgnd_1
XFILLER_2_710 VGND VGND VPWR VPWR sky130_fd_sc_hd__fill_1
XFILLER_2_732 VGND VGND VPWR VPWR sky130_fd_sc_hd__decap_3
XTAP_TAPCELL_ROW_9_342 VGND VPWR sky130_fd_sc_hd__tapvpwrvgnd_1
XFILLER_1_286 VGND VGND VPWR VPWR sky130_fd_sc_hd__fill_1
XFILLER_89_382 VGND VGND VPWR VPWR sky130_fd_sc_hd__decap_3
XTAP_TAPCELL_ROW_92_1593 VGND VPWR sky130_fd_sc_hd__tapvpwrvgnd_1
XFILLER_89_393 VGND VGND VPWR VPWR sky130_fd_sc_hd__fill_1
XFILLER_92_503 VGND VGND VPWR VPWR sky130_fd_sc_hd__fill_2
XTAP_TAPCELL_ROW_48_926 VGND VPWR sky130_fd_sc_hd__tapvpwrvgnd_1
XFILLER_64_249 VGND VGND VPWR VPWR sky130_fd_sc_hd__decap_3
XTAP_TAPCELL_ROW_48_937 VGND VPWR sky130_fd_sc_hd__tapvpwrvgnd_1
XFILLER_33_603 VGND VGND VPWR VPWR sky130_fd_sc_hd__decap_3
XFILLER_92_569 VGND VGND VPWR VPWR sky130_fd_sc_hd__fill_2
Xg_row\[0\].g_col\[0\].pe_hold3113 g_row\[0\].g_col\[0\].pe__2742_/Q VGND VGND VPWR
+ VPWR g_row\[0\].g_col\[0\].pe_hold3113/X sky130_fd_sc_hd__clkbuf_2
Xg_row\[0\].g_col\[0\].pe_hold1700 g_row\[0\].g_col\[0\].pe__2158_/X VGND VGND VPWR
+ VPWR g_row\[0\].g_col\[0\].pe__2159_/B sky130_fd_sc_hd__clkbuf_2
Xg_row\[0\].g_col\[0\].pe_hold1722 ANTENNA_142/DIODE VGND VGND VPWR VPWR g_row\[0\].g_col\[0\].pe__2236_/B1
+ sky130_fd_sc_hd__clkbuf_2
XFILLER_13_393 VGND VGND VPWR VPWR sky130_fd_sc_hd__fill_1
Xg_row\[0\].g_col\[0\].pe_hold1755 g_row\[0\].g_col\[0\].pe__2114_/X VGND VGND VPWR
+ VPWR g_row\[0\].g_col\[0\].pe__2115_/B sky130_fd_sc_hd__clkbuf_2
Xg_row\[0\].g_col\[0\].pe_hold1799 g_row\[0\].g_col\[0\].pe_hold2008/X VGND VGND VPWR
+ VPWR g_row\[0\].g_col\[0\].pe__2672_/A sky130_fd_sc_hd__clkbuf_2
Xg_row\[1\].g_col\[0\].pe__1984_ g_row\[1\].g_col\[0\].pe__1424_/A g_row\[1\].g_col\[0\].pe__1424_/B
+ g_row\[1\].g_col\[0\].pe__1983_/Y VGND VGND VPWR VPWR g_row\[1\].g_col\[0\].pe__1985_/C
+ sky130_fd_sc_hd__a21o_2
XFILLER_56_3 VGND VGND VPWR VPWR sky130_fd_sc_hd__decap_3
Xg_row\[1\].g_col\[1\].pe__2621_ g_row\[1\].g_col\[1\].pe__2639_/A g_row\[1\].g_col\[1\].pe__2621_/B
+ VGND VGND VPWR VPWR g_row\[1\].g_col\[1\].pe__2621_/X sky130_fd_sc_hd__or2_2
Xg_row\[1\].g_col\[0\].pe__2605_ g_row\[1\].g_col\[0\].pe__2639_/A g_row\[1\].g_col\[0\].pe__2605_/B
+ VGND VGND VPWR VPWR g_row\[1\].g_col\[0\].pe__2605_/X sky130_fd_sc_hd__or2_2
Xg_row\[1\].g_col\[1\].pe__2552_ g_row\[1\].g_col\[1\].pe__2551_/B g_row\[1\].g_col\[1\].pe__2551_/C
+ g_row\[1\].g_col\[1\].pe__2551_/A VGND VGND VPWR VPWR g_row\[1\].g_col\[1\].pe__2552_/X
+ sky130_fd_sc_hd__a21o_2
XFILLER_68_533 VGND VGND VPWR VPWR sky130_fd_sc_hd__fill_1
Xg_row\[0\].g_col\[0\].pe__1993_ g_row\[0\].g_col\[0\].pe__1991_/X g_row\[0\].g_col\[0\].pe__1993_/B
+ VGND VGND VPWR VPWR g_row\[0\].g_col\[0\].pe__2055_/A sky130_fd_sc_hd__nand2b_4
Xg_row\[1\].g_col\[1\].pe__1503_ g_row\[1\].g_col\[1\].pe__2735_/Q g_row\[1\].g_col\[1\].pe__1540_/C
+ VGND VGND VPWR VPWR g_row\[1\].g_col\[1\].pe__2341_/B sky130_fd_sc_hd__nor2_2
Xg_row\[1\].g_col\[0\].pe__2536_ g_row\[1\].g_col\[0\].pe__2561_/A g_row\[1\].g_col\[0\].pe__2536_/B
+ VGND VGND VPWR VPWR g_row\[1\].g_col\[0\].pe__2759_/D sky130_fd_sc_hd__and2_2
XFILLER_68_577 VGND VGND VPWR VPWR sky130_fd_sc_hd__decap_3
Xg_row\[1\].g_col\[1\].pe__2483_ g_row\[1\].g_col\[1\].pe__2508_/A g_row\[1\].g_col\[1\].pe__2508_/B
+ g_row\[1\].g_col\[1\].pe__2425_/A VGND VGND VPWR VPWR g_row\[1\].g_col\[1\].pe__2509_/S
+ sky130_fd_sc_hd__a21oi_2
Xg_row\[1\].g_col\[0\].pe__2467_ g_row\[1\].g_col\[0\].pe__2446_/B g_row\[1\].g_col\[0\].pe__2761_/Q
+ VGND VGND VPWR VPWR g_row\[1\].g_col\[0\].pe__2497_/A sky130_fd_sc_hd__and2b_2
XFILLER_83_558 VGND VGND VPWR VPWR sky130_fd_sc_hd__fill_2
Xg_row\[1\].g_col\[0\].pe__2398_ g_row\[1\].g_col\[0\].pe__2398_/A hold1766/X VGND
+ VGND VPWR VPWR g_row\[1\].g_col\[0\].pe__2398_/X sky130_fd_sc_hd__and2_2
Xg_row\[1\].g_col\[0\].pe__1418_ place1092/X g_row\[1\].g_col\[0\].pe__1729_/A2 g_row\[1\].g_col\[0\].pe__1729_/A3
+ g_row\[1\].g_col\[0\].pe__1801_/B place1089/X VGND VGND VPWR VPWR g_row\[1\].g_col\[0\].pe__1419_/B
+ sky130_fd_sc_hd__a32o_2
Xg_row\[0\].g_col\[1\].pe__2630_ place1248/X g_row\[0\].g_col\[1\].pe__2630_/B VGND
+ VGND VPWR VPWR g_row\[0\].g_col\[1\].pe__2630_/X sky130_fd_sc_hd__or2_2
XFILLER_64_761 VGND VGND VPWR VPWR sky130_fd_sc_hd__fill_1
Xg_row\[0\].g_col\[0\].pe__2614_ g_row\[0\].g_col\[0\].pe__2623_/A place1210/A VGND
+ VGND VPWR VPWR g_row\[0\].g_col\[0\].pe__2614_/X sky130_fd_sc_hd__or2_2
Xg_row\[1\].g_col\[1\].pe__1365_ g_row\[1\].g_col\[1\].pe__2767_/Q g_row\[1\].g_col\[1\].pe__2766_/Q
+ g_row\[1\].g_col\[1\].pe__1361_/B g_row\[1\].g_col\[1\].pe__2776_/A VGND VGND VPWR
+ VPWR g_row\[1\].g_col\[1\].pe__1366_/B sky130_fd_sc_hd__o31a_2
Xg_row\[1\].g_col\[0\].pe__1349_ g_row\[1\].g_col\[0\].pe__2760_/Q g_row\[1\].g_col\[0\].pe__1349_/B
+ VGND VGND VPWR VPWR output1384/A sky130_fd_sc_hd__xnor2_2
XFILLER_24_636 VGND VGND VPWR VPWR sky130_fd_sc_hd__fill_1
Xg_row\[0\].g_col\[0\].pe__2545_ g_row\[0\].g_col\[0\].pe__2546_/A g_row\[0\].g_col\[0\].pe__2546_/B
+ VGND VGND VPWR VPWR g_row\[0\].g_col\[0\].pe__2547_/B sky130_fd_sc_hd__nor2_2
Xg_row\[0\].g_col\[1\].pe__2561_ g_row\[0\].g_col\[1\].pe__2592_/A g_row\[0\].g_col\[1\].pe__2561_/B
+ VGND VGND VPWR VPWR g_row\[0\].g_col\[1\].pe__2763_/D sky130_fd_sc_hd__and2_4
XFILLER_24_658 VGND VGND VPWR VPWR sky130_fd_sc_hd__decap_3
XFILLER_63_293 VGND VGND VPWR VPWR sky130_fd_sc_hd__decap_3
Xg_row\[0\].g_col\[1\].pe__1512_ g_row\[0\].g_col\[1\].pe__1512_/A g_row\[0\].g_col\[1\].pe__1512_/B
+ VGND VGND VPWR VPWR g_row\[0\].g_col\[1\].pe__1512_/Y sky130_fd_sc_hd__nor2_2
Xg_row\[0\].g_col\[1\].pe__2492_ g_row\[0\].g_col\[1\].pe__2492_/A g_row\[0\].g_col\[1\].pe__2492_/B
+ VGND VGND VPWR VPWR g_row\[0\].g_col\[1\].pe__2567_/A sky130_fd_sc_hd__and2_2
XTAP_TAPCELL_ROW_63_1150 VGND VPWR sky130_fd_sc_hd__tapvpwrvgnd_1
XTAP_TAPCELL_ROW_63_1161 VGND VPWR sky130_fd_sc_hd__tapvpwrvgnd_1
Xg_row\[0\].g_col\[0\].pe__2476_ g_row\[0\].g_col\[0\].pe__2767_/Q g_row\[0\].g_col\[0\].pe__2476_/B
+ VGND VGND VPWR VPWR g_row\[0\].g_col\[0\].pe__2487_/A sky130_fd_sc_hd__xnor2_2
Xg_row\[0\].g_col\[1\].pe__1443_ g_row\[0\].g_col\[1\].pe__1479_/A g_row\[0\].g_col\[1\].pe__1479_/B
+ VGND VGND VPWR VPWR g_row\[0\].g_col\[1\].pe__1662_/A sky130_fd_sc_hd__xor2_2
Xg_row\[0\].g_col\[0\].pe__1427_ g_row\[0\].g_col\[0\].pe__1789_/A g_row\[0\].g_col\[0\].pe__1427_/B
+ VGND VGND VPWR VPWR g_row\[0\].g_col\[0\].pe__1650_/B sky130_fd_sc_hd__xor2_2
Xg_row\[0\].g_col\[0\].pe__1358_ g_row\[0\].g_col\[0\].pe__2764_/Q g_row\[0\].g_col\[0\].pe__1357_/B
+ g_row\[0\].g_col\[0\].pe__2776_/A VGND VGND VPWR VPWR g_row\[0\].g_col\[0\].pe__1359_/B
+ sky130_fd_sc_hd__o21a_2
Xg_row\[0\].g_col\[1\].pe__1374_ g_row\[0\].g_col\[1\].pe__2663_/A _276_/Q VGND VGND
+ VPWR VPWR g_row\[0\].g_col\[1\].pe__1389_/B sky130_fd_sc_hd__nand2_2
XFILLER_87_39 VGND VGND VPWR VPWR sky130_fd_sc_hd__fill_1
XTAP_TAPCELL_ROW_6_301 VGND VPWR sky130_fd_sc_hd__tapvpwrvgnd_1
XFILLER_59_577 VGND VGND VPWR VPWR sky130_fd_sc_hd__decap_3
XFILLER_15_636 VGND VGND VPWR VPWR sky130_fd_sc_hd__decap_3
XFILLER_27_474 VGND VGND VPWR VPWR sky130_fd_sc_hd__decap_3
XFILLER_54_271 VGND VGND VPWR VPWR sky130_fd_sc_hd__fill_2
Xg_row\[0\].g_col\[1\].pe_hold1852 g_row\[0\].g_col\[1\].pe__2761_/Q VGND VGND VPWR
+ VPWR g_row\[0\].g_col\[1\].pe__2548_/A1 sky130_fd_sc_hd__clkbuf_2
Xg_row\[0\].g_col\[1\].pe__2759_ _279_/CLK g_row\[0\].g_col\[1\].pe__2759_/D VGND
+ VGND VPWR VPWR g_row\[0\].g_col\[1\].pe__2759_/Q sky130_fd_sc_hd__dfxtp_2
XFILLER_42_477 VGND VGND VPWR VPWR sky130_fd_sc_hd__decap_3
X_312_ _318_/CLK _312_/D VGND VGND VPWR VPWR _312_/Q sky130_fd_sc_hd__dfxtp_2
XFILLER_11_820 VGND VGND VPWR VPWR sky130_fd_sc_hd__fill_2
X_243_ _269_/A _243_/B_N VGND VGND VPWR VPWR _243_/Y sky130_fd_sc_hd__nor2b_4
XFILLER_77_61 VGND VGND VPWR VPWR sky130_fd_sc_hd__decap_3
XFILLER_77_72 VGND VGND VPWR VPWR sky130_fd_sc_hd__fill_1
Xg_row\[1\].g_col\[0\].pe__2321_ g_row\[1\].g_col\[0\].pe__2321_/A g_row\[1\].g_col\[0\].pe__2348_/B
+ VGND VGND VPWR VPWR g_row\[1\].g_col\[0\].pe__2337_/C sky130_fd_sc_hd__and2_2
Xg_row\[1\].g_col\[0\].pe__2252_ g_row\[1\].g_col\[0\].pe__2273_/A g_row\[1\].g_col\[0\].pe__2273_/B
+ VGND VGND VPWR VPWR g_row\[1\].g_col\[0\].pe__2271_/A sky130_fd_sc_hd__xnor2_2
XFILLER_52_219 VGND VGND VPWR VPWR sky130_fd_sc_hd__decap_3
XFILLER_93_93 VGND VGND VPWR VPWR sky130_fd_sc_hd__fill_1
Xg_row\[1\].g_col\[0\].pe__2183_ g_row\[1\].g_col\[0\].pe__2183_/A g_row\[1\].g_col\[0\].pe__2183_/B
+ VGND VGND VPWR VPWR g_row\[1\].g_col\[0\].pe__2203_/B sky130_fd_sc_hd__xor2_2
XFILLER_33_422 VGND VGND VPWR VPWR sky130_fd_sc_hd__decap_3
XFILLER_61_764 VGND VGND VPWR VPWR sky130_fd_sc_hd__fill_2
XFILLER_73_591 VGND VGND VPWR VPWR sky130_fd_sc_hd__decap_3
XFILLER_33_466 VGND VGND VPWR VPWR sky130_fd_sc_hd__decap_3
Xg_row\[0\].g_col\[0\].pe__2330_ g_row\[0\].g_col\[0\].pe__2330_/A g_row\[0\].g_col\[0\].pe__2330_/B
+ g_row\[0\].g_col\[0\].pe__2330_/C VGND VGND VPWR VPWR g_row\[0\].g_col\[0\].pe__2330_/X
+ sky130_fd_sc_hd__or3_2
Xg_row\[0\].g_col\[0\].pe__2261_ g_row\[0\].g_col\[0\].pe__2262_/A g_row\[0\].g_col\[0\].pe__2262_/B
+ VGND VGND VPWR VPWR g_row\[0\].g_col\[0\].pe__2261_/Y sky130_fd_sc_hd__nor2_2
Xg_row\[0\].g_col\[0\].pe_hold2275 g_row\[0\].g_col\[0\].pe_hold3034/X VGND VGND VPWR
+ VPWR g_row\[0\].g_col\[0\].pe__2710_/D sky130_fd_sc_hd__clkbuf_2
Xg_row\[0\].g_col\[0\].pe_hold2286 g_row\[0\].g_col\[0\].pe_hold3080/X VGND VGND VPWR
+ VPWR g_row\[0\].g_col\[0\].pe__1386_/A1 sky130_fd_sc_hd__clkbuf_2
XTAP_TAPCELL_ROW_31_678 VGND VPWR sky130_fd_sc_hd__tapvpwrvgnd_1
Xg_row\[0\].g_col\[0\].pe__2192_ g_row\[0\].g_col\[0\].pe__2192_/A g_row\[0\].g_col\[0\].pe__2192_/B
+ VGND VGND VPWR VPWR g_row\[0\].g_col\[0\].pe__2192_/Y sky130_fd_sc_hd__nor2_2
Xg_row\[0\].g_col\[0\].pe_hold2297 g_row\[0\].g_col\[0\].pe_hold3067/X VGND VGND VPWR
+ VPWR g_row\[0\].g_col\[0\].pe__2698_/D sky130_fd_sc_hd__clkbuf_2
Xg_row\[0\].g_col\[1\].pe_place856 g_row\[0\].g_col\[1\].pe__1504_/Y VGND VGND VPWR
+ VPWR g_row\[0\].g_col\[1\].pe__2313_/A2 sky130_fd_sc_hd__buf_6
XTAP_TAPCELL_ROW_11_380 VGND VPWR sky130_fd_sc_hd__tapvpwrvgnd_1
Xg_row\[1\].g_col\[1\].pe__1983_ g_row\[1\].g_col\[1\].pe__2703_/Q VGND VGND VPWR
+ VPWR g_row\[1\].g_col\[1\].pe__1983_/Y sky130_fd_sc_hd__inv_2
Xg_row\[1\].g_col\[0\].pe__1967_ g_row\[1\].g_col\[0\].pe__1449_/A g_row\[1\].g_col\[0\].pe__1449_/B
+ g_row\[1\].g_col\[0\].pe__1966_/Y VGND VGND VPWR VPWR g_row\[1\].g_col\[0\].pe__1968_/C
+ sky130_fd_sc_hd__a21o_2
Xhold3405 hold3405/A VGND VGND VPWR VPWR hold3405/X sky130_fd_sc_hd__clkbuf_2
Xhold3416 hold3416/A VGND VGND VPWR VPWR hold3416/X sky130_fd_sc_hd__clkbuf_2
Xg_row\[1\].g_col\[0\].pe__1898_ g_row\[1\].g_col\[0\].pe__1604_/A g_row\[1\].g_col\[0\].pe__1604_/B
+ g_row\[1\].g_col\[0\].pe__1860_/B g_row\[1\].g_col\[0\].pe__1859_/B g_row\[1\].g_col\[0\].pe__1859_/A
+ VGND VGND VPWR VPWR g_row\[1\].g_col\[0\].pe__1939_/A sky130_fd_sc_hd__a32o_2
XFILLER_88_639 VGND VGND VPWR VPWR sky130_fd_sc_hd__decap_3
Xhold2704 hold3491/X VGND VGND VPWR VPWR hold3492/A sky130_fd_sc_hd__clkbuf_2
Xoutput1377 output1377/A VGND VGND VPWR VPWR results_flat[2] sky130_fd_sc_hd__buf_2
Xoutput1366 output1366/A VGND VGND VPWR VPWR results_flat[1] sky130_fd_sc_hd__buf_2
Xoutput1355 output1355/A VGND VGND VPWR VPWR results_flat[0] sky130_fd_sc_hd__buf_2
Xhold3449 hold3449/A VGND VGND VPWR VPWR hold3449/X sky130_fd_sc_hd__clkbuf_2
Xhold3438 a_inputs_flat[18] VGND VGND VPWR VPWR hold3438/X sky130_fd_sc_hd__clkbuf_2
Xhold3427 hold3427/A VGND VGND VPWR VPWR hold3427/X sky130_fd_sc_hd__clkbuf_2
Xg_row\[1\].g_col\[1\].pe__2604_ g_row\[1\].g_col\[1\].pe__2633_/A1 place1104/X g_row\[1\].g_col\[1\].pe__2679_/C1
+ g_row\[1\].g_col\[1\].pe__2604_/C1 VGND VGND VPWR VPWR g_row\[1\].g_col\[1\].pe__2604_/X
+ sky130_fd_sc_hd__o211a_2
Xhold2715 hold3468/X VGND VGND VPWR VPWR hold3469/A sky130_fd_sc_hd__clkbuf_2
Xhold2726 hold3529/X VGND VGND VPWR VPWR hold3530/A sky130_fd_sc_hd__clkbuf_2
Xhold2737 hold2737/A VGND VGND VPWR VPWR _314_/D sky130_fd_sc_hd__clkbuf_2
Xoutput1399 output1399/A VGND VGND VPWR VPWR results_flat[4] sky130_fd_sc_hd__buf_2
Xoutput1388 output1388/A VGND VGND VPWR VPWR results_flat[3] sky130_fd_sc_hd__buf_2
XFILLER_56_514 VGND VGND VPWR VPWR sky130_fd_sc_hd__decap_3
Xg_row\[0\].g_col\[0\].pe__1976_ g_row\[0\].g_col\[0\].pe__2215_/B2 g_row\[0\].g_col\[0\].pe__1471_/X
+ g_row\[0\].g_col\[0\].pe__1474_/Y place1208/A VGND VGND VPWR VPWR g_row\[0\].g_col\[0\].pe__1977_/B
+ sky130_fd_sc_hd__a22o_2
Xhold2748 _197_/Y VGND VGND VPWR VPWR hold2748/X sky130_fd_sc_hd__clkbuf_2
Xhold2759 hold2759/A VGND VGND VPWR VPWR _195_/B_N sky130_fd_sc_hd__clkbuf_2
Xg_row\[1\].g_col\[1\].pe__2535_ g_row\[1\].g_col\[1\].pe__2535_/A1 g_row\[1\].g_col\[1\].pe__2568_/A2
+ g_row\[1\].g_col\[1\].pe__2568_/B1 g_row\[1\].g_col\[1\].pe__2534_/X VGND VGND VPWR
+ VPWR g_row\[1\].g_col\[1\].pe__2535_/X sky130_fd_sc_hd__a22o_2
Xg_row\[1\].g_col\[0\].pe__2519_ g_row\[1\].g_col\[0\].pe__2519_/A g_row\[1\].g_col\[0\].pe__2519_/B
+ VGND VGND VPWR VPWR g_row\[1\].g_col\[0\].pe__2519_/Y sky130_fd_sc_hd__nand2_2
Xg_row\[0\].g_col\[1\].pe__1992_ g_row\[0\].g_col\[1\].pe__1991_/A g_row\[0\].g_col\[1\].pe__1991_/B
+ g_row\[0\].g_col\[1\].pe__1991_/C g_row\[0\].g_col\[1\].pe__1991_/D VGND VGND VPWR
+ VPWR g_row\[0\].g_col\[1\].pe__1993_/B sky130_fd_sc_hd__a22o_2
XFILLER_56_536 VGND VGND VPWR VPWR sky130_fd_sc_hd__fill_1
Xg_row\[1\].g_col\[1\].pe__2466_ g_row\[1\].g_col\[1\].pe__2452_/B g_row\[1\].g_col\[1\].pe__2760_/Q
+ VGND VGND VPWR VPWR g_row\[1\].g_col\[1\].pe__2466_/X sky130_fd_sc_hd__and2b_2
XFILLER_56_569 VGND VGND VPWR VPWR sky130_fd_sc_hd__fill_2
XTAP_TAPCELL_ROW_39_789 VGND VPWR sky130_fd_sc_hd__tapvpwrvgnd_1
Xg_row\[1\].g_col\[1\].pe__2397_ g_row\[1\].g_col\[1\].pe__2722_/Q g_row\[1\].g_col\[1\].pe__2639_/B
+ VGND VGND VPWR VPWR g_row\[1\].g_col\[1\].pe__2397_/Y sky130_fd_sc_hd__nor2_2
Xg_row\[0\].g_col\[1\].pe__2613_ g_row\[0\].g_col\[1\].pe__2624_/A1 place1212/X g_row\[0\].g_col\[1\].pe__2626_/B1
+ g_row\[0\].g_col\[1\].pe__2613_/C1 VGND VGND VPWR VPWR g_row\[0\].g_col\[1\].pe__2613_/X
+ sky130_fd_sc_hd__o211a_2
XTAP_TAPCELL_ROW_19_491 VGND VPWR sky130_fd_sc_hd__tapvpwrvgnd_1
Xg_row\[1\].g_col\[1\].pe__1348_ g_row\[1\].g_col\[1\].pe__1348_/A g_row\[1\].g_col\[1\].pe__1348_/B
+ VGND VGND VPWR VPWR g_row\[1\].g_col\[1\].pe__1349_/B sky130_fd_sc_hd__nand2_2
Xg_row\[0\].g_col\[1\].pe__2544_ g_row\[0\].g_col\[1\].pe__2466_/X g_row\[0\].g_col\[1\].pe__2544_/B
+ VGND VGND VPWR VPWR g_row\[0\].g_col\[1\].pe__2546_/A sky130_fd_sc_hd__and2b_2
XFILLER_24_477 VGND VGND VPWR VPWR sky130_fd_sc_hd__decap_3
Xg_row\[0\].g_col\[0\].pe__2528_ g_row\[0\].g_col\[0\].pe__2528_/A1 g_row\[0\].g_col\[0\].pe__2554_/A2
+ g_row\[0\].g_col\[0\].pe__2517_/Y g_row\[0\].g_col\[0\].pe__2527_/X VGND VGND VPWR
+ VPWR g_row\[0\].g_col\[0\].pe__2528_/X sky130_fd_sc_hd__a22o_2
XFILLER_12_639 VGND VGND VPWR VPWR sky130_fd_sc_hd__decap_3
Xg_row\[0\].g_col\[0\].pe__2459_ g_row\[0\].g_col\[0\].pe__2754_/Q g_row\[0\].g_col\[0\].pe__2739_/Q
+ VGND VGND VPWR VPWR g_row\[0\].g_col\[0\].pe__2460_/B sky130_fd_sc_hd__and2b_2
Xg_row\[0\].g_col\[1\].pe__2475_ g_row\[0\].g_col\[1\].pe__2489_/B g_row\[0\].g_col\[1\].pe__2492_/A
+ g_row\[0\].g_col\[1\].pe__2474_/Y VGND VGND VPWR VPWR g_row\[0\].g_col\[1\].pe__2490_/A
+ sky130_fd_sc_hd__a21boi_2
XFILLER_20_650 VGND VGND VPWR VPWR sky130_fd_sc_hd__fill_1
XTAP_TAPCELL_ROW_50_954 VGND VPWR sky130_fd_sc_hd__tapvpwrvgnd_1
XTAP_TAPCELL_ROW_50_965 VGND VPWR sky130_fd_sc_hd__tapvpwrvgnd_1
Xg_row\[0\].g_col\[1\].pe__1426_ g_row\[0\].g_col\[1\].pe__1727_/A2 g_row\[0\].g_col\[1\].pe__1732_/A2
+ g_row\[0\].g_col\[1\].pe__1732_/B1 g_row\[0\].g_col\[1\].pe__1749_/A2 VGND VGND
+ VPWR VPWR g_row\[0\].g_col\[1\].pe__1427_/B sky130_fd_sc_hd__a22o_2
Xg_row\[0\].g_col\[1\].pe__1357_ g_row\[0\].g_col\[1\].pe__2764_/Q g_row\[0\].g_col\[1\].pe__1357_/B
+ VGND VGND VPWR VPWR output1371/A sky130_fd_sc_hd__xor2_2
XTAP_TAPCELL_ROW_76_1352 VGND VPWR sky130_fd_sc_hd__tapvpwrvgnd_1
XFILLER_78_105 VGND VGND VPWR VPWR sky130_fd_sc_hd__fill_1
XFILLER_79_617 VGND VGND VPWR VPWR sky130_fd_sc_hd__decap_3
XFILLER_59_341 VGND VGND VPWR VPWR sky130_fd_sc_hd__fill_1
XFILLER_74_355 VGND VGND VPWR VPWR sky130_fd_sc_hd__fill_1
Xg_row\[0\].g_col\[1\].pe_hold3073 g_row\[0\].g_col\[1\].pe__2733_/Q VGND VGND VPWR
+ VPWR g_row\[0\].g_col\[1\].pe_hold3073/X sky130_fd_sc_hd__clkbuf_2
Xg_row\[0\].g_col\[1\].pe_hold2372 g_row\[0\].g_col\[1\].pe__2749_/Q VGND VGND VPWR
+ VPWR g_row\[0\].g_col\[1\].pe__2269_/A sky130_fd_sc_hd__clkbuf_2
Xg_row\[0\].g_col\[1\].pe_hold2361 g_row\[0\].g_col\[1\].pe_hold3049/X VGND VGND VPWR
+ VPWR g_row\[0\].g_col\[1\].pe_hold3050/A sky130_fd_sc_hd__clkbuf_2
Xg_row\[0\].g_col\[1\].pe_hold2350 g_row\[0\].g_col\[1\].pe__2607_/X VGND VGND VPWR
+ VPWR g_row\[0\].g_col\[1\].pe__2608_/C1 sky130_fd_sc_hd__clkbuf_2
Xg_row\[0\].g_col\[1\].pe_hold2394 g_row\[0\].g_col\[1\].pe__2753_/Q VGND VGND VPWR
+ VPWR g_row\[0\].g_col\[1\].pe__2383_/A sky130_fd_sc_hd__clkbuf_2
Xg_row\[0\].g_col\[1\].pe_hold2383 g_row\[0\].g_col\[1\].pe__2755_/Q VGND VGND VPWR
+ VPWR g_row\[0\].g_col\[1\].pe_hold2383/X sky130_fd_sc_hd__clkbuf_2
XFILLER_42_263 VGND VGND VPWR VPWR sky130_fd_sc_hd__fill_1
XFILLER_43_764 VGND VGND VPWR VPWR sky130_fd_sc_hd__fill_2
XFILLER_70_572 VGND VGND VPWR VPWR sky130_fd_sc_hd__decap_3
XFILLER_30_425 VGND VGND VPWR VPWR sky130_fd_sc_hd__decap_3
XFILLER_30_447 VGND VGND VPWR VPWR sky130_fd_sc_hd__decap_3
XFILLER_7_643 VGND VGND VPWR VPWR sky130_fd_sc_hd__decap_3
X_157_ _199_/A _157_/B_N VGND VGND VPWR VPWR _157_/Y sky130_fd_sc_hd__nor2b_4
Xg_row\[1\].g_col\[0\].pe__1821_ g_row\[1\].g_col\[0\].pe__1822_/C g_row\[1\].g_col\[0\].pe__1821_/B
+ g_row\[1\].g_col\[0\].pe__1821_/C g_row\[1\].g_col\[0\].pe__1821_/D VGND VGND VPWR
+ VPWR g_row\[1\].g_col\[0\].pe__1821_/X sky130_fd_sc_hd__and4_2
XFILLER_6_197 VGND VGND VPWR VPWR sky130_fd_sc_hd__fill_1
Xg_row\[1\].g_col\[0\].pe__1752_ g_row\[1\].g_col\[0\].pe__1785_/A g_row\[1\].g_col\[0\].pe__1752_/B
+ VGND VGND VPWR VPWR g_row\[1\].g_col\[0\].pe__1756_/B sky130_fd_sc_hd__xor2_2
Xg_row\[1\].g_col\[0\].pe__1683_ g_row\[1\].g_col\[0\].pe__1686_/A g_row\[1\].g_col\[0\].pe__1686_/B
+ VGND VGND VPWR VPWR g_row\[1\].g_col\[0\].pe__1713_/A sky130_fd_sc_hd__xor2_2
Xg_row\[1\].g_col\[0\].pe_hold2913 _298_/Q VGND VGND VPWR VPWR g_row\[1\].g_col\[0\].pe_hold2913/X
+ sky130_fd_sc_hd__clkbuf_2
Xg_row\[1\].g_col\[0\].pe_hold2902 _295_/Q VGND VGND VPWR VPWR g_row\[1\].g_col\[0\].pe_hold2902/X
+ sky130_fd_sc_hd__clkbuf_2
Xg_row\[0\].g_col\[0\].pe__1830_ g_row\[0\].g_col\[0\].pe__1830_/A g_row\[0\].g_col\[0\].pe__1830_/B
+ g_row\[0\].g_col\[0\].pe__1830_/C VGND VGND VPWR VPWR g_row\[0\].g_col\[0\].pe__1832_/B
+ sky130_fd_sc_hd__or3_2
Xg_row\[1\].g_col\[0\].pe_hold2957 _300_/Q VGND VGND VPWR VPWR g_row\[1\].g_col\[0\].pe_hold2957/X
+ sky130_fd_sc_hd__clkbuf_2
Xg_row\[1\].g_col\[0\].pe_hold2946 _301_/Q VGND VGND VPWR VPWR g_row\[1\].g_col\[0\].pe_hold2946/X
+ sky130_fd_sc_hd__clkbuf_2
XFILLER_38_514 VGND VGND VPWR VPWR sky130_fd_sc_hd__decap_3
Xg_row\[0\].g_col\[0\].pe__1761_ g_row\[0\].g_col\[0\].pe__1761_/A1 place1214/A place1216/X
+ g_row\[0\].g_col\[0\].pe__1761_/B2 VGND VGND VPWR VPWR g_row\[0\].g_col\[0\].pe__1762_/B
+ sky130_fd_sc_hd__a22o_2
Xg_row\[1\].g_col\[1\].pe__2320_ g_row\[1\].g_col\[1\].pe__2368_/A g_row\[1\].g_col\[1\].pe__2348_/B
+ VGND VGND VPWR VPWR g_row\[1\].g_col\[1\].pe__2337_/B sky130_fd_sc_hd__nor2_2
Xg_row\[1\].g_col\[0\].pe__2304_ g_row\[1\].g_col\[0\].pe__2304_/A g_row\[1\].g_col\[0\].pe__2304_/B
+ g_row\[1\].g_col\[0\].pe__2304_/C VGND VGND VPWR VPWR g_row\[1\].g_col\[0\].pe__2305_/B
+ sky130_fd_sc_hd__and3_2
XFILLER_65_344 VGND VGND VPWR VPWR sky130_fd_sc_hd__fill_2
Xclkbuf_4_1_0_clk clkbuf_0_clk/X VGND VGND VPWR VPWR clkload0/A sky130_fd_sc_hd__clkbuf_16
Xg_row\[1\].g_col\[1\].pe__2251_ g_row\[1\].g_col\[1\].pe__2283_/A g_row\[1\].g_col\[1\].pe__2251_/B
+ VGND VGND VPWR VPWR g_row\[1\].g_col\[1\].pe__2273_/B sky130_fd_sc_hd__and2_2
Xg_row\[0\].g_col\[0\].pe__1692_ g_row\[0\].g_col\[0\].pe__1689_/Y g_row\[0\].g_col\[0\].pe__1722_/B
+ g_row\[0\].g_col\[0\].pe__1691_/Y VGND VGND VPWR VPWR g_row\[0\].g_col\[0\].pe__1695_/A
+ sky130_fd_sc_hd__a21o_2
Xg_row\[1\].g_col\[0\].pe__2235_ g_row\[1\].g_col\[0\].pe__2235_/A VGND VGND VPWR
+ VPWR g_row\[1\].g_col\[0\].pe__2436_/A sky130_fd_sc_hd__inv_2
XFILLER_18_282 VGND VGND VPWR VPWR sky130_fd_sc_hd__fill_2
XTAP_TAPCELL_ROW_36_748 VGND VPWR sky130_fd_sc_hd__tapvpwrvgnd_1
Xg_row\[1\].g_col\[1\].pe__2182_ g_row\[1\].g_col\[1\].pe__2182_/A g_row\[1\].g_col\[1\].pe__2182_/B
+ VGND VGND VPWR VPWR g_row\[1\].g_col\[1\].pe__2183_/B sky130_fd_sc_hd__xor2_2
Xg_row\[1\].g_col\[0\].pe__2166_ g_row\[1\].g_col\[0\].pe__2165_/B g_row\[1\].g_col\[0\].pe__2165_/C
+ g_row\[1\].g_col\[0\].pe__2165_/A VGND VGND VPWR VPWR g_row\[1\].g_col\[0\].pe__2167_/C
+ sky130_fd_sc_hd__a21o_2
XFILLER_33_252 VGND VGND VPWR VPWR sky130_fd_sc_hd__decap_3
XFILLER_34_764 VGND VGND VPWR VPWR sky130_fd_sc_hd__fill_2
XTAP_TAPCELL_ROW_16_450 VGND VPWR sky130_fd_sc_hd__tapvpwrvgnd_1
Xg_row\[0\].g_col\[0\].pe__2313_ g_row\[0\].g_col\[0\].pe__2388_/A g_row\[0\].g_col\[0\].pe__1504_/Y
+ g_row\[0\].g_col\[0\].pe__1541_/X g_row\[0\].g_col\[0\].pe__2121_/A VGND VGND VPWR
+ VPWR g_row\[0\].g_col\[0\].pe__2314_/B sky130_fd_sc_hd__a22o_2
Xg_row\[1\].g_col\[0\].pe__2097_ g_row\[1\].g_col\[0\].pe__2097_/A g_row\[1\].g_col\[0\].pe__2097_/B
+ g_row\[1\].g_col\[0\].pe__2097_/C VGND VGND VPWR VPWR g_row\[1\].g_col\[0\].pe__2184_/B
+ sky130_fd_sc_hd__or3_4
Xg_row\[0\].g_col\[1\].pe__2260_ g_row\[0\].g_col\[1\].pe__2330_/A g_row\[0\].g_col\[1\].pe__2330_/B
+ VGND VGND VPWR VPWR g_row\[0\].g_col\[1\].pe__2262_/B sky130_fd_sc_hd__xnor2_2
Xg_row\[0\].g_col\[0\].pe__2244_ g_row\[0\].g_col\[0\].pe__2277_/A g_row\[0\].g_col\[0\].pe__2277_/B
+ VGND VGND VPWR VPWR g_row\[0\].g_col\[0\].pe__2288_/B sky130_fd_sc_hd__xor2_2
Xg_row\[0\].g_col\[0\].pe__2175_ g_row\[0\].g_col\[0\].pe__2128_/B g_row\[0\].g_col\[0\].pe__2128_/C
+ g_row\[0\].g_col\[0\].pe__2128_/A VGND VGND VPWR VPWR g_row\[0\].g_col\[0\].pe__2175_/X
+ sky130_fd_sc_hd__a21o_2
Xg_row\[0\].g_col\[1\].pe__2191_ g_row\[0\].g_col\[1\].pe__2191_/A g_row\[0\].g_col\[1\].pe__2228_/B
+ VGND VGND VPWR VPWR g_row\[0\].g_col\[1\].pe__2202_/A sky130_fd_sc_hd__or2_4
Xg_row\[1\].g_col\[1\].pe__1966_ g_row\[1\].g_col\[1\].pe__2701_/Q VGND VGND VPWR
+ VPWR g_row\[1\].g_col\[1\].pe__1966_/Y sky130_fd_sc_hd__inv_2
Xg_row\[1\].g_col\[1\].pe_hold1819 g_row\[1\].g_col\[1\].pe__2528_/X VGND VGND VPWR
+ VPWR g_row\[1\].g_col\[1\].pe__2529_/B sky130_fd_sc_hd__clkbuf_2
Xg_row\[1\].g_col\[1\].pe_hold1808 g_row\[1\].g_col\[1\].pe__2763_/Q VGND VGND VPWR
+ VPWR g_row\[1\].g_col\[1\].pe__2560_/A1 sky130_fd_sc_hd__clkbuf_2
XFILLER_0_318 VGND VGND VPWR VPWR sky130_fd_sc_hd__fill_1
XTAP_TAPCELL_ROW_58_1082 VGND VPWR sky130_fd_sc_hd__tapvpwrvgnd_1
Xhold3202 hold3202/A VGND VGND VPWR VPWR hold3202/X sky130_fd_sc_hd__clkbuf_2
Xhold3213 hold3213/A VGND VGND VPWR VPWR hold3213/X sky130_fd_sc_hd__clkbuf_2
Xhold3224 hold3224/A VGND VGND VPWR VPWR hold3224/X sky130_fd_sc_hd__clkbuf_2
Xg_row\[1\].g_col\[1\].pe__1897_ g_row\[1\].g_col\[1\].pe__1886_/A g_row\[1\].g_col\[1\].pe__1897_/B
+ VGND VGND VPWR VPWR g_row\[1\].g_col\[1\].pe__1941_/B sky130_fd_sc_hd__nand2b_2
Xhold2501 hold3241/X VGND VGND VPWR VPWR _159_/B_N sky130_fd_sc_hd__clkbuf_2
Xhold2512 hold3302/X VGND VGND VPWR VPWR hold3303/A sky130_fd_sc_hd__clkbuf_2
Xhold3235 a_inputs_flat[8] VGND VGND VPWR VPWR hold3235/X sky130_fd_sc_hd__clkbuf_2
Xhold3246 hold3246/A VGND VGND VPWR VPWR hold3246/X sky130_fd_sc_hd__clkbuf_2
Xhold3257 hold3257/A VGND VGND VPWR VPWR hold3257/X sky130_fd_sc_hd__clkbuf_2
XFILLER_29_503 VGND VGND VPWR VPWR sky130_fd_sc_hd__fill_1
XFILLER_69_650 VGND VGND VPWR VPWR sky130_fd_sc_hd__decap_3
XTAP_TAPCELL_ROW_71_1271 VGND VPWR sky130_fd_sc_hd__tapvpwrvgnd_1
XTAP_TAPCELL_ROW_71_1282 VGND VPWR sky130_fd_sc_hd__tapvpwrvgnd_1
Xhold2523 hold3293/X VGND VGND VPWR VPWR hold3294/A sky130_fd_sc_hd__clkbuf_2
Xhold2534 hold3256/X VGND VGND VPWR VPWR hold3257/A sky130_fd_sc_hd__clkbuf_2
Xhold2545 hold2545/A VGND VGND VPWR VPWR _324_/D sky130_fd_sc_hd__clkbuf_2
Xhold2556 _241_/Y VGND VGND VPWR VPWR hold2556/X sky130_fd_sc_hd__clkbuf_2
Xhold3268 hold3268/A VGND VGND VPWR VPWR hold3268/X sky130_fd_sc_hd__clkbuf_2
Xhold3279 hold3279/A VGND VGND VPWR VPWR hold3279/X sky130_fd_sc_hd__clkbuf_2
Xhold2567 hold3325/X VGND VGND VPWR VPWR _263_/B_N sky130_fd_sc_hd__clkbuf_2
Xhold2578 hold3309/X VGND VGND VPWR VPWR hold3310/A sky130_fd_sc_hd__clkbuf_2
Xhold2589 hold3342/X VGND VGND VPWR VPWR hold3343/A sky130_fd_sc_hd__clkbuf_2
Xg_row\[1\].g_col\[0\].pe_wire1420 g_row\[1\].g_col\[0\].pe__2517_/Y VGND VGND VPWR
+ VPWR g_row\[1\].g_col\[0\].pe__2591_/B1 sky130_fd_sc_hd__clkbuf_8
Xg_row\[0\].g_col\[1\].pe__1975_ g_row\[0\].g_col\[1\].pe__1974_/A g_row\[0\].g_col\[1\].pe__1974_/B
+ g_row\[0\].g_col\[1\].pe__1974_/C g_row\[0\].g_col\[1\].pe__1974_/D VGND VGND VPWR
+ VPWR g_row\[0\].g_col\[1\].pe__1978_/B sky130_fd_sc_hd__a22oi_2
XFILLER_84_653 VGND VGND VPWR VPWR sky130_fd_sc_hd__fill_1
Xg_row\[0\].g_col\[0\].pe__1959_ g_row\[0\].g_col\[0\].pe__2217_/A g_row\[0\].g_col\[0\].pe__1959_/B
+ VGND VGND VPWR VPWR g_row\[0\].g_col\[0\].pe__1961_/B sky130_fd_sc_hd__xnor2_2
Xg_row\[1\].g_col\[1\].pe__2449_ g_row\[1\].g_col\[1\].pe__2741_/Q g_row\[1\].g_col\[1\].pe__2455_/B
+ g_row\[1\].g_col\[1\].pe__2399_/Y VGND VGND VPWR VPWR g_row\[1\].g_col\[1\].pe__2453_/B
+ sky130_fd_sc_hd__o21a_2
XFILLER_83_196 VGND VGND VPWR VPWR sky130_fd_sc_hd__fill_1
XFILLER_52_572 VGND VGND VPWR VPWR sky130_fd_sc_hd__decap_3
XFILLER_12_425 VGND VGND VPWR VPWR sky130_fd_sc_hd__fill_2
Xg_row\[0\].g_col\[1\].pe__2527_ g_row\[0\].g_col\[1\].pe__2525_/Y g_row\[0\].g_col\[1\].pe__2526_/X
+ g_row\[0\].g_col\[1\].pe__2559_/A VGND VGND VPWR VPWR g_row\[0\].g_col\[1\].pe__2527_/X
+ sky130_fd_sc_hd__a21o_2
XFILLER_33_66 VGND VGND VPWR VPWR sky130_fd_sc_hd__fill_2
XFILLER_33_77 VGND VGND VPWR VPWR sky130_fd_sc_hd__fill_1
XFILLER_8_418 VGND VGND VPWR VPWR sky130_fd_sc_hd__fill_2
Xg_row\[0\].g_col\[1\].pe__2458_ g_row\[0\].g_col\[1\].pe__2458_/A g_row\[0\].g_col\[1\].pe__2458_/B
+ VGND VGND VPWR VPWR g_row\[0\].g_col\[1\].pe__2526_/A sky130_fd_sc_hd__nor2_2
XPHY_EDGE_ROW_49_Left_143 VGND VGND VPWR VPWR sky130_fd_sc_hd__decap_3
Xg_row\[0\].g_col\[1\].pe__2389_ g_row\[0\].g_col\[1\].pe__2364_/A g_row\[0\].g_col\[1\].pe__2364_/B
+ g_row\[0\].g_col\[1\].pe__2366_/X VGND VGND VPWR VPWR g_row\[0\].g_col\[1\].pe__2390_/B
+ sky130_fd_sc_hd__o21a_2
XFILLER_4_602 VGND VGND VPWR VPWR sky130_fd_sc_hd__decap_3
XFILLER_4_624 VGND VGND VPWR VPWR sky130_fd_sc_hd__decap_3
XFILLER_0_841 VGND VGND VPWR VPWR sky130_fd_sc_hd__fill_1
XPHY_EDGE_ROW_58_Left_152 VGND VGND VPWR VPWR sky130_fd_sc_hd__decap_3
XFILLER_58_85 VGND VGND VPWR VPWR sky130_fd_sc_hd__fill_1
XFILLER_59_171 VGND VGND VPWR VPWR sky130_fd_sc_hd__fill_1
XFILLER_59_193 VGND VGND VPWR VPWR sky130_fd_sc_hd__decap_3
XFILLER_75_653 VGND VGND VPWR VPWR sky130_fd_sc_hd__decap_3
XTAP_TAPCELL_ROW_89_1543 VGND VPWR sky130_fd_sc_hd__tapvpwrvgnd_1
XFILLER_90_612 VGND VGND VPWR VPWR sky130_fd_sc_hd__decap_3
Xg_row\[1\].g_col\[0\].pe__2020_ g_row\[1\].g_col\[0\].pe__2616_/B g_row\[1\].g_col\[0\].pe__1549_/B
+ g_row\[1\].g_col\[0\].pe__2074_/B1 place1094/A VGND VGND VPWR VPWR g_row\[1\].g_col\[0\].pe__2021_/B
+ sky130_fd_sc_hd__a22o_2
XTAP_TAPCELL_ROW_33_707 VGND VPWR sky130_fd_sc_hd__tapvpwrvgnd_1
Xg_row\[0\].g_col\[1\].pe_hold2191 g_row\[0\].g_col\[1\].pe_hold2342/X VGND VGND VPWR
+ VPWR g_row\[0\].g_col\[1\].pe__2664_/A2 sky130_fd_sc_hd__clkbuf_2
XFILLER_30_222 VGND VGND VPWR VPWR sky130_fd_sc_hd__decap_3
XFILLER_43_572 VGND VGND VPWR VPWR sky130_fd_sc_hd__decap_3
XPHY_EDGE_ROW_67_Left_161 VGND VGND VPWR VPWR sky130_fd_sc_hd__decap_3
X_209_ _219_/A _209_/B_N VGND VGND VPWR VPWR _209_/Y sky130_fd_sc_hd__nor2b_4
Xplace1106 place1106/A VGND VGND VPWR VPWR place1106/X sky130_fd_sc_hd__buf_6
Xg_row\[1\].g_col\[1\].pe__1820_ g_row\[1\].g_col\[1\].pe__1820_/A g_row\[1\].g_col\[1\].pe__1820_/B
+ VGND VGND VPWR VPWR g_row\[1\].g_col\[1\].pe__1821_/D sky130_fd_sc_hd__nor2_2
Xg_row\[1\].g_col\[0\].pe__1804_ g_row\[1\].g_col\[0\].pe__1804_/A g_row\[1\].g_col\[0\].pe__1804_/B
+ VGND VGND VPWR VPWR g_row\[1\].g_col\[0\].pe__1804_/X sky130_fd_sc_hd__or2_2
Xg_row\[1\].g_col\[1\].pe__1751_ g_row\[1\].g_col\[1\].pe__2692_/Q g_row\[1\].g_col\[1\].pe__1414_/X
+ g_row\[1\].g_col\[1\].pe__1415_/Y g_row\[1\].g_col\[1\].pe__1801_/B g_row\[1\].g_col\[1\].pe__1782_/A2
+ VGND VGND VPWR VPWR g_row\[1\].g_col\[1\].pe__1752_/B sky130_fd_sc_hd__a32o_2
Xg_row\[1\].g_col\[0\].pe__1735_ g_row\[1\].g_col\[0\].pe__1758_/A g_row\[1\].g_col\[0\].pe__1758_/B
+ g_row\[1\].g_col\[0\].pe__1734_/X VGND VGND VPWR VPWR g_row\[1\].g_col\[0\].pe__1740_/A
+ sky130_fd_sc_hd__a21oi_2
XPHY_EDGE_ROW_76_Left_170 VGND VGND VPWR VPWR sky130_fd_sc_hd__decap_3
Xg_row\[1\].g_col\[1\].pe__1682_ g_row\[1\].g_col\[1\].pe__1730_/A g_row\[1\].g_col\[1\].pe__1682_/B
+ VGND VGND VPWR VPWR g_row\[1\].g_col\[1\].pe__1686_/B sky130_fd_sc_hd__xor2_2
Xg_row\[1\].g_col\[0\].pe__1666_ g_row\[1\].g_col\[0\].pe__1697_/B g_row\[1\].g_col\[0\].pe__1697_/A
+ VGND VGND VPWR VPWR g_row\[1\].g_col\[0\].pe__1666_/Y sky130_fd_sc_hd__nand2b_2
Xg_row\[0\].g_col\[0\].pe__1813_ g_row\[0\].g_col\[0\].pe__1813_/A g_row\[0\].g_col\[0\].pe__1813_/B
+ VGND VGND VPWR VPWR g_row\[0\].g_col\[0\].pe__1813_/Y sky130_fd_sc_hd__nand2_2
Xg_row\[1\].g_col\[0\].pe__1597_ g_row\[1\].g_col\[0\].pe__1571_/A g_row\[1\].g_col\[0\].pe__1571_/B
+ g_row\[1\].g_col\[0\].pe__1596_/X VGND VGND VPWR VPWR g_row\[1\].g_col\[0\].pe__1606_/A
+ sky130_fd_sc_hd__a21oi_2
XFILLER_66_664 VGND VGND VPWR VPWR sky130_fd_sc_hd__fill_1
Xg_row\[1\].g_col\[1\].pe__2303_ g_row\[1\].g_col\[1\].pe__2233_/C g_row\[1\].g_col\[1\].pe__2299_/B
+ g_row\[1\].g_col\[1\].pe__2302_/Y VGND VGND VPWR VPWR g_row\[1\].g_col\[1\].pe__2304_/C
+ sky130_fd_sc_hd__o21a_2
Xg_row\[0\].g_col\[1\].pe__1760_ g_row\[0\].g_col\[1\].pe__1816_/B g_row\[0\].g_col\[1\].pe__1760_/B
+ VGND VGND VPWR VPWR g_row\[0\].g_col\[1\].pe__1780_/A sky130_fd_sc_hd__xnor2_2
XFILLER_53_314 VGND VGND VPWR VPWR sky130_fd_sc_hd__decap_3
XFILLER_81_623 VGND VGND VPWR VPWR sky130_fd_sc_hd__decap_3
Xg_row\[0\].g_col\[0\].pe__1744_ g_row\[0\].g_col\[0\].pe__1815_/B g_row\[0\].g_col\[0\].pe__1815_/A
+ VGND VGND VPWR VPWR g_row\[0\].g_col\[0\].pe__1819_/A sky130_fd_sc_hd__nand2b_2
Xg_row\[0\].g_col\[0\].pe__1675_ g_row\[0\].g_col\[0\].pe__1676_/A g_row\[0\].g_col\[0\].pe__1676_/B
+ VGND VGND VPWR VPWR g_row\[0\].g_col\[0\].pe__1823_/A sky130_fd_sc_hd__nor2_2
Xg_row\[0\].g_col\[1\].pe__1691_ g_row\[0\].g_col\[1\].pe__1721_/A g_row\[0\].g_col\[1\].pe__1721_/B
+ VGND VGND VPWR VPWR g_row\[0\].g_col\[1\].pe__1691_/Y sky130_fd_sc_hd__nor2_2
Xg_row\[1\].g_col\[1\].pe__2234_ g_row\[1\].g_col\[1\].pe__2233_/A g_row\[1\].g_col\[1\].pe__2233_/C
+ g_row\[1\].g_col\[1\].pe__2298_/A VGND VGND VPWR VPWR g_row\[1\].g_col\[1\].pe__2234_/Y
+ sky130_fd_sc_hd__a21oi_2
Xg_row\[1\].g_col\[0\].pe__2218_ g_row\[1\].g_col\[0\].pe__2239_/A g_row\[1\].g_col\[0\].pe__2239_/B
+ VGND VGND VPWR VPWR g_row\[1\].g_col\[0\].pe__2219_/B sky130_fd_sc_hd__xor2_2
XFILLER_22_701 VGND VGND VPWR VPWR sky130_fd_sc_hd__decap_3
XFILLER_53_369 VGND VGND VPWR VPWR sky130_fd_sc_hd__fill_1
Xg_row\[1\].g_col\[1\].pe__2165_ g_row\[1\].g_col\[1\].pe__2165_/A g_row\[1\].g_col\[1\].pe__2165_/B
+ g_row\[1\].g_col\[1\].pe__2165_/C VGND VGND VPWR VPWR g_row\[1\].g_col\[1\].pe__2167_/B
+ sky130_fd_sc_hd__nand3_2
Xg_row\[1\].g_col\[0\].pe__2149_ g_row\[1\].g_col\[0\].pe__2161_/A g_row\[1\].g_col\[0\].pe__2161_/B
+ VGND VGND VPWR VPWR g_row\[1\].g_col\[0\].pe__2200_/A sky130_fd_sc_hd__xnor2_2
Xg_row\[1\].g_col\[1\].pe__2096_ g_row\[1\].g_col\[1\].pe__2097_/B g_row\[1\].g_col\[1\].pe__2097_/C
+ g_row\[1\].g_col\[1\].pe__2097_/A VGND VGND VPWR VPWR g_row\[1\].g_col\[1\].pe__2099_/A
+ sky130_fd_sc_hd__o21ai_2
Xg_row\[0\].g_col\[1\].pe__2312_ g_row\[0\].g_col\[1\].pe__2627_/B g_row\[0\].g_col\[1\].pe__1558_/B
+ g_row\[0\].g_col\[1\].pe__2388_/B g_row\[0\].g_col\[1\].pe__2625_/B VGND VGND VPWR
+ VPWR g_row\[0\].g_col\[1\].pe__2316_/A sky130_fd_sc_hd__a22o_2
XFILLER_21_277 VGND VGND VPWR VPWR sky130_fd_sc_hd__decap_3
XFILLER_21_288 VGND VGND VPWR VPWR sky130_fd_sc_hd__fill_2
Xg_row\[0\].g_col\[0\].pe__2227_ g_row\[0\].g_col\[0\].pe__2228_/A g_row\[0\].g_col\[0\].pe__2228_/B
+ g_row\[0\].g_col\[0\].pe__2228_/C VGND VGND VPWR VPWR g_row\[0\].g_col\[0\].pe__2262_/A
+ sky130_fd_sc_hd__o21ai_2
Xg_row\[1\].g_col\[1\].pe_hold3007 place1100/A VGND VGND VPWR VPWR g_row\[1\].g_col\[1\].pe__2608_/A2
+ sky130_fd_sc_hd__clkbuf_2
Xg_row\[0\].g_col\[1\].pe__2243_ g_row\[0\].g_col\[1\].pe__2364_/A g_row\[0\].g_col\[1\].pe__2243_/B
+ VGND VGND VPWR VPWR g_row\[0\].g_col\[1\].pe__2277_/B sky130_fd_sc_hd__xnor2_2
Xg_row\[0\].g_col\[1\].pe__2174_ g_row\[0\].g_col\[1\].pe__2174_/A g_row\[0\].g_col\[1\].pe__2174_/B
+ VGND VGND VPWR VPWR g_row\[0\].g_col\[1\].pe__2182_/A sky130_fd_sc_hd__nand2_2
Xg_row\[0\].g_col\[0\].pe__2158_ g_row\[0\].g_col\[0\].pe__2599_/A g_row\[0\].g_col\[0\].pe__2158_/A2
+ g_row\[0\].g_col\[0\].pe__2155_/X g_row\[0\].g_col\[0\].pe__2157_/Y VGND VGND VPWR
+ VPWR g_row\[0\].g_col\[0\].pe__2158_/X sky130_fd_sc_hd__o22a_2
XTAP_TAPCELL_ROW_73_1300 VGND VPWR sky130_fd_sc_hd__tapvpwrvgnd_1
XTAP_TAPCELL_ROW_73_1311 VGND VPWR sky130_fd_sc_hd__tapvpwrvgnd_1
Xg_row\[0\].g_col\[0\].pe__2089_ g_row\[0\].g_col\[0\].pe__1970_/A g_row\[0\].g_col\[0\].pe__1471_/X
+ g_row\[0\].g_col\[0\].pe__1474_/Y g_row\[0\].g_col\[0\].pe__2241_/B2 VGND VGND VPWR
+ VPWR g_row\[0\].g_col\[0\].pe__2090_/B sky130_fd_sc_hd__a22o_2
XFILLER_0_115 VGND VGND VPWR VPWR sky130_fd_sc_hd__fill_1
Xg_row\[1\].g_col\[1\].pe_hold1649 g_row\[1\].g_col\[1\].pe__2115_/Y VGND VGND VPWR
+ VPWR g_row\[1\].g_col\[1\].pe__2744_/D sky130_fd_sc_hd__clkbuf_2
XFILLER_49_609 VGND VGND VPWR VPWR sky130_fd_sc_hd__decap_3
Xhold1630 hold3584/X VGND VGND VPWR VPWR hold3585/A sky130_fd_sc_hd__clkbuf_2
Xhold1641 hold1641/A VGND VGND VPWR VPWR hold1641/X sky130_fd_sc_hd__clkbuf_2
XFILLER_45_837 VGND VGND VPWR VPWR sky130_fd_sc_hd__decap_3
XFILLER_56_141 VGND VGND VPWR VPWR sky130_fd_sc_hd__fill_1
Xg_row\[0\].g_col\[1\].pe__1958_ g_row\[0\].g_col\[1\].pe__2696_/Q g_row\[0\].g_col\[1\].pe__1549_/B
+ g_row\[0\].g_col\[1\].pe__2216_/B1 g_row\[0\].g_col\[1\].pe__2073_/B2 VGND VGND
+ VPWR VPWR g_row\[0\].g_col\[1\].pe__1959_/B sky130_fd_sc_hd__a22o_2
XFILLER_72_656 VGND VGND VPWR VPWR sky130_fd_sc_hd__decap_3
Xg_row\[0\].g_col\[1\].pe__1889_ g_row\[0\].g_col\[1\].pe__1951_/A g_row\[0\].g_col\[1\].pe__1889_/B
+ VGND VGND VPWR VPWR g_row\[0\].g_col\[1\].pe__1894_/B sky130_fd_sc_hd__nor2_2
XFILLER_25_561 VGND VGND VPWR VPWR sky130_fd_sc_hd__decap_3
XTAP_TAPCELL_ROW_84_1473 VGND VPWR sky130_fd_sc_hd__tapvpwrvgnd_1
XFILLER_13_778 VGND VGND VPWR VPWR sky130_fd_sc_hd__decap_3
XFILLER_40_531 VGND VGND VPWR VPWR sky130_fd_sc_hd__fill_1
Xg_row\[0\].g_col\[0\].pe_place1200 hold2229/A VGND VGND VPWR VPWR g_row\[0\].g_col\[0\].pe__2030_/A
+ sky130_fd_sc_hd__buf_6
Xg_row\[0\].g_col\[0\].pe_place1211 place1212/X VGND VGND VPWR VPWR g_row\[0\].g_col\[0\].pe__1866_/B2
+ sky130_fd_sc_hd__buf_6
Xg_row\[0\].g_col\[0\].pe_place1255 g_row\[0\].g_col\[0\].pe__2676_/A VGND VGND VPWR
+ VPWR g_row\[0\].g_col\[0\].pe__2669_/A sky130_fd_sc_hd__buf_6
XFILLER_4_421 VGND VGND VPWR VPWR sky130_fd_sc_hd__fill_1
XFILLER_5_48 VGND VGND VPWR VPWR sky130_fd_sc_hd__fill_1
Xg_row\[1\].g_col\[1\].pe_hold2840 g_row\[1\].g_col\[1\].pe__2664_/X VGND VGND VPWR
+ VPWR g_row\[1\].g_col\[1\].pe_hold2840/X sky130_fd_sc_hd__clkbuf_2
XFILLER_79_222 VGND VGND VPWR VPWR sky130_fd_sc_hd__fill_2
Xg_row\[1\].g_col\[1\].pe_hold2862 g_row\[1\].g_col\[1\].pe__2714_/Q VGND VGND VPWR
+ VPWR g_row\[1\].g_col\[1\].pe__2657_/B sky130_fd_sc_hd__clkbuf_2
Xg_row\[1\].g_col\[1\].pe_hold2873 g_row\[1\].g_col\[1\].pe__2659_/X VGND VGND VPWR
+ VPWR g_row\[1\].g_col\[1\].pe__2660_/C1 sky130_fd_sc_hd__clkbuf_2
Xg_row\[1\].g_col\[1\].pe_hold2884 g_row\[1\].g_col\[1\].pe_hold2884/A VGND VGND VPWR
+ VPWR g_row\[1\].g_col\[1\].pe__2677_/A1 sky130_fd_sc_hd__clkbuf_2
Xg_row\[1\].g_col\[0\].pe__1520_ g_row\[1\].g_col\[0\].pe__1580_/A g_row\[1\].g_col\[0\].pe__1580_/B
+ VGND VGND VPWR VPWR g_row\[1\].g_col\[0\].pe__1523_/A sky130_fd_sc_hd__xor2_2
XFILLER_0_671 VGND VGND VPWR VPWR sky130_fd_sc_hd__fill_1
XFILLER_0_682 VGND VGND VPWR VPWR sky130_fd_sc_hd__decap_3
XFILLER_79_288 VGND VGND VPWR VPWR sky130_fd_sc_hd__fill_2
Xg_row\[1\].g_col\[0\].pe__1451_ hold1950/A g_row\[1\].g_col\[0\].pe__1748_/B g_row\[1\].g_col\[0\].pe__1738_/B1
+ g_row\[1\].g_col\[0\].pe__2610_/B VGND VGND VPWR VPWR g_row\[1\].g_col\[0\].pe__1452_/B
+ sky130_fd_sc_hd__a22o_2
XPHY_EDGE_ROW_13_Right_13 VGND VGND VPWR VPWR sky130_fd_sc_hd__decap_3
XFILLER_63_601 VGND VGND VPWR VPWR sky130_fd_sc_hd__fill_1
XTAP_TAPCELL_ROW_46_898 VGND VPWR sky130_fd_sc_hd__tapvpwrvgnd_1
Xg_row\[0\].g_col\[0\].pe__1460_ g_row\[0\].g_col\[0\].pe__2731_/Q g_row\[0\].g_col\[0\].pe__1460_/B
+ g_row\[0\].g_col\[0\].pe__2732_/Q VGND VGND VPWR VPWR g_row\[0\].g_col\[0\].pe__1461_/B
+ sky130_fd_sc_hd__or3b_4
Xg_row\[1\].g_col\[0\].pe__2003_ g_row\[1\].g_col\[0\].pe__2013_/A g_row\[1\].g_col\[0\].pe__2013_/B
+ VGND VGND VPWR VPWR g_row\[1\].g_col\[0\].pe__2005_/B sky130_fd_sc_hd__xor2_2
XFILLER_31_553 VGND VGND VPWR VPWR sky130_fd_sc_hd__decap_3
Xg_row\[0\].g_col\[0\].pe__1391_ g_row\[0\].g_col\[0\].pe__1391_/A1 g_row\[0\].g_col\[0\].pe__1399_/A2
+ g_row\[0\].g_col\[0\].pe__1389_/X g_row\[0\].g_col\[0\].pe__2633_/B1 VGND VGND VPWR
+ VPWR g_row\[0\].g_col\[0\].pe__1391_/X sky130_fd_sc_hd__o211a_2
XFILLER_31_586 VGND VGND VPWR VPWR sky130_fd_sc_hd__decap_3
XFILLER_86_3 VGND VGND VPWR VPWR sky130_fd_sc_hd__fill_1
XPHY_EDGE_ROW_22_Right_22 VGND VGND VPWR VPWR sky130_fd_sc_hd__decap_3
XFILLER_8_760 VGND VGND VPWR VPWR sky130_fd_sc_hd__decap_3
Xg_row\[0\].g_col\[0\].pe__2012_ g_row\[0\].g_col\[0\].pe__1951_/A g_row\[0\].g_col\[0\].pe__1951_/B
+ g_row\[0\].g_col\[0\].pe__2009_/B g_row\[0\].g_col\[0\].pe__2006_/A VGND VGND VPWR
+ VPWR g_row\[0\].g_col\[0\].pe__2062_/C sky130_fd_sc_hd__a31o_2
Xg_row\[1\].g_col\[1\].pe__1803_ g_row\[1\].g_col\[1\].pe__1807_/A g_row\[1\].g_col\[1\].pe__1807_/B
+ VGND VGND VPWR VPWR g_row\[1\].g_col\[1\].pe__1803_/Y sky130_fd_sc_hd__nor2_2
XTAP_TAPCELL_ROW_55_1030 VGND VPWR sky130_fd_sc_hd__tapvpwrvgnd_1
XTAP_TAPCELL_ROW_55_1041 VGND VPWR sky130_fd_sc_hd__tapvpwrvgnd_1
Xg_row\[1\].g_col\[1\].pe__1734_ g_row\[1\].g_col\[1\].pe__1734_/A g_row\[1\].g_col\[1\].pe__1734_/B
+ VGND VGND VPWR VPWR g_row\[1\].g_col\[1\].pe__1734_/X sky130_fd_sc_hd__and2_2
Xg_row\[1\].g_col\[0\].pe__2767_ clkbuf_leaf_53_clk/X g_row\[1\].g_col\[0\].pe__2767_/D
+ VGND VGND VPWR VPWR g_row\[1\].g_col\[0\].pe__2767_/Q sky130_fd_sc_hd__dfxtp_2
Xg_row\[1\].g_col\[0\].pe__2698_ _302_/CLK g_row\[1\].g_col\[0\].pe__2698_/D VGND
+ VGND VPWR VPWR place1090/A sky130_fd_sc_hd__dfxtp_2
Xg_row\[1\].g_col\[0\].pe__1718_ g_row\[1\].g_col\[0\].pe__1724_/S g_row\[1\].g_col\[0\].pe__1718_/B
+ VGND VGND VPWR VPWR g_row\[1\].g_col\[0\].pe__1743_/B sky130_fd_sc_hd__xnor2_2
XFILLER_85_225 VGND VGND VPWR VPWR sky130_fd_sc_hd__fill_2
XPHY_EDGE_ROW_31_Right_31 VGND VGND VPWR VPWR sky130_fd_sc_hd__decap_3
Xg_row\[1\].g_col\[1\].pe__1665_ g_row\[1\].g_col\[1\].pe__1656_/A g_row\[1\].g_col\[1\].pe__1656_/B
+ g_row\[1\].g_col\[1\].pe__1664_/X VGND VGND VPWR VPWR g_row\[1\].g_col\[1\].pe__1697_/A
+ sky130_fd_sc_hd__a21bo_2
Xg_row\[1\].g_col\[0\].pe__1649_ g_row\[1\].g_col\[0\].pe__1688_/A g_row\[1\].g_col\[0\].pe__1688_/B
+ g_row\[1\].g_col\[0\].pe__1648_/X VGND VGND VPWR VPWR g_row\[1\].g_col\[0\].pe__1660_/A
+ sky130_fd_sc_hd__a21oi_2
Xg_row\[1\].g_col\[1\].pe__1596_ g_row\[1\].g_col\[1\].pe__1596_/A g_row\[1\].g_col\[1\].pe__1596_/B
+ VGND VGND VPWR VPWR g_row\[1\].g_col\[1\].pe__1596_/X sky130_fd_sc_hd__and2_2
XFILLER_38_141 VGND VGND VPWR VPWR sky130_fd_sc_hd__decap_3
Xg_row\[0\].g_col\[0\].pe__2776_ g_row\[0\].g_col\[0\].pe__2776_/A VGND VGND VPWR
+ VPWR output1361/A sky130_fd_sc_hd__buf_2
Xg_row\[1\].g_col\[0\].pe_hold1872 g_row\[1\].g_col\[0\].pe_hold3011/X VGND VGND VPWR
+ VPWR g_row\[1\].g_col\[0\].pe_hold3012/A sky130_fd_sc_hd__clkbuf_2
Xg_row\[1\].g_col\[0\].pe_hold1861 g_row\[1\].g_col\[0\].pe__1395_/X VGND VGND VPWR
+ VPWR g_row\[1\].g_col\[0\].pe__2733_/D sky130_fd_sc_hd__clkbuf_2
Xg_row\[0\].g_col\[1\].pe__1812_ g_row\[0\].g_col\[1\].pe__1813_/A g_row\[0\].g_col\[1\].pe__1780_/Y
+ g_row\[0\].g_col\[1\].pe__1810_/X g_row\[0\].g_col\[1\].pe__1811_/X VGND VGND VPWR
+ VPWR g_row\[0\].g_col\[1\].pe__1812_/X sky130_fd_sc_hd__o31a_2
XFILLER_54_645 VGND VGND VPWR VPWR sky130_fd_sc_hd__decap_3
Xg_row\[0\].g_col\[0\].pe__1727_ g_row\[0\].g_col\[0\].pe__1761_/A1 place1209/X place1212/X
+ g_row\[0\].g_col\[0\].pe__1761_/B2 VGND VGND VPWR VPWR g_row\[0\].g_col\[0\].pe__1728_/B
+ sky130_fd_sc_hd__a22o_2
Xg_row\[0\].g_col\[1\].pe__1743_ g_row\[0\].g_col\[1\].pe__1743_/A g_row\[0\].g_col\[1\].pe__1743_/B
+ VGND VGND VPWR VPWR g_row\[0\].g_col\[1\].pe__1815_/A sky130_fd_sc_hd__xnor2_2
XFILLER_81_442 VGND VGND VPWR VPWR sky130_fd_sc_hd__fill_2
XFILLER_81_453 VGND VGND VPWR VPWR sky130_fd_sc_hd__fill_2
Xg_row\[0\].g_col\[1\].pe__1674_ g_row\[0\].g_col\[1\].pe__1690_/A g_row\[0\].g_col\[1\].pe__1690_/B
+ VGND VGND VPWR VPWR g_row\[0\].g_col\[1\].pe__1676_/B sky130_fd_sc_hd__nand2_2
Xg_row\[1\].g_col\[1\].pe__2217_ g_row\[1\].g_col\[1\].pe__2364_/A g_row\[1\].g_col\[1\].pe__2217_/B
+ VGND VGND VPWR VPWR g_row\[1\].g_col\[1\].pe__2239_/B sky130_fd_sc_hd__xnor2_2
Xg_row\[0\].g_col\[0\].pe__1658_ g_row\[0\].g_col\[0\].pe__1676_/A g_row\[0\].g_col\[0\].pe__1658_/B
+ VGND VGND VPWR VPWR g_row\[0\].g_col\[0\].pe__1664_/A sky130_fd_sc_hd__xnor2_2
Xg_row\[0\].g_col\[0\].pe__1589_ g_row\[0\].g_col\[0\].pe__1547_/A g_row\[0\].g_col\[0\].pe__1547_/B
+ g_row\[0\].g_col\[0\].pe__1588_/Y VGND VGND VPWR VPWR g_row\[0\].g_col\[0\].pe__1594_/B
+ sky130_fd_sc_hd__a21o_2
Xg_row\[1\].g_col\[1\].pe__2148_ g_row\[1\].g_col\[1\].pe__2148_/A g_row\[1\].g_col\[1\].pe__2162_/B
+ VGND VGND VPWR VPWR g_row\[1\].g_col\[1\].pe__2161_/B sky130_fd_sc_hd__xnor2_2
XFILLER_22_564 VGND VGND VPWR VPWR sky130_fd_sc_hd__decap_3
XPHY_EDGE_ROW_40_Right_40 VGND VGND VPWR VPWR sky130_fd_sc_hd__decap_3
Xg_row\[1\].g_col\[1\].pe__2079_ g_row\[1\].g_col\[1\].pe__2163_/A g_row\[1\].g_col\[1\].pe__2079_/B
+ VGND VGND VPWR VPWR g_row\[1\].g_col\[1\].pe__2081_/B sky130_fd_sc_hd__nand2_2
XFILLER_22_597 VGND VGND VPWR VPWR sky130_fd_sc_hd__decap_3
Xg_row\[0\].g_col\[1\].pe__2226_ g_row\[0\].g_col\[1\].pe__2226_/A g_row\[0\].g_col\[1\].pe__2226_/B
+ VGND VGND VPWR VPWR g_row\[0\].g_col\[1\].pe__2228_/C sky130_fd_sc_hd__xor2_2
XFILLER_5_229 VGND VGND VPWR VPWR sky130_fd_sc_hd__fill_1
Xg_row\[0\].g_col\[1\].pe__2157_ g_row\[0\].g_col\[1\].pe__2157_/A g_row\[0\].g_col\[1\].pe__2157_/B
+ VGND VGND VPWR VPWR g_row\[0\].g_col\[1\].pe__2157_/Y sky130_fd_sc_hd__nand2_2
Xg_row\[0\].g_col\[1\].pe__2088_ g_row\[0\].g_col\[1\].pe__2087_/A g_row\[0\].g_col\[1\].pe__2087_/B
+ g_row\[0\].g_col\[1\].pe__2087_/C g_row\[0\].g_col\[1\].pe__2087_/D VGND VGND VPWR
+ VPWR g_row\[0\].g_col\[1\].pe__2091_/B sky130_fd_sc_hd__a22o_4
XFILLER_1_446 VGND VGND VPWR VPWR sky130_fd_sc_hd__fill_2
XFILLER_77_715 VGND VGND VPWR VPWR sky130_fd_sc_hd__fill_1
XFILLER_77_726 VGND VGND VPWR VPWR sky130_fd_sc_hd__fill_2
XFILLER_91_217 VGND VGND VPWR VPWR sky130_fd_sc_hd__fill_1
XTAP_TAPCELL_ROW_4_273 VGND VPWR sky130_fd_sc_hd__tapvpwrvgnd_1
XTAP_TAPCELL_ROW_86_1502 VGND VPWR sky130_fd_sc_hd__tapvpwrvgnd_1
Xhold1460 hold3240/X VGND VGND VPWR VPWR hold3241/A sky130_fd_sc_hd__clkbuf_2
XFILLER_57_494 VGND VGND VPWR VPWR sky130_fd_sc_hd__decap_3
Xhold1471 hold3229/X VGND VGND VPWR VPWR hold3230/A sky130_fd_sc_hd__clkbuf_2
Xhold1482 hold2526/X VGND VGND VPWR VPWR hold2527/A sky130_fd_sc_hd__clkbuf_2
Xhold1493 hold3261/X VGND VGND VPWR VPWR hold3262/A sky130_fd_sc_hd__clkbuf_2
XFILLER_55_97 VGND VGND VPWR VPWR sky130_fd_sc_hd__fill_2
XFILLER_72_475 VGND VGND VPWR VPWR sky130_fd_sc_hd__fill_1
Xg_row\[1\].g_col\[0\].pe_place843 g_row\[1\].g_col\[0\].pe__1838_/X VGND VGND VPWR
+ VPWR g_row\[1\].g_col\[0\].pe__2010_/A sky130_fd_sc_hd__buf_6
XTAP_TAPCELL_ROW_43_857 VGND VPWR sky130_fd_sc_hd__tapvpwrvgnd_1
XFILLER_13_564 VGND VGND VPWR VPWR sky130_fd_sc_hd__decap_3
XFILLER_13_586 VGND VGND VPWR VPWR sky130_fd_sc_hd__fill_2
XFILLER_40_372 VGND VGND VPWR VPWR sky130_fd_sc_hd__fill_1
XFILLER_9_502 VGND VGND VPWR VPWR sky130_fd_sc_hd__fill_2
Xg_row\[0\].g_col\[0\].pe_hold1959 g_row\[0\].g_col\[0\].pe__2380_/X VGND VGND VPWR
+ VPWR g_row\[0\].g_col\[0\].pe__2381_/B sky130_fd_sc_hd__clkbuf_2
XFILLER_4_251 VGND VGND VPWR VPWR sky130_fd_sc_hd__fill_1
Xg_row\[1\].g_col\[0\].pe__2621_ place1246/X hold3129/A VGND VGND VPWR VPWR g_row\[1\].g_col\[0\].pe__2621_/X
+ sky130_fd_sc_hd__or2_2
XFILLER_68_704 VGND VGND VPWR VPWR sky130_fd_sc_hd__decap_3
Xg_row\[1\].g_col\[0\].pe__2552_ g_row\[1\].g_col\[0\].pe__2551_/B g_row\[1\].g_col\[0\].pe__2551_/C
+ g_row\[1\].g_col\[0\].pe__2551_/A VGND VGND VPWR VPWR g_row\[1\].g_col\[0\].pe__2552_/X
+ sky130_fd_sc_hd__a21o_2
XFILLER_67_214 VGND VGND VPWR VPWR sky130_fd_sc_hd__fill_2
XFILLER_67_225 VGND VGND VPWR VPWR sky130_fd_sc_hd__fill_2
XFILLER_68_737 VGND VGND VPWR VPWR sky130_fd_sc_hd__fill_1
Xg_row\[1\].g_col\[1\].pe_hold1991 place1106/A VGND VGND VPWR VPWR g_row\[1\].g_col\[1\].pe__2600_/A2
+ sky130_fd_sc_hd__clkbuf_2
Xg_row\[1\].g_col\[1\].pe_hold1980 g_row\[1\].g_col\[1\].pe__2691_/Q VGND VGND VPWR
+ VPWR g_row\[1\].g_col\[1\].pe__2603_/B sky130_fd_sc_hd__clkbuf_2
Xg_row\[1\].g_col\[0\].pe__2483_ g_row\[1\].g_col\[0\].pe__2508_/A g_row\[1\].g_col\[0\].pe__2508_/B
+ g_row\[1\].g_col\[0\].pe__2425_/A VGND VGND VPWR VPWR g_row\[1\].g_col\[0\].pe__2509_/S
+ sky130_fd_sc_hd__a21oi_2
Xg_row\[1\].g_col\[0\].pe__1503_ g_row\[1\].g_col\[0\].pe__2735_/Q g_row\[1\].g_col\[0\].pe__2734_/Q
+ VGND VGND VPWR VPWR g_row\[1\].g_col\[0\].pe__2341_/B sky130_fd_sc_hd__nor2_2
XFILLER_76_781 VGND VGND VPWR VPWR sky130_fd_sc_hd__fill_1
Xg_row\[0\].g_col\[0\].pe__2630_ g_row\[0\].g_col\[0\].pe__2639_/A hold2340/X VGND
+ VGND VPWR VPWR g_row\[0\].g_col\[0\].pe__2630_/X sky130_fd_sc_hd__or2_2
XFILLER_36_645 VGND VGND VPWR VPWR sky130_fd_sc_hd__decap_3
XFILLER_48_483 VGND VGND VPWR VPWR sky130_fd_sc_hd__fill_2
Xg_row\[1\].g_col\[0\].pe__1365_ g_row\[1\].g_col\[0\].pe__2767_/Q g_row\[1\].g_col\[0\].pe__2766_/Q
+ g_row\[1\].g_col\[0\].pe__1361_/B g_row\[1\].g_col\[0\].pe__2594_/B2 VGND VGND VPWR
+ VPWR g_row\[1\].g_col\[0\].pe__1366_/B sky130_fd_sc_hd__o31a_2
XFILLER_63_442 VGND VGND VPWR VPWR sky130_fd_sc_hd__fill_1
Xg_row\[0\].g_col\[0\].pe__2561_ g_row\[0\].g_col\[0\].pe__2592_/A g_row\[0\].g_col\[0\].pe__2561_/B
+ VGND VGND VPWR VPWR g_row\[0\].g_col\[0\].pe__2763_/D sky130_fd_sc_hd__and2_4
XFILLER_23_328 VGND VGND VPWR VPWR sky130_fd_sc_hd__fill_1
Xg_row\[0\].g_col\[0\].pe__1512_ g_row\[0\].g_col\[0\].pe__1512_/A g_row\[0\].g_col\[0\].pe__1512_/B
+ VGND VGND VPWR VPWR g_row\[0\].g_col\[0\].pe__1512_/Y sky130_fd_sc_hd__nor2_2
Xg_row\[0\].g_col\[0\].pe__2492_ g_row\[0\].g_col\[0\].pe__2492_/A g_row\[0\].g_col\[0\].pe__2492_/B
+ VGND VGND VPWR VPWR g_row\[0\].g_col\[0\].pe__2567_/A sky130_fd_sc_hd__and2_2
Xg_row\[0\].g_col\[0\].pe__1443_ g_row\[0\].g_col\[0\].pe__1479_/A g_row\[0\].g_col\[0\].pe__1479_/B
+ VGND VGND VPWR VPWR g_row\[0\].g_col\[0\].pe__1662_/A sky130_fd_sc_hd__xor2_2
Xg_row\[1\].g_col\[1\].pe__2002_ g_row\[1\].g_col\[1\].pe__2002_/A g_row\[1\].g_col\[1\].pe__2002_/B
+ VGND VGND VPWR VPWR g_row\[1\].g_col\[1\].pe__2013_/B sky130_fd_sc_hd__xnor2_2
XTAP_TAPCELL_ROW_21_518 VGND VPWR sky130_fd_sc_hd__tapvpwrvgnd_1
XTAP_TAPCELL_ROW_21_529 VGND VPWR sky130_fd_sc_hd__tapvpwrvgnd_1
Xg_row\[0\].g_col\[0\].pe__1374_ place1262/X g_row\[0\].g_col\[0\].pe__1374_/B VGND
+ VGND VPWR VPWR g_row\[0\].g_col\[0\].pe__1385_/B sky130_fd_sc_hd__nand2_2
Xg_row\[0\].g_col\[1\].pe__2011_ g_row\[0\].g_col\[1\].pe__2011_/A1 g_row\[0\].g_col\[1\].pe__2010_/X
+ _203_/A VGND VGND VPWR VPWR g_row\[0\].g_col\[1\].pe__2011_/Y sky130_fd_sc_hd__a21oi_2
Xg_row\[1\].g_col\[1\].pe__2766_ clkbuf_leaf_74_clk/X g_row\[1\].g_col\[1\].pe__2766_/D
+ VGND VGND VPWR VPWR g_row\[1\].g_col\[1\].pe__2766_/Q sky130_fd_sc_hd__dfxtp_2
Xg_row\[1\].g_col\[1\].pe__2697_ clkbuf_leaf_69_clk/X g_row\[1\].g_col\[1\].pe__2697_/D
+ VGND VGND VPWR VPWR g_row\[1\].g_col\[1\].pe__2697_/Q sky130_fd_sc_hd__dfxtp_2
Xg_row\[1\].g_col\[1\].pe__1717_ g_row\[1\].g_col\[1\].pe__1739_/A g_row\[1\].g_col\[1\].pe__1717_/B
+ VGND VGND VPWR VPWR g_row\[1\].g_col\[1\].pe__1718_/B sky130_fd_sc_hd__xor2_2
XFILLER_59_759 VGND VGND VPWR VPWR sky130_fd_sc_hd__fill_1
Xg_row\[1\].g_col\[1\].pe__1648_ g_row\[1\].g_col\[1\].pe__1648_/A g_row\[1\].g_col\[1\].pe__1648_/B
+ VGND VGND VPWR VPWR g_row\[1\].g_col\[1\].pe__1648_/X sky130_fd_sc_hd__and2_2
Xg_row\[1\].g_col\[0\].pe_hold3082 g_row\[1\].g_col\[0\].pe__2736_/Q VGND VGND VPWR
+ VPWR g_row\[1\].g_col\[0\].pe__1401_/A1 sky130_fd_sc_hd__clkbuf_2
XFILLER_26_111 VGND VGND VPWR VPWR sky130_fd_sc_hd__fill_1
XTAP_TAPCELL_ROW_1_221 VGND VPWR sky130_fd_sc_hd__tapvpwrvgnd_1
XTAP_TAPCELL_ROW_1_232 VGND VPWR sky130_fd_sc_hd__tapvpwrvgnd_1
XTAP_TAPCELL_ROW_68_1232 VGND VPWR sky130_fd_sc_hd__tapvpwrvgnd_1
Xg_row\[1\].g_col\[1\].pe__1579_ g_row\[1\].g_col\[1\].pe__1579_/A g_row\[1\].g_col\[1\].pe__1579_/B
+ VGND VGND VPWR VPWR g_row\[1\].g_col\[1\].pe__1630_/B sky130_fd_sc_hd__xor2_2
XFILLER_54_442 VGND VGND VPWR VPWR sky130_fd_sc_hd__fill_1
Xg_row\[0\].g_col\[0\].pe__2759_ clkbuf_leaf_32_clk/X g_row\[0\].g_col\[0\].pe__2759_/D
+ VGND VGND VPWR VPWR g_row\[0\].g_col\[0\].pe__2759_/Q sky130_fd_sc_hd__dfxtp_2
Xg_row\[0\].g_col\[1\].pe__2775_ g_row\[0\].g_col\[1\].pe__2775_/A VGND VGND VPWR
+ VPWR output1362/A sky130_fd_sc_hd__buf_2
XFILLER_54_486 VGND VGND VPWR VPWR sky130_fd_sc_hd__decap_3
Xg_row\[0\].g_col\[1\].pe__1726_ g_row\[0\].g_col\[1\].pe__1824_/B g_row\[0\].g_col\[1\].pe__1726_/B
+ VGND VGND VPWR VPWR g_row\[0\].g_col\[1\].pe__1747_/A sky130_fd_sc_hd__xnor2_2
XTAP_TAPCELL_ROW_81_1421 VGND VPWR sky130_fd_sc_hd__tapvpwrvgnd_1
XTAP_TAPCELL_ROW_81_1432 VGND VPWR sky130_fd_sc_hd__tapvpwrvgnd_1
Xg_row\[0\].g_col\[1\].pe__1657_ g_row\[0\].g_col\[1\].pe__2599_/B g_row\[0\].g_col\[1\].pe__1657_/B
+ VGND VGND VPWR VPWR g_row\[0\].g_col\[1\].pe__1658_/B sky130_fd_sc_hd__nand2_2
XFILLER_41_169 VGND VGND VPWR VPWR sky130_fd_sc_hd__fill_2
XTAP_TAPCELL_ROW_40_805 VGND VPWR sky130_fd_sc_hd__tapvpwrvgnd_1
XTAP_TAPCELL_ROW_40_816 VGND VPWR sky130_fd_sc_hd__tapvpwrvgnd_1
Xg_row\[0\].g_col\[1\].pe__1588_ g_row\[0\].g_col\[1\].pe__1588_/A g_row\[0\].g_col\[1\].pe__1588_/B
+ VGND VGND VPWR VPWR g_row\[0\].g_col\[1\].pe__1588_/Y sky130_fd_sc_hd__nor2_2
XFILLER_50_681 VGND VGND VPWR VPWR sky130_fd_sc_hd__fill_1
XFILLER_50_692 VGND VGND VPWR VPWR sky130_fd_sc_hd__decap_3
XFILLER_10_589 VGND VGND VPWR VPWR sky130_fd_sc_hd__fill_2
XTAP_TAPCELL_ROW_79_1394 VGND VPWR sky130_fd_sc_hd__tapvpwrvgnd_1
Xg_row\[0\].g_col\[1\].pe__2209_ g_row\[0\].g_col\[1\].pe__2209_/A g_row\[0\].g_col\[1\].pe__2209_/B
+ VGND VGND VPWR VPWR g_row\[0\].g_col\[1\].pe__2210_/B sky130_fd_sc_hd__xnor2_2
XTAP_TAPCELL_ROW_9_343 VGND VPWR sky130_fd_sc_hd__tapvpwrvgnd_1
XFILLER_2_755 VGND VGND VPWR VPWR sky130_fd_sc_hd__fill_1
XTAP_TAPCELL_ROW_92_1583 VGND VPWR sky130_fd_sc_hd__tapvpwrvgnd_1
XTAP_TAPCELL_ROW_92_1594 VGND VPWR sky130_fd_sc_hd__tapvpwrvgnd_1
XFILLER_2_49 VGND VGND VPWR VPWR sky130_fd_sc_hd__fill_2
XFILLER_49_225 VGND VGND VPWR VPWR sky130_fd_sc_hd__fill_2
XFILLER_77_545 VGND VGND VPWR VPWR sky130_fd_sc_hd__fill_2
XFILLER_65_718 VGND VGND VPWR VPWR sky130_fd_sc_hd__fill_2
XTAP_TAPCELL_ROW_48_927 VGND VPWR sky130_fd_sc_hd__tapvpwrvgnd_1
XFILLER_17_111 VGND VGND VPWR VPWR sky130_fd_sc_hd__fill_1
XFILLER_18_634 VGND VGND VPWR VPWR sky130_fd_sc_hd__decap_3
XFILLER_45_431 VGND VGND VPWR VPWR sky130_fd_sc_hd__fill_1
XFILLER_73_740 VGND VGND VPWR VPWR sky130_fd_sc_hd__fill_2
XFILLER_33_626 VGND VGND VPWR VPWR sky130_fd_sc_hd__decap_3
XFILLER_45_486 VGND VGND VPWR VPWR sky130_fd_sc_hd__fill_1
XFILLER_72_250 VGND VGND VPWR VPWR sky130_fd_sc_hd__fill_2
XFILLER_14_840 VGND VGND VPWR VPWR sky130_fd_sc_hd__fill_2
XFILLER_60_489 VGND VGND VPWR VPWR sky130_fd_sc_hd__fill_2
Xg_row\[0\].g_col\[0\].pe_hold1723 g_row\[0\].g_col\[0\].pe__2236_/X VGND VGND VPWR
+ VPWR g_row\[0\].g_col\[0\].pe__2237_/B sky130_fd_sc_hd__clkbuf_2
Xg_row\[1\].g_col\[0\].pe__1983_ hold1986/A VGND VGND VPWR VPWR g_row\[1\].g_col\[0\].pe__1983_/Y
+ sky130_fd_sc_hd__inv_2
Xg_row\[1\].g_col\[0\].pe__2604_ g_row\[1\].g_col\[0\].pe__2640_/A1 g_row\[1\].g_col\[0\].pe__2604_/A2
+ g_row\[1\].g_col\[0\].pe__2640_/C1 g_row\[1\].g_col\[0\].pe__2603_/X VGND VGND VPWR
+ VPWR g_row\[1\].g_col\[0\].pe__2604_/X sky130_fd_sc_hd__o211a_2
Xg_row\[0\].g_col\[0\].pe__1992_ g_row\[0\].g_col\[0\].pe__1991_/A g_row\[0\].g_col\[0\].pe__1991_/B
+ g_row\[0\].g_col\[0\].pe__1991_/C g_row\[0\].g_col\[0\].pe__1991_/D VGND VGND VPWR
+ VPWR g_row\[0\].g_col\[0\].pe__1993_/B sky130_fd_sc_hd__a22o_2
Xg_row\[1\].g_col\[1\].pe__2551_ g_row\[1\].g_col\[1\].pe__2551_/A g_row\[1\].g_col\[1\].pe__2551_/B
+ g_row\[1\].g_col\[1\].pe__2551_/C VGND VGND VPWR VPWR g_row\[1\].g_col\[1\].pe__2551_/Y
+ sky130_fd_sc_hd__nand3_2
Xg_row\[1\].g_col\[0\].pe__2535_ g_row\[1\].g_col\[0\].pe__2535_/A1 g_row\[1\].g_col\[0\].pe__2560_/A2
+ g_row\[1\].g_col\[0\].pe__2560_/B1 g_row\[1\].g_col\[0\].pe__2534_/X VGND VGND VPWR
+ VPWR g_row\[1\].g_col\[0\].pe__2535_/X sky130_fd_sc_hd__a22o_2
Xg_row\[1\].g_col\[1\].pe__2482_ g_row\[1\].g_col\[1\].pe__2494_/A g_row\[1\].g_col\[1\].pe__2482_/B
+ VGND VGND VPWR VPWR g_row\[1\].g_col\[1\].pe__2508_/B sky130_fd_sc_hd__nor2_2
Xg_row\[1\].g_col\[1\].pe__1502_ g_row\[1\].g_col\[1\].pe__2735_/Q g_row\[1\].g_col\[1\].pe__1540_/C
+ VGND VGND VPWR VPWR g_row\[1\].g_col\[1\].pe__1504_/A sky130_fd_sc_hd__and2_2
XFILLER_56_718 VGND VGND VPWR VPWR sky130_fd_sc_hd__fill_2
Xg_row\[1\].g_col\[0\].pe__2466_ g_row\[1\].g_col\[0\].pe__2452_/B g_row\[1\].g_col\[0\].pe__2760_/Q
+ VGND VGND VPWR VPWR g_row\[1\].g_col\[0\].pe__2466_/X sky130_fd_sc_hd__and2b_2
XFILLER_55_228 VGND VGND VPWR VPWR sky130_fd_sc_hd__decap_3
XFILLER_83_548 VGND VGND VPWR VPWR sky130_fd_sc_hd__decap_3
Xg_row\[1\].g_col\[0\].pe__2397_ g_row\[1\].g_col\[0\].pe__2398_/A hold1766/X VGND
+ VGND VPWR VPWR g_row\[1\].g_col\[0\].pe__2397_/Y sky130_fd_sc_hd__nor2_2
Xg_row\[0\].g_col\[0\].pe__2613_ g_row\[0\].g_col\[0\].pe__2628_/A1 g_row\[0\].g_col\[0\].pe__2613_/A2
+ g_row\[0\].g_col\[0\].pe__2628_/B1 g_row\[0\].g_col\[0\].pe__2612_/X VGND VGND VPWR
+ VPWR g_row\[0\].g_col\[0\].pe__2613_/X sky130_fd_sc_hd__o211a_2
Xg_row\[1\].g_col\[1\].pe__1364_ g_row\[1\].g_col\[1\].pe__2768_/Q VGND VGND VPWR
+ VPWR g_row\[1\].g_col\[1\].pe__2478_/A sky130_fd_sc_hd__inv_2
Xg_row\[1\].g_col\[0\].pe__1348_ g_row\[1\].g_col\[0\].pe__2776_/A g_row\[1\].g_col\[0\].pe__1348_/B
+ VGND VGND VPWR VPWR g_row\[1\].g_col\[0\].pe__1349_/B sky130_fd_sc_hd__nand2_2
XFILLER_36_475 VGND VGND VPWR VPWR sky130_fd_sc_hd__fill_1
XFILLER_36_497 VGND VGND VPWR VPWR sky130_fd_sc_hd__decap_3
Xg_row\[0\].g_col\[0\].pe__2544_ g_row\[0\].g_col\[0\].pe__2466_/X g_row\[0\].g_col\[0\].pe__2544_/B
+ VGND VGND VPWR VPWR g_row\[0\].g_col\[0\].pe__2546_/A sky130_fd_sc_hd__and2b_2
Xg_row\[0\].g_col\[1\].pe__2560_ g_row\[0\].g_col\[1\].pe__2560_/A1 g_row\[0\].g_col\[1\].pe__2406_/Y
+ g_row\[0\].g_col\[1\].pe__2591_/B1 g_row\[0\].g_col\[1\].pe__2559_/X VGND VGND VPWR
+ VPWR g_row\[0\].g_col\[1\].pe__2560_/X sky130_fd_sc_hd__a22o_2
XFILLER_23_136 VGND VGND VPWR VPWR sky130_fd_sc_hd__decap_3
Xg_row\[0\].g_col\[1\].pe__1511_ g_row\[0\].g_col\[1\].pe__1640_/A g_row\[0\].g_col\[1\].pe__1640_/B
+ g_row\[0\].g_col\[1\].pe__1510_/X VGND VGND VPWR VPWR g_row\[0\].g_col\[1\].pe__1550_/A
+ sky130_fd_sc_hd__a21oi_2
Xg_row\[0\].g_col\[1\].pe__2491_ g_row\[0\].g_col\[1\].pe__2491_/A g_row\[0\].g_col\[1\].pe__2491_/B
+ g_row\[0\].g_col\[1\].pe__2505_/A VGND VGND VPWR VPWR g_row\[0\].g_col\[1\].pe__2492_/B
+ sky130_fd_sc_hd__or3_2
XFILLER_23_158 VGND VGND VPWR VPWR sky130_fd_sc_hd__fill_1
XFILLER_23_169 VGND VGND VPWR VPWR sky130_fd_sc_hd__decap_3
XFILLER_51_478 VGND VGND VPWR VPWR sky130_fd_sc_hd__decap_3
XTAP_TAPCELL_ROW_63_1151 VGND VPWR sky130_fd_sc_hd__tapvpwrvgnd_1
XTAP_TAPCELL_ROW_63_1162 VGND VPWR sky130_fd_sc_hd__tapvpwrvgnd_1
Xg_row\[0\].g_col\[0\].pe__2475_ g_row\[0\].g_col\[0\].pe__2489_/B g_row\[0\].g_col\[0\].pe__2492_/A
+ g_row\[0\].g_col\[0\].pe__2474_/Y VGND VGND VPWR VPWR g_row\[0\].g_col\[0\].pe__2490_/A
+ sky130_fd_sc_hd__a21boi_2
Xg_row\[0\].g_col\[1\].pe__1442_ g_row\[0\].g_col\[1\].pe__1442_/A g_row\[0\].g_col\[1\].pe__1442_/B
+ VGND VGND VPWR VPWR g_row\[0\].g_col\[1\].pe__1479_/B sky130_fd_sc_hd__xnor2_2
Xg_row\[0\].g_col\[0\].pe__1426_ place1209/X g_row\[0\].g_col\[0\].pe__1732_/A2 g_row\[0\].g_col\[0\].pe__1732_/B1
+ g_row\[0\].g_col\[0\].pe__1866_/B2 VGND VGND VPWR VPWR g_row\[0\].g_col\[0\].pe__1427_/B
+ sky130_fd_sc_hd__a22o_2
XFILLER_31_191 VGND VGND VPWR VPWR sky130_fd_sc_hd__decap_3
XPHY_EDGE_ROW_12_Left_106 VGND VGND VPWR VPWR sky130_fd_sc_hd__decap_3
Xg_row\[0\].g_col\[0\].pe__1357_ g_row\[0\].g_col\[0\].pe__2764_/Q g_row\[0\].g_col\[0\].pe__1357_/B
+ VGND VGND VPWR VPWR output1417/A sky130_fd_sc_hd__xor2_2
XFILLER_78_309 VGND VGND VPWR VPWR sky130_fd_sc_hd__fill_2
XTAP_TAPCELL_ROW_6_302 VGND VPWR sky130_fd_sc_hd__tapvpwrvgnd_1
Xg_row\[1\].g_col\[1\].pe__2749_ clkbuf_leaf_77_clk/X g_row\[1\].g_col\[1\].pe__2749_/D
+ VGND VGND VPWR VPWR g_row\[1\].g_col\[1\].pe__2749_/Q sky130_fd_sc_hd__dfxtp_2
XPHY_EDGE_ROW_21_Left_115 VGND VGND VPWR VPWR sky130_fd_sc_hd__decap_3
Xg_row\[0\].g_col\[1\].pe__2758_ _278_/CLK g_row\[0\].g_col\[1\].pe__2758_/D VGND
+ VGND VPWR VPWR g_row\[0\].g_col\[1\].pe__2758_/Q sky130_fd_sc_hd__dfxtp_2
XFILLER_14_136 VGND VGND VPWR VPWR sky130_fd_sc_hd__decap_3
Xg_row\[0\].g_col\[1\].pe__1709_ g_row\[0\].g_col\[1\].pe__1709_/A g_row\[0\].g_col\[1\].pe__1709_/B
+ VGND VGND VPWR VPWR g_row\[0\].g_col\[1\].pe__1736_/A sky130_fd_sc_hd__xor2_2
Xg_row\[0\].g_col\[1\].pe_hold1853 g_row\[0\].g_col\[1\].pe__2548_/X VGND VGND VPWR
+ VPWR g_row\[0\].g_col\[1\].pe__2549_/B sky130_fd_sc_hd__clkbuf_2
XPHY_EDGE_ROW_30_Left_124 VGND VGND VPWR VPWR sky130_fd_sc_hd__decap_3
X_311_ _314_/CLK _311_/D VGND VGND VPWR VPWR _311_/Q sky130_fd_sc_hd__dfxtp_2
Xg_row\[0\].g_col\[1\].pe__2689_ g_row\[0\].g_col\[1\].pe__2689_/A g_row\[0\].g_col\[1\].pe__2724_/Q
+ g_row\[0\].g_col\[1\].pe__2689_/CIN VGND VGND VPWR VPWR g_row\[0\].g_col\[1\].pe__1727_/B2
+ g_row\[0\].g_col\[1\].pe__2689_/SUM sky130_fd_sc_hd__fa_1
XFILLER_22_191 VGND VGND VPWR VPWR sky130_fd_sc_hd__decap_3
X_173_ _173_/A _173_/B_N VGND VGND VPWR VPWR _173_/Y sky130_fd_sc_hd__nor2b_4
XFILLER_2_530 VGND VGND VPWR VPWR sky130_fd_sc_hd__fill_2
XFILLER_77_342 VGND VGND VPWR VPWR sky130_fd_sc_hd__fill_1
Xg_row\[1\].g_col\[0\].pe__2320_ g_row\[1\].g_col\[0\].pe__2321_/A g_row\[1\].g_col\[0\].pe__2348_/B
+ VGND VGND VPWR VPWR g_row\[1\].g_col\[0\].pe__2337_/B sky130_fd_sc_hd__nor2_2
Xg_row\[1\].g_col\[0\].pe__2251_ g_row\[1\].g_col\[0\].pe__2283_/A g_row\[1\].g_col\[0\].pe__2251_/B
+ VGND VGND VPWR VPWR g_row\[1\].g_col\[0\].pe__2273_/B sky130_fd_sc_hd__and2_2
XFILLER_18_475 VGND VGND VPWR VPWR sky130_fd_sc_hd__fill_1
XFILLER_52_209 VGND VGND VPWR VPWR sky130_fd_sc_hd__fill_2
Xg_row\[1\].g_col\[0\].pe__2182_ g_row\[1\].g_col\[0\].pe__2182_/A g_row\[1\].g_col\[0\].pe__2182_/B
+ VGND VGND VPWR VPWR g_row\[1\].g_col\[0\].pe__2183_/B sky130_fd_sc_hd__xor2_2
Xg_row\[0\].g_col\[0\].pe__2260_ g_row\[0\].g_col\[0\].pe__2330_/A g_row\[0\].g_col\[0\].pe__2330_/B
+ VGND VGND VPWR VPWR g_row\[0\].g_col\[0\].pe__2262_/B sky130_fd_sc_hd__xnor2_2
Xg_row\[0\].g_col\[0\].pe_hold2254 g_row\[0\].g_col\[0\].pe_hold2271/X VGND VGND VPWR
+ VPWR g_row\[0\].g_col\[0\].pe__2681_/A1 sky130_fd_sc_hd__clkbuf_2
Xg_row\[0\].g_col\[0\].pe_hold2265 g_row\[0\].g_col\[0\].pe__2755_/Q VGND VGND VPWR
+ VPWR g_row\[0\].g_col\[0\].pe_hold2265/X sky130_fd_sc_hd__clkbuf_2
Xg_row\[0\].g_col\[0\].pe_hold2276 _312_/Q VGND VGND VPWR VPWR g_row\[0\].g_col\[0\].pe_hold2276/X
+ sky130_fd_sc_hd__clkbuf_2
Xg_row\[0\].g_col\[1\].pe_place824 g_row\[0\].g_col\[1\].pe__2590_/A VGND VGND VPWR
+ VPWR g_row\[0\].g_col\[1\].pe__2559_/A sky130_fd_sc_hd__buf_6
XTAP_TAPCELL_ROW_31_668 VGND VPWR sky130_fd_sc_hd__tapvpwrvgnd_1
Xg_row\[0\].g_col\[0\].pe__2191_ g_row\[0\].g_col\[0\].pe__2191_/A g_row\[0\].g_col\[0\].pe__2228_/B
+ VGND VGND VPWR VPWR g_row\[0\].g_col\[0\].pe__2202_/A sky130_fd_sc_hd__or2_4
Xg_row\[0\].g_col\[0\].pe_hold2287 g_row\[0\].g_col\[0\].pe__1386_/X VGND VGND VPWR
+ VPWR g_row\[0\].g_col\[0\].pe__2729_/D sky130_fd_sc_hd__clkbuf_2
Xg_row\[0\].g_col\[0\].pe_hold2298 g_row\[0\].g_col\[0\].pe_hold2875/X VGND VGND VPWR
+ VPWR g_row\[0\].g_col\[0\].pe_hold2876/A sky130_fd_sc_hd__clkbuf_2
Xg_row\[0\].g_col\[1\].pe_place857 g_row\[0\].g_col\[1\].pe__1504_/Y VGND VGND VPWR
+ VPWR g_row\[0\].g_col\[1\].pe__1549_/B sky130_fd_sc_hd__buf_6
XTAP_TAPCELL_ROW_31_679 VGND VPWR sky130_fd_sc_hd__tapvpwrvgnd_1
XTAP_TAPCELL_ROW_11_370 VGND VPWR sky130_fd_sc_hd__tapvpwrvgnd_1
XTAP_TAPCELL_ROW_11_381 VGND VPWR sky130_fd_sc_hd__tapvpwrvgnd_1
Xg_row\[1\].g_col\[1\].pe__1982_ g_row\[1\].g_col\[1\].pe__2163_/A g_row\[1\].g_col\[1\].pe__1982_/B
+ VGND VGND VPWR VPWR g_row\[1\].g_col\[1\].pe__1985_/B sky130_fd_sc_hd__nand2_2
Xg_row\[1\].g_col\[0\].pe__1966_ hold1938/A VGND VGND VPWR VPWR g_row\[1\].g_col\[0\].pe__1966_/Y
+ sky130_fd_sc_hd__inv_2
Xhold3406 hold3406/A VGND VGND VPWR VPWR hold3406/X sky130_fd_sc_hd__clkbuf_2
Xg_row\[1\].g_col\[0\].pe__1897_ g_row\[1\].g_col\[0\].pe__1886_/A g_row\[1\].g_col\[0\].pe__1897_/B
+ VGND VGND VPWR VPWR g_row\[1\].g_col\[0\].pe__1941_/B sky130_fd_sc_hd__nand2b_2
Xhold2705 hold3493/X VGND VGND VPWR VPWR _233_/B_N sky130_fd_sc_hd__clkbuf_2
Xoutput1367 output1367/A VGND VGND VPWR VPWR results_flat[20] sky130_fd_sc_hd__buf_2
Xoutput1356 output1356/A VGND VGND VPWR VPWR results_flat[10] sky130_fd_sc_hd__buf_2
Xhold3439 hold3439/A VGND VGND VPWR VPWR hold3439/X sky130_fd_sc_hd__clkbuf_2
Xhold3428 hold3428/A VGND VGND VPWR VPWR hold3428/X sky130_fd_sc_hd__clkbuf_2
Xhold3417 b_inputs_flat[2] VGND VGND VPWR VPWR hold3417/X sky130_fd_sc_hd__clkbuf_2
Xg_row\[1\].g_col\[1\].pe__2603_ place1248/X g_row\[1\].g_col\[1\].pe__2603_/B VGND
+ VGND VPWR VPWR g_row\[1\].g_col\[1\].pe__2603_/X sky130_fd_sc_hd__or2_2
Xhold2716 hold3470/X VGND VGND VPWR VPWR hold3471/A sky130_fd_sc_hd__clkbuf_2
Xhold2727 hold3531/X VGND VGND VPWR VPWR hold3532/A sky130_fd_sc_hd__clkbuf_2
Xhold2738 hold3501/X VGND VGND VPWR VPWR hold3502/A sky130_fd_sc_hd__clkbuf_2
Xoutput1389 output1389/A VGND VGND VPWR VPWR results_flat[40] sky130_fd_sc_hd__buf_2
Xoutput1378 output1378/A VGND VGND VPWR VPWR results_flat[30] sky130_fd_sc_hd__buf_2
Xg_row\[0\].g_col\[0\].pe__1975_ g_row\[0\].g_col\[0\].pe__1974_/A g_row\[0\].g_col\[0\].pe__1974_/B
+ g_row\[0\].g_col\[0\].pe__1974_/C g_row\[0\].g_col\[0\].pe__1974_/D VGND VGND VPWR
+ VPWR g_row\[0\].g_col\[0\].pe__1978_/B sky130_fd_sc_hd__a22oi_2
Xhold2749 hold2749/A VGND VGND VPWR VPWR _304_/D sky130_fd_sc_hd__clkbuf_2
Xg_row\[1\].g_col\[1\].pe__2534_ g_row\[1\].g_col\[1\].pe__2559_/A g_row\[1\].g_col\[1\].pe__2534_/B
+ g_row\[1\].g_col\[1\].pe__2534_/C VGND VGND VPWR VPWR g_row\[1\].g_col\[1\].pe__2534_/X
+ sky130_fd_sc_hd__or3_2
Xg_row\[0\].g_col\[1\].pe__1991_ g_row\[0\].g_col\[1\].pe__1991_/A g_row\[0\].g_col\[1\].pe__1991_/B
+ g_row\[0\].g_col\[1\].pe__1991_/C g_row\[0\].g_col\[1\].pe__1991_/D VGND VGND VPWR
+ VPWR g_row\[0\].g_col\[1\].pe__1991_/X sky130_fd_sc_hd__and4_4
XFILLER_28_239 VGND VGND VPWR VPWR sky130_fd_sc_hd__decap_3
Xg_row\[1\].g_col\[1\].pe__2465_ g_row\[1\].g_col\[1\].pe__2526_/A g_row\[1\].g_col\[1\].pe__2526_/B
+ g_row\[1\].g_col\[1\].pe__2464_/X g_row\[1\].g_col\[1\].pe__2458_/A VGND VGND VPWR
+ VPWR g_row\[1\].g_col\[1\].pe__2538_/C sky130_fd_sc_hd__a211o_2
Xg_row\[1\].g_col\[0\].pe__2449_ g_row\[1\].g_col\[0\].pe__2741_/Q g_row\[1\].g_col\[0\].pe__2455_/B
+ g_row\[1\].g_col\[0\].pe__2399_/Y VGND VGND VPWR VPWR g_row\[1\].g_col\[0\].pe__2453_/B
+ sky130_fd_sc_hd__o21a_2
Xg_row\[1\].g_col\[1\].pe__2396_ g_row\[1\].g_col\[1\].pe__2396_/A g_row\[1\].g_col\[1\].pe__2396_/B
+ VGND VGND VPWR VPWR g_row\[1\].g_col\[1\].pe__2753_/D sky130_fd_sc_hd__nor2_8
Xg_row\[1\].g_col\[1\].pe__1416_ g_row\[1\].g_col\[1\].pe__2725_/Q g_row\[1\].g_col\[1\].pe__1928_/A
+ VGND VGND VPWR VPWR g_row\[1\].g_col\[1\].pe__1801_/B sky130_fd_sc_hd__xor2_2
Xg_row\[0\].g_col\[1\].pe__2612_ g_row\[0\].g_col\[1\].pe__2663_/A g_row\[0\].g_col\[1\].pe__2612_/B
+ VGND VGND VPWR VPWR g_row\[0\].g_col\[1\].pe__2612_/X sky130_fd_sc_hd__or2_2
XTAP_TAPCELL_ROW_19_492 VGND VPWR sky130_fd_sc_hd__tapvpwrvgnd_1
Xg_row\[1\].g_col\[1\].pe__1347_ g_row\[1\].g_col\[1\].pe__2759_/Q g_row\[1\].g_col\[1\].pe__2758_/Q
+ g_row\[1\].g_col\[1\].pe__2757_/Q g_row\[1\].g_col\[1\].pe__2775_/A VGND VGND VPWR
+ VPWR g_row\[1\].g_col\[1\].pe__1348_/B sky130_fd_sc_hd__or4_2
XFILLER_12_607 VGND VGND VPWR VPWR sky130_fd_sc_hd__fill_1
XFILLER_24_456 VGND VGND VPWR VPWR sky130_fd_sc_hd__decap_3
XFILLER_51_264 VGND VGND VPWR VPWR sky130_fd_sc_hd__fill_1
Xg_row\[0\].g_col\[0\].pe__2527_ g_row\[0\].g_col\[0\].pe__2525_/Y g_row\[0\].g_col\[0\].pe__2526_/X
+ g_row\[0\].g_col\[0\].pe__2559_/A VGND VGND VPWR VPWR g_row\[0\].g_col\[0\].pe__2527_/X
+ sky130_fd_sc_hd__a21o_2
XFILLER_51_286 VGND VGND VPWR VPWR sky130_fd_sc_hd__decap_3
Xg_row\[0\].g_col\[0\].pe__2458_ g_row\[0\].g_col\[0\].pe__2458_/A g_row\[0\].g_col\[0\].pe__2458_/B
+ VGND VGND VPWR VPWR g_row\[0\].g_col\[0\].pe__2526_/A sky130_fd_sc_hd__nor2_2
Xg_row\[0\].g_col\[1\].pe__2474_ g_row\[0\].g_col\[1\].pe__2766_/Q g_row\[0\].g_col\[1\].pe__2474_/B
+ VGND VGND VPWR VPWR g_row\[0\].g_col\[1\].pe__2474_/Y sky130_fd_sc_hd__xnor2_2
XTAP_TAPCELL_ROW_50_955 VGND VPWR sky130_fd_sc_hd__tapvpwrvgnd_1
XTAP_TAPCELL_ROW_50_966 VGND VPWR sky130_fd_sc_hd__tapvpwrvgnd_1
Xg_row\[0\].g_col\[0\].pe__2389_ g_row\[0\].g_col\[0\].pe__2364_/A g_row\[0\].g_col\[0\].pe__2364_/B
+ g_row\[0\].g_col\[0\].pe__2366_/X VGND VGND VPWR VPWR g_row\[0\].g_col\[0\].pe__2390_/B
+ sky130_fd_sc_hd__o21a_2
Xg_row\[0\].g_col\[1\].pe__1356_ g_row\[0\].g_col\[1\].pe__2763_/Q g_row\[0\].g_col\[1\].pe__1355_/B
+ g_row\[0\].g_col\[1\].pe__2771_/Q VGND VGND VPWR VPWR g_row\[0\].g_col\[1\].pe__1357_/B
+ sky130_fd_sc_hd__o21a_2
XTAP_TAPCELL_ROW_76_1353 VGND VPWR sky130_fd_sc_hd__tapvpwrvgnd_1
XFILLER_87_640 VGND VGND VPWR VPWR sky130_fd_sc_hd__decap_3
XFILLER_47_32 VGND VGND VPWR VPWR sky130_fd_sc_hd__fill_2
XFILLER_55_570 VGND VGND VPWR VPWR sky130_fd_sc_hd__fill_2
Xg_row\[0\].g_col\[1\].pe_hold2362 g_row\[0\].g_col\[1\].pe__1399_/X VGND VGND VPWR
+ VPWR g_row\[0\].g_col\[1\].pe__2735_/D sky130_fd_sc_hd__clkbuf_2
Xg_row\[0\].g_col\[1\].pe_hold2351 g_row\[0\].g_col\[1\].pe__2608_/X VGND VGND VPWR
+ VPWR g_row\[0\].g_col\[1\].pe__2693_/D sky130_fd_sc_hd__clkbuf_2
XFILLER_15_445 VGND VGND VPWR VPWR sky130_fd_sc_hd__decap_3
Xg_row\[0\].g_col\[1\].pe_hold2395 g_row\[0\].g_col\[1\].pe__2422_/A VGND VGND VPWR
+ VPWR g_row\[0\].g_col\[1\].pe__2395_/A2 sky130_fd_sc_hd__clkbuf_2
Xg_row\[0\].g_col\[1\].pe_hold2384 g_row\[0\].g_col\[1\].pe__2404_/X VGND VGND VPWR
+ VPWR g_row\[0\].g_col\[1\].pe__2405_/B sky130_fd_sc_hd__clkbuf_2
Xg_row\[0\].g_col\[1\].pe_hold2373 g_row\[0\].g_col\[1\].pe__2432_/A VGND VGND VPWR
+ VPWR g_row\[0\].g_col\[1\].pe__2306_/A2 sky130_fd_sc_hd__clkbuf_2
XFILLER_42_253 VGND VGND VPWR VPWR sky130_fd_sc_hd__fill_1
XPHY_EDGE_ROW_69_Right_69 VGND VGND VPWR VPWR sky130_fd_sc_hd__decap_3
XFILLER_42_286 VGND VGND VPWR VPWR sky130_fd_sc_hd__decap_3
XFILLER_11_651 VGND VGND VPWR VPWR sky130_fd_sc_hd__decap_3
XFILLER_8_26 VGND VGND VPWR VPWR sky130_fd_sc_hd__fill_2
X_225_ _235_/A _225_/B_N VGND VGND VPWR VPWR _225_/Y sky130_fd_sc_hd__nor2b_4
XFILLER_10_172 VGND VGND VPWR VPWR sky130_fd_sc_hd__fill_2
Xg_row\[1\].g_col\[0\].pe__1820_ g_row\[1\].g_col\[0\].pe__1820_/A g_row\[1\].g_col\[0\].pe__1820_/B
+ VGND VGND VPWR VPWR g_row\[1\].g_col\[0\].pe__1821_/D sky130_fd_sc_hd__nor2_2
XFILLER_6_154 VGND VGND VPWR VPWR sky130_fd_sc_hd__decap_3
Xg_row\[1\].g_col\[0\].pe__1751_ place1102/X g_row\[1\].g_col\[0\].pe__1414_/X g_row\[1\].g_col\[0\].pe__1415_/Y
+ g_row\[1\].g_col\[0\].pe__1416_/X place1100/A VGND VGND VPWR VPWR g_row\[1\].g_col\[0\].pe__1752_/B
+ sky130_fd_sc_hd__a32o_2
XPHY_EDGE_ROW_78_Right_78 VGND VGND VPWR VPWR sky130_fd_sc_hd__decap_3
Xg_row\[1\].g_col\[0\].pe__1682_ g_row\[1\].g_col\[0\].pe__1730_/A g_row\[1\].g_col\[0\].pe__1682_/B
+ VGND VGND VPWR VPWR g_row\[1\].g_col\[0\].pe__1686_/B sky130_fd_sc_hd__xor2_2
Xg_row\[1\].g_col\[0\].pe_hold2914 g_row\[1\].g_col\[0\].pe_hold2914/A VGND VGND VPWR
+ VPWR g_row\[1\].g_col\[0\].pe__2613_/A2 sky130_fd_sc_hd__clkbuf_2
Xg_row\[1\].g_col\[0\].pe_hold2903 g_row\[1\].g_col\[0\].pe_hold2903/A VGND VGND VPWR
+ VPWR g_row\[1\].g_col\[0\].pe__2606_/A2 sky130_fd_sc_hd__clkbuf_2
Xg_row\[1\].g_col\[0\].pe_hold2958 g_row\[1\].g_col\[0\].pe_hold2958/A VGND VGND VPWR
+ VPWR g_row\[1\].g_col\[0\].pe__2617_/A2 sky130_fd_sc_hd__clkbuf_2
Xg_row\[1\].g_col\[0\].pe_hold2947 g_row\[1\].g_col\[0\].pe_hold2947/A VGND VGND VPWR
+ VPWR g_row\[1\].g_col\[0\].pe__2619_/A2 sky130_fd_sc_hd__clkbuf_2
Xg_row\[1\].g_col\[0\].pe_hold2925 _304_/Q VGND VGND VPWR VPWR g_row\[1\].g_col\[0\].pe_hold2925/X
+ sky130_fd_sc_hd__clkbuf_2
XFILLER_93_621 VGND VGND VPWR VPWR sky130_fd_sc_hd__fill_2
Xg_row\[0\].g_col\[0\].pe__1760_ g_row\[0\].g_col\[0\].pe__1816_/B g_row\[0\].g_col\[0\].pe__1760_/B
+ VGND VGND VPWR VPWR g_row\[0\].g_col\[0\].pe__1780_/A sky130_fd_sc_hd__xnor2_2
Xg_row\[1\].g_col\[0\].pe__2303_ g_row\[1\].g_col\[0\].pe__2233_/C g_row\[1\].g_col\[0\].pe__2299_/B
+ g_row\[1\].g_col\[0\].pe__2302_/Y VGND VGND VPWR VPWR g_row\[1\].g_col\[0\].pe__2304_/C
+ sky130_fd_sc_hd__o21a_2
XFILLER_19_751 VGND VGND VPWR VPWR sky130_fd_sc_hd__decap_3
Xg_row\[1\].g_col\[1\].pe__2250_ g_row\[1\].g_col\[1\].pe__2250_/A g_row\[1\].g_col\[1\].pe__2250_/B
+ VGND VGND VPWR VPWR g_row\[1\].g_col\[1\].pe__2251_/B sky130_fd_sc_hd__nand2_2
XFILLER_93_698 VGND VGND VPWR VPWR sky130_fd_sc_hd__fill_2
Xg_row\[0\].g_col\[0\].pe__1691_ g_row\[0\].g_col\[0\].pe__1721_/A g_row\[0\].g_col\[0\].pe__1721_/B
+ VGND VGND VPWR VPWR g_row\[0\].g_col\[0\].pe__1691_/Y sky130_fd_sc_hd__nor2_2
Xg_row\[1\].g_col\[0\].pe__2234_ g_row\[1\].g_col\[0\].pe__2233_/A g_row\[1\].g_col\[0\].pe__2233_/C
+ g_row\[1\].g_col\[0\].pe__2298_/A VGND VGND VPWR VPWR g_row\[1\].g_col\[0\].pe__2234_/Y
+ sky130_fd_sc_hd__a21oi_2
XFILLER_46_592 VGND VGND VPWR VPWR sky130_fd_sc_hd__fill_1
XFILLER_92_197 VGND VGND VPWR VPWR sky130_fd_sc_hd__fill_2
XPHY_EDGE_ROW_87_Right_87 VGND VGND VPWR VPWR sky130_fd_sc_hd__decap_3
XTAP_TAPCELL_ROW_36_749 VGND VPWR sky130_fd_sc_hd__tapvpwrvgnd_1
Xg_row\[1\].g_col\[1\].pe__2181_ g_row\[1\].g_col\[1\].pe__2181_/A g_row\[1\].g_col\[1\].pe__2181_/B
+ VGND VGND VPWR VPWR g_row\[1\].g_col\[1\].pe__2182_/B sky130_fd_sc_hd__xor2_2
Xg_row\[1\].g_col\[0\].pe__2165_ g_row\[1\].g_col\[0\].pe__2165_/A g_row\[1\].g_col\[0\].pe__2165_/B
+ g_row\[1\].g_col\[0\].pe__2165_/C VGND VGND VPWR VPWR g_row\[1\].g_col\[0\].pe__2167_/B
+ sky130_fd_sc_hd__nand3_2
XTAP_TAPCELL_ROW_16_451 VGND VPWR sky130_fd_sc_hd__tapvpwrvgnd_1
XFILLER_21_437 VGND VGND VPWR VPWR sky130_fd_sc_hd__fill_2
XTAP_TAPCELL_ROW_60_1110 VGND VPWR sky130_fd_sc_hd__tapvpwrvgnd_1
Xg_row\[0\].g_col\[0\].pe__2312_ g_row\[0\].g_col\[0\].pe__2083_/A g_row\[0\].g_col\[0\].pe__2363_/A2
+ g_row\[0\].g_col\[0\].pe__2388_/B g_row\[0\].g_col\[0\].pe__2030_/A VGND VGND VPWR
+ VPWR g_row\[0\].g_col\[0\].pe__2316_/A sky130_fd_sc_hd__a22o_2
Xg_row\[1\].g_col\[0\].pe__2096_ g_row\[1\].g_col\[0\].pe__2097_/B g_row\[1\].g_col\[0\].pe__2097_/C
+ g_row\[1\].g_col\[0\].pe__2097_/A VGND VGND VPWR VPWR g_row\[1\].g_col\[0\].pe__2099_/A
+ sky130_fd_sc_hd__o21ai_2
Xg_row\[0\].g_col\[0\].pe__2243_ g_row\[0\].g_col\[0\].pe__2364_/A g_row\[0\].g_col\[0\].pe__2243_/B
+ VGND VGND VPWR VPWR g_row\[0\].g_col\[0\].pe__2277_/B sky130_fd_sc_hd__xnor2_2
Xg_row\[0\].g_col\[0\].pe_hold2095 g_row\[0\].g_col\[0\].pe__2765_/Q VGND VGND VPWR
+ VPWR g_row\[0\].g_col\[0\].pe__2568_/A1 sky130_fd_sc_hd__clkbuf_2
Xg_row\[0\].g_col\[1\].pe__2190_ g_row\[0\].g_col\[1\].pe__2190_/A g_row\[0\].g_col\[1\].pe__2190_/B
+ VGND VGND VPWR VPWR g_row\[0\].g_col\[1\].pe__2228_/B sky130_fd_sc_hd__nor2_2
Xg_row\[0\].g_col\[0\].pe__2174_ g_row\[0\].g_col\[0\].pe__2174_/A g_row\[0\].g_col\[0\].pe__2174_/B
+ VGND VGND VPWR VPWR g_row\[0\].g_col\[0\].pe__2182_/A sky130_fd_sc_hd__nand2_2
Xg_row\[1\].g_col\[1\].pe__1965_ g_row\[1\].g_col\[1\].pe__2083_/A g_row\[1\].g_col\[1\].pe__2026_/B
+ VGND VGND VPWR VPWR g_row\[1\].g_col\[1\].pe__1968_/B sky130_fd_sc_hd__nand2_2
Xg_row\[1\].g_col\[1\].pe_hold1809 g_row\[1\].g_col\[1\].pe__2560_/X VGND VGND VPWR
+ VPWR g_row\[1\].g_col\[1\].pe__2561_/B sky130_fd_sc_hd__clkbuf_2
XTAP_TAPCELL_ROW_58_1083 VGND VPWR sky130_fd_sc_hd__tapvpwrvgnd_1
Xhold3203 hold3203/A VGND VGND VPWR VPWR hold3203/X sky130_fd_sc_hd__clkbuf_2
Xhold3214 b_inputs_flat[7] VGND VGND VPWR VPWR hold3214/X sky130_fd_sc_hd__clkbuf_2
Xg_row\[1\].g_col\[1\].pe__1896_ g_row\[1\].g_col\[1\].pe__1896_/A g_row\[1\].g_col\[1\].pe__1885_/A
+ VGND VGND VPWR VPWR g_row\[1\].g_col\[1\].pe__1941_/A sky130_fd_sc_hd__or2b_2
Xhold2502 _159_/Y VGND VGND VPWR VPWR hold2502/X sky130_fd_sc_hd__clkbuf_2
Xhold2513 hold3304/X VGND VGND VPWR VPWR _213_/B_N sky130_fd_sc_hd__clkbuf_2
Xhold3225 hold3225/A VGND VGND VPWR VPWR hold3225/X sky130_fd_sc_hd__clkbuf_2
Xhold3236 hold3236/A VGND VGND VPWR VPWR hold3236/X sky130_fd_sc_hd__clkbuf_2
Xhold3247 hold3247/A VGND VGND VPWR VPWR hold3247/X sky130_fd_sc_hd__clkbuf_2
Xhold3258 hold3258/A VGND VGND VPWR VPWR hold3258/X sky130_fd_sc_hd__clkbuf_2
XTAP_TAPCELL_ROW_71_1272 VGND VPWR sky130_fd_sc_hd__tapvpwrvgnd_1
Xhold2524 hold3295/X VGND VGND VPWR VPWR hold3296/A sky130_fd_sc_hd__clkbuf_2
Xhold2535 hold3258/X VGND VGND VPWR VPWR hold3259/A sky130_fd_sc_hd__clkbuf_2
Xhold2546 hold3270/X VGND VGND VPWR VPWR hold3271/A sky130_fd_sc_hd__clkbuf_2
Xhold3269 hold3269/A VGND VGND VPWR VPWR hold3269/X sky130_fd_sc_hd__clkbuf_2
XFILLER_29_537 VGND VGND VPWR VPWR sky130_fd_sc_hd__fill_1
XFILLER_56_312 VGND VGND VPWR VPWR sky130_fd_sc_hd__fill_1
Xg_row\[0\].g_col\[0\].pe__1958_ place1210/A g_row\[0\].g_col\[0\].pe__2279_/A2 g_row\[0\].g_col\[0\].pe__2279_/B1
+ place1212/A VGND VGND VPWR VPWR g_row\[0\].g_col\[0\].pe__1959_/B sky130_fd_sc_hd__a22o_2
Xhold2557 hold2557/A VGND VGND VPWR VPWR _326_/D sky130_fd_sc_hd__clkbuf_2
Xhold2568 _263_/Y VGND VGND VPWR VPWR hold2568/X sky130_fd_sc_hd__clkbuf_2
Xhold2579 hold3311/X VGND VGND VPWR VPWR _163_/B_N sky130_fd_sc_hd__clkbuf_2
Xg_row\[1\].g_col\[1\].pe__2517_ g_row\[1\].g_col\[1\].pe__2510_/X g_row\[1\].g_col\[1\].pe__2516_/X
+ g_row\[1\].g_col\[1\].pe__2403_/Y g_row\[1\].g_col\[1\].pe__2010_/A VGND VGND VPWR
+ VPWR g_row\[1\].g_col\[1\].pe__2517_/Y sky130_fd_sc_hd__a211oi_2
Xg_row\[0\].g_col\[1\].pe__1974_ g_row\[0\].g_col\[1\].pe__1974_/A g_row\[0\].g_col\[1\].pe__1974_/B
+ g_row\[0\].g_col\[1\].pe__1974_/C g_row\[0\].g_col\[1\].pe__1974_/D VGND VGND VPWR
+ VPWR g_row\[0\].g_col\[1\].pe__1978_/A sky130_fd_sc_hd__and4_4
XFILLER_71_315 VGND VGND VPWR VPWR sky130_fd_sc_hd__fill_1
Xg_row\[0\].g_col\[0\].pe__1889_ g_row\[0\].g_col\[0\].pe__1951_/A g_row\[0\].g_col\[0\].pe__1889_/B
+ VGND VGND VPWR VPWR g_row\[0\].g_col\[0\].pe__1894_/B sky130_fd_sc_hd__nor2_2
Xhold1889 hold3035/X VGND VGND VPWR VPWR hold1889/X sky130_fd_sc_hd__clkbuf_2
Xg_row\[1\].g_col\[1\].pe__2448_ g_row\[1\].g_col\[1\].pe__2743_/Q VGND VGND VPWR
+ VPWR g_row\[1\].g_col\[1\].pe__2451_/A sky130_fd_sc_hd__inv_2
XFILLER_17_57 VGND VGND VPWR VPWR sky130_fd_sc_hd__decap_3
XFILLER_71_337 VGND VGND VPWR VPWR sky130_fd_sc_hd__decap_3
Xg_row\[1\].g_col\[1\].pe__2379_ g_row\[1\].g_col\[1\].pe__2356_/A g_row\[1\].g_col\[1\].pe__2375_/B
+ g_row\[1\].g_col\[1\].pe__2394_/B1 VGND VGND VPWR VPWR g_row\[1\].g_col\[1\].pe__2379_/Y
+ sky130_fd_sc_hd__a21oi_2
XFILLER_24_253 VGND VGND VPWR VPWR sky130_fd_sc_hd__fill_2
XFILLER_52_584 VGND VGND VPWR VPWR sky130_fd_sc_hd__decap_3
Xg_row\[0\].g_col\[1\].pe__2526_ g_row\[0\].g_col\[1\].pe__2526_/A g_row\[0\].g_col\[1\].pe__2526_/B
+ VGND VGND VPWR VPWR g_row\[0\].g_col\[1\].pe__2526_/X sky130_fd_sc_hd__or2_2
Xg_row\[0\].g_col\[1\].pe__2457_ g_row\[0\].g_col\[1\].pe__2758_/Q g_row\[0\].g_col\[1\].pe__2457_/B
+ VGND VGND VPWR VPWR g_row\[0\].g_col\[1\].pe__2458_/B sky130_fd_sc_hd__and2b_2
Xg_row\[0\].g_col\[1\].pe__1408_ g_row\[0\].g_col\[1\].pe__2405_/A g_row\[0\].g_col\[1\].pe__1408_/B
+ VGND VGND VPWR VPWR g_row\[0\].g_col\[1\].pe__2738_/D sky130_fd_sc_hd__nor2_2
Xg_row\[0\].g_col\[1\].pe__2388_ g_row\[0\].g_col\[1\].pe__2632_/B g_row\[0\].g_col\[1\].pe__2388_/B
+ VGND VGND VPWR VPWR g_row\[0\].g_col\[1\].pe__2390_/A sky130_fd_sc_hd__nand2_2
XFILLER_3_113 VGND VGND VPWR VPWR sky130_fd_sc_hd__fill_2
XFILLER_48_813 VGND VGND VPWR VPWR sky130_fd_sc_hd__fill_1
XFILLER_74_120 VGND VGND VPWR VPWR sky130_fd_sc_hd__fill_1
XTAP_TAPCELL_ROW_89_1544 VGND VPWR sky130_fd_sc_hd__tapvpwrvgnd_1
XFILLER_63_838 VGND VGND VPWR VPWR sky130_fd_sc_hd__fill_2
XFILLER_75_687 VGND VGND VPWR VPWR sky130_fd_sc_hd__fill_2
XFILLER_74_85 VGND VGND VPWR VPWR sky130_fd_sc_hd__fill_2
XFILLER_90_635 VGND VGND VPWR VPWR sky130_fd_sc_hd__fill_1
XFILLER_15_231 VGND VGND VPWR VPWR sky130_fd_sc_hd__fill_1
XFILLER_90_679 VGND VGND VPWR VPWR sky130_fd_sc_hd__fill_1
XTAP_TAPCELL_ROW_33_708 VGND VPWR sky130_fd_sc_hd__tapvpwrvgnd_1
Xg_row\[0\].g_col\[1\].pe_hold2192 g_row\[0\].g_col\[1\].pe__2664_/X VGND VGND VPWR
+ VPWR g_row\[0\].g_col\[1\].pe__2717_/D sky130_fd_sc_hd__clkbuf_2
XFILLER_90_73 VGND VGND VPWR VPWR sky130_fd_sc_hd__fill_2
XTAP_TAPCELL_ROW_13_410 VGND VPWR sky130_fd_sc_hd__tapvpwrvgnd_1
Xg_row\[1\].g_col\[0\].pe__1803_ g_row\[1\].g_col\[0\].pe__1807_/A g_row\[1\].g_col\[0\].pe__1807_/B
+ VGND VGND VPWR VPWR g_row\[1\].g_col\[0\].pe__1803_/Y sky130_fd_sc_hd__nor2_2
X_139_ _171_/A _139_/B_N VGND VGND VPWR VPWR _139_/Y sky130_fd_sc_hd__nor2b_4
Xg_row\[1\].g_col\[1\].pe__1750_ g_row\[1\].g_col\[1\].pe__1808_/A g_row\[1\].g_col\[1\].pe__1750_/B
+ VGND VGND VPWR VPWR g_row\[1\].g_col\[1\].pe__1756_/A sky130_fd_sc_hd__xnor2_2
Xg_row\[1\].g_col\[0\].pe__1734_ g_row\[1\].g_col\[0\].pe__1734_/A g_row\[1\].g_col\[0\].pe__1734_/B
+ VGND VGND VPWR VPWR g_row\[1\].g_col\[0\].pe__1734_/X sky130_fd_sc_hd__and2_2
Xg_row\[1\].g_col\[1\].pe__1681_ g_row\[1\].g_col\[1\].pe__2612_/B g_row\[1\].g_col\[1\].pe__1729_/A2
+ g_row\[1\].g_col\[1\].pe__1729_/A3 g_row\[1\].g_col\[1\].pe__1729_/B1 g_row\[1\].g_col\[1\].pe__2614_/B
+ VGND VGND VPWR VPWR g_row\[1\].g_col\[1\].pe__1682_/B sky130_fd_sc_hd__a32o_2
Xg_row\[1\].g_col\[0\].pe__1665_ g_row\[1\].g_col\[0\].pe__1656_/A g_row\[1\].g_col\[0\].pe__1656_/B
+ g_row\[1\].g_col\[0\].pe__1664_/X VGND VGND VPWR VPWR g_row\[1\].g_col\[0\].pe__1697_/A
+ sky130_fd_sc_hd__a21bo_2
Xg_row\[0\].g_col\[0\].pe__1812_ g_row\[0\].g_col\[0\].pe__1813_/A g_row\[0\].g_col\[0\].pe__1780_/Y
+ g_row\[0\].g_col\[0\].pe__1810_/X g_row\[0\].g_col\[0\].pe__1811_/X VGND VGND VPWR
+ VPWR g_row\[0\].g_col\[0\].pe__1812_/X sky130_fd_sc_hd__o31a_2
Xg_row\[1\].g_col\[0\].pe__1596_ g_row\[1\].g_col\[0\].pe__1596_/A g_row\[1\].g_col\[0\].pe__1596_/B
+ VGND VGND VPWR VPWR g_row\[1\].g_col\[0\].pe__1596_/X sky130_fd_sc_hd__and2_2
Xg_row\[1\].g_col\[1\].pe__2302_ g_row\[1\].g_col\[1\].pe__2238_/X g_row\[1\].g_col\[1\].pe__2263_/B
+ g_row\[1\].g_col\[1\].pe__2261_/Y VGND VGND VPWR VPWR g_row\[1\].g_col\[1\].pe__2302_/Y
+ sky130_fd_sc_hd__a21oi_2
XFILLER_38_378 VGND VGND VPWR VPWR sky130_fd_sc_hd__decap_3
Xg_row\[0\].g_col\[0\].pe__1743_ g_row\[0\].g_col\[0\].pe__1743_/A g_row\[0\].g_col\[0\].pe__1743_/B
+ VGND VGND VPWR VPWR g_row\[0\].g_col\[0\].pe__1815_/A sky130_fd_sc_hd__xnor2_2
XFILLER_53_337 VGND VGND VPWR VPWR sky130_fd_sc_hd__decap_3
Xg_row\[0\].g_col\[0\].pe__1674_ g_row\[0\].g_col\[0\].pe__1690_/A g_row\[0\].g_col\[0\].pe__1690_/B
+ VGND VGND VPWR VPWR g_row\[0\].g_col\[0\].pe__1676_/B sky130_fd_sc_hd__nand2_2
Xg_row\[0\].g_col\[1\].pe__1690_ g_row\[0\].g_col\[1\].pe__1690_/A g_row\[0\].g_col\[1\].pe__1690_/B
+ VGND VGND VPWR VPWR g_row\[0\].g_col\[1\].pe__1722_/B sky130_fd_sc_hd__xor2_2
Xg_row\[1\].g_col\[1\].pe__2233_ g_row\[1\].g_col\[1\].pe__2233_/A g_row\[1\].g_col\[1\].pe__2298_/A
+ g_row\[1\].g_col\[1\].pe__2233_/C VGND VGND VPWR VPWR g_row\[1\].g_col\[1\].pe__2233_/X
+ sky130_fd_sc_hd__and3_2
Xg_row\[1\].g_col\[0\].pe__2217_ g_row\[1\].g_col\[0\].pe__2364_/A g_row\[1\].g_col\[0\].pe__2217_/B
+ VGND VGND VPWR VPWR g_row\[1\].g_col\[0\].pe__2239_/B sky130_fd_sc_hd__xnor2_2
Xg_row\[1\].g_col\[1\].pe__2164_ g_row\[1\].g_col\[1\].pe__1461_/A g_row\[1\].g_col\[1\].pe__1461_/B
+ g_row\[1\].g_col\[1\].pe__1983_/Y VGND VGND VPWR VPWR g_row\[1\].g_col\[1\].pe__2165_/C
+ sky130_fd_sc_hd__a21o_2
Xg_row\[1\].g_col\[0\].pe__2148_ g_row\[1\].g_col\[0\].pe__2148_/A g_row\[1\].g_col\[0\].pe__2162_/B
+ VGND VGND VPWR VPWR g_row\[1\].g_col\[0\].pe__2161_/B sky130_fd_sc_hd__xnor2_2
XFILLER_21_223 VGND VGND VPWR VPWR sky130_fd_sc_hd__fill_1
XFILLER_22_757 VGND VGND VPWR VPWR sky130_fd_sc_hd__fill_2
Xg_row\[1\].g_col\[1\].pe__2095_ g_row\[1\].g_col\[1\].pe__2184_/C g_row\[1\].g_col\[1\].pe__2095_/B
+ VGND VGND VPWR VPWR g_row\[1\].g_col\[1\].pe__2097_/A sky130_fd_sc_hd__nand2_2
Xg_row\[1\].g_col\[0\].pe__2079_ g_row\[1\].g_col\[0\].pe__2163_/A g_row\[1\].g_col\[0\].pe__2079_/B
+ VGND VGND VPWR VPWR g_row\[1\].g_col\[0\].pe__2081_/B sky130_fd_sc_hd__nand2_2
Xg_row\[0\].g_col\[1\].pe__2311_ g_row\[0\].g_col\[1\].pe__2311_/A g_row\[0\].g_col\[1\].pe__2311_/B
+ VGND VGND VPWR VPWR g_row\[0\].g_col\[1\].pe__2319_/A sky130_fd_sc_hd__nand2_2
Xg_row\[0\].g_col\[0\].pe__2226_ g_row\[0\].g_col\[0\].pe__2226_/A g_row\[0\].g_col\[0\].pe__2226_/B
+ VGND VGND VPWR VPWR g_row\[0\].g_col\[0\].pe__2228_/C sky130_fd_sc_hd__xor2_2
Xg_row\[0\].g_col\[1\].pe__2242_ g_row\[0\].g_col\[1\].pe__2627_/B g_row\[0\].g_col\[1\].pe__2313_/A2
+ g_row\[0\].g_col\[1\].pe__1541_/X g_row\[0\].g_col\[1\].pe__2625_/B VGND VGND VPWR
+ VPWR g_row\[0\].g_col\[1\].pe__2243_/B sky130_fd_sc_hd__a22o_2
Xg_row\[0\].g_col\[0\].pe__2157_ g_row\[0\].g_col\[0\].pe__2157_/A g_row\[0\].g_col\[0\].pe__2157_/B
+ VGND VGND VPWR VPWR g_row\[0\].g_col\[0\].pe__2157_/Y sky130_fd_sc_hd__nand2_2
Xg_row\[1\].g_col\[1\].pe_hold3019 hold1781/X VGND VGND VPWR VPWR g_row\[1\].g_col\[1\].pe__2668_/A2
+ sky130_fd_sc_hd__clkbuf_2
Xg_row\[0\].g_col\[1\].pe__2173_ g_row\[0\].g_col\[1\].pe__2222_/A g_row\[0\].g_col\[1\].pe__2253_/A
+ VGND VGND VPWR VPWR g_row\[0\].g_col\[1\].pe__2183_/A sky130_fd_sc_hd__xnor2_2
XFILLER_1_617 VGND VGND VPWR VPWR sky130_fd_sc_hd__decap_3
XFILLER_89_713 VGND VGND VPWR VPWR sky130_fd_sc_hd__fill_1
XTAP_TAPCELL_ROW_73_1301 VGND VPWR sky130_fd_sc_hd__tapvpwrvgnd_1
XTAP_TAPCELL_ROW_73_1312 VGND VPWR sky130_fd_sc_hd__tapvpwrvgnd_1
Xg_row\[0\].g_col\[0\].pe__2088_ g_row\[0\].g_col\[0\].pe__2087_/A g_row\[0\].g_col\[0\].pe__2087_/B
+ g_row\[0\].g_col\[0\].pe__2087_/C g_row\[0\].g_col\[0\].pe__2087_/D VGND VGND VPWR
+ VPWR g_row\[0\].g_col\[0\].pe__2091_/B sky130_fd_sc_hd__a22o_4
Xg_row\[1\].g_col\[1\].pe__1948_ hold1641/X g_row\[1\].g_col\[1\].pe__1948_/B VGND
+ VGND VPWR VPWR g_row\[1\].g_col\[1\].pe__1948_/Y sky130_fd_sc_hd__nor2_2
XFILLER_1_639 VGND VGND VPWR VPWR sky130_fd_sc_hd__decap_3
Xhold3000 hold3000/A VGND VGND VPWR VPWR hold3000/X sky130_fd_sc_hd__clkbuf_2
Xg_row\[1\].g_col\[1\].pe__1879_ g_row\[1\].g_col\[1\].pe__1879_/A g_row\[1\].g_col\[1\].pe__1879_/B
+ VGND VGND VPWR VPWR g_row\[1\].g_col\[1\].pe__1879_/Y sky130_fd_sc_hd__nor2_2
XFILLER_57_643 VGND VGND VPWR VPWR sky130_fd_sc_hd__decap_3
Xhold1620 hold2790/X VGND VGND VPWR VPWR hold2791/A sky130_fd_sc_hd__clkbuf_2
Xhold1631 hold3588/X VGND VGND VPWR VPWR hold2807/A sky130_fd_sc_hd__clkbuf_2
Xg_row\[0\].g_col\[1\].pe__1957_ g_row\[0\].g_col\[1\].pe__2019_/B2 g_row\[0\].g_col\[1\].pe__2177_/A2
+ g_row\[0\].g_col\[1\].pe__2215_/B1 g_row\[0\].g_col\[1\].pe__1957_/B2 VGND VGND
+ VPWR VPWR g_row\[0\].g_col\[1\].pe__1961_/A sky130_fd_sc_hd__a22o_2
XFILLER_56_186 VGND VGND VPWR VPWR sky130_fd_sc_hd__fill_1
Xg_row\[0\].g_col\[1\].pe__1888_ g_row\[0\].g_col\[1\].pe__1888_/A g_row\[0\].g_col\[1\].pe__1888_/B
+ g_row\[0\].g_col\[1\].pe__1888_/C VGND VGND VPWR VPWR g_row\[0\].g_col\[1\].pe__1889_/B
+ sky130_fd_sc_hd__nor3_2
XFILLER_13_724 VGND VGND VPWR VPWR sky130_fd_sc_hd__decap_3
XFILLER_25_573 VGND VGND VPWR VPWR sky130_fd_sc_hd__fill_1
XFILLER_71_189 VGND VGND VPWR VPWR sky130_fd_sc_hd__fill_2
XTAP_TAPCELL_ROW_84_1463 VGND VPWR sky130_fd_sc_hd__tapvpwrvgnd_1
XTAP_TAPCELL_ROW_84_1474 VGND VPWR sky130_fd_sc_hd__tapvpwrvgnd_1
XFILLER_12_234 VGND VGND VPWR VPWR sky130_fd_sc_hd__fill_1
XFILLER_13_746 VGND VGND VPWR VPWR sky130_fd_sc_hd__decap_3
XFILLER_9_717 VGND VGND VPWR VPWR sky130_fd_sc_hd__decap_3
Xg_row\[0\].g_col\[1\].pe__2509_ g_row\[0\].g_col\[1\].pe__2503_/B g_row\[0\].g_col\[1\].pe__2486_/B
+ g_row\[0\].g_col\[1\].pe__2509_/S VGND VGND VPWR VPWR g_row\[0\].g_col\[1\].pe__2509_/X
+ sky130_fd_sc_hd__mux2_1
Xg_row\[0\].g_col\[0\].pe_place1256 place1263/X VGND VGND VPWR VPWR g_row\[0\].g_col\[0\].pe__2676_/A
+ sky130_fd_sc_hd__buf_6
Xclkbuf_4_0_0_clk clkbuf_0_clk/X VGND VGND VPWR VPWR clkbuf_4_0_0_clk/X sky130_fd_sc_hd__clkbuf_16
Xg_row\[1\].g_col\[1\].pe_hold2841 g_row\[1\].g_col\[1\].pe_hold2841/A VGND VGND VPWR
+ VPWR g_row\[1\].g_col\[1\].pe__2717_/D sky130_fd_sc_hd__clkbuf_2
Xg_row\[1\].g_col\[1\].pe_hold2863 g_row\[1\].g_col\[1\].pe__2657_/X VGND VGND VPWR
+ VPWR g_row\[1\].g_col\[1\].pe__2658_/C1 sky130_fd_sc_hd__clkbuf_2
Xg_row\[1\].g_col\[1\].pe_hold2874 g_row\[1\].g_col\[1\].pe__2660_/X VGND VGND VPWR
+ VPWR g_row\[1\].g_col\[1\].pe_hold2874/X sky130_fd_sc_hd__clkbuf_2
Xg_row\[1\].g_col\[1\].pe_hold2885 g_row\[1\].g_col\[1\].pe__2677_/X VGND VGND VPWR
+ VPWR g_row\[1\].g_col\[1\].pe_hold2885/X sky130_fd_sc_hd__clkbuf_2
XFILLER_0_661 VGND VGND VPWR VPWR sky130_fd_sc_hd__decap_3
XFILLER_47_153 VGND VGND VPWR VPWR sky130_fd_sc_hd__fill_2
Xg_row\[1\].g_col\[0\].pe__2002_ g_row\[1\].g_col\[0\].pe__2002_/A g_row\[1\].g_col\[0\].pe__2002_/B
+ VGND VGND VPWR VPWR g_row\[1\].g_col\[0\].pe__2013_/B sky130_fd_sc_hd__xnor2_2
XFILLER_50_307 VGND VGND VPWR VPWR sky130_fd_sc_hd__fill_1
XTAP_TAPCELL_ROW_46_899 VGND VPWR sky130_fd_sc_hd__tapvpwrvgnd_1
Xg_row\[0\].g_col\[0\].pe__2011_ g_row\[0\].g_col\[0\].pe__2011_/A1 g_row\[0\].g_col\[0\].pe__2010_/X
+ place1269/X VGND VGND VPWR VPWR g_row\[0\].g_col\[0\].pe__2011_/Y sky130_fd_sc_hd__a21oi_2
Xg_row\[1\].g_col\[1\].pe__1802_ g_row\[1\].g_col\[1\].pe__1785_/A g_row\[1\].g_col\[1\].pe__1806_/B
+ g_row\[1\].g_col\[1\].pe__1801_/X VGND VGND VPWR VPWR g_row\[1\].g_col\[1\].pe__1807_/B
+ sky130_fd_sc_hd__a21o_2
Xg_row\[1\].g_col\[0\].pe__2766_ clkbuf_leaf_56_clk/X g_row\[1\].g_col\[0\].pe__2766_/D
+ VGND VGND VPWR VPWR g_row\[1\].g_col\[0\].pe__2766_/Q sky130_fd_sc_hd__dfxtp_2
XTAP_TAPCELL_ROW_55_1031 VGND VPWR sky130_fd_sc_hd__tapvpwrvgnd_1
XTAP_TAPCELL_ROW_55_1042 VGND VPWR sky130_fd_sc_hd__tapvpwrvgnd_1
Xg_row\[1\].g_col\[1\].pe__1733_ g_row\[1\].g_col\[1\].pe__1733_/A g_row\[1\].g_col\[1\].pe__1733_/B
+ VGND VGND VPWR VPWR g_row\[1\].g_col\[1\].pe__1758_/B sky130_fd_sc_hd__xor2_2
Xg_row\[1\].g_col\[0\].pe__1717_ g_row\[1\].g_col\[0\].pe__1816_/A g_row\[1\].g_col\[0\].pe__1717_/B
+ VGND VGND VPWR VPWR g_row\[1\].g_col\[0\].pe__1718_/B sky130_fd_sc_hd__xor2_2
Xg_row\[1\].g_col\[0\].pe__2697_ clkbuf_leaf_67_clk/X g_row\[1\].g_col\[0\].pe__2697_/D
+ VGND VGND VPWR VPWR place1092/A sky130_fd_sc_hd__dfxtp_2
XFILLER_58_429 VGND VGND VPWR VPWR sky130_fd_sc_hd__fill_1
XFILLER_86_738 VGND VGND VPWR VPWR sky130_fd_sc_hd__decap_3
Xg_row\[1\].g_col\[1\].pe__1664_ g_row\[1\].g_col\[1\].pe__1664_/A g_row\[1\].g_col\[1\].pe__1659_/A
+ VGND VGND VPWR VPWR g_row\[1\].g_col\[1\].pe__1664_/X sky130_fd_sc_hd__or2b_2
Xg_row\[1\].g_col\[0\].pe__1648_ g_row\[1\].g_col\[0\].pe__1648_/A g_row\[1\].g_col\[0\].pe__1648_/B
+ VGND VGND VPWR VPWR g_row\[1\].g_col\[0\].pe__1648_/X sky130_fd_sc_hd__and2_2
XFILLER_39_643 VGND VGND VPWR VPWR sky130_fd_sc_hd__fill_2
Xg_row\[1\].g_col\[1\].pe__1595_ g_row\[1\].g_col\[1\].pe__1591_/A g_row\[1\].g_col\[1\].pe__1593_/Y
+ g_row\[1\].g_col\[1\].pe__1594_/Y VGND VGND VPWR VPWR g_row\[1\].g_col\[1\].pe__1844_/A
+ sky130_fd_sc_hd__o21ai_2
Xg_row\[1\].g_col\[0\].pe__1579_ g_row\[1\].g_col\[0\].pe__1579_/A g_row\[1\].g_col\[0\].pe__1579_/B
+ VGND VGND VPWR VPWR g_row\[1\].g_col\[0\].pe__1630_/B sky130_fd_sc_hd__xor2_2
Xg_row\[0\].g_col\[1\].pe__1811_ g_row\[0\].g_col\[1\].pe__1811_/A g_row\[0\].g_col\[1\].pe__1811_/B
+ g_row\[0\].g_col\[1\].pe__1811_/C g_row\[0\].g_col\[1\].pe__1780_/A VGND VGND VPWR
+ VPWR g_row\[0\].g_col\[1\].pe__1811_/X sky130_fd_sc_hd__or4b_4
Xg_row\[0\].g_col\[0\].pe__2775_ g_row\[0\].g_col\[0\].pe__2775_/A VGND VGND VPWR
+ VPWR output1355/A sky130_fd_sc_hd__buf_2
Xg_row\[1\].g_col\[0\].pe_hold1862 g_row\[1\].g_col\[0\].pe_hold2965/X VGND VGND VPWR
+ VPWR g_row\[1\].g_col\[0\].pe_hold2966/A sky130_fd_sc_hd__clkbuf_2
Xg_row\[1\].g_col\[0\].pe_hold1840 g_row\[1\].g_col\[0\].pe__2640_/X VGND VGND VPWR
+ VPWR g_row\[1\].g_col\[0\].pe__2705_/D sky130_fd_sc_hd__clkbuf_2
Xg_row\[0\].g_col\[1\].pe_hold2906 _340_/Q VGND VGND VPWR VPWR g_row\[0\].g_col\[1\].pe__2675_/B1
+ sky130_fd_sc_hd__clkbuf_2
XFILLER_54_635 VGND VGND VPWR VPWR sky130_fd_sc_hd__decap_3
XFILLER_93_281 VGND VGND VPWR VPWR sky130_fd_sc_hd__fill_1
Xg_row\[0\].g_col\[0\].pe__1726_ g_row\[0\].g_col\[0\].pe__1824_/B g_row\[0\].g_col\[0\].pe__1726_/B
+ VGND VGND VPWR VPWR g_row\[0\].g_col\[0\].pe__1747_/A sky130_fd_sc_hd__xnor2_2
Xg_row\[0\].g_col\[1\].pe__1742_ g_row\[0\].g_col\[1\].pe__1719_/Y g_row\[0\].g_col\[1\].pe__1742_/B
+ VGND VGND VPWR VPWR g_row\[0\].g_col\[1\].pe__1743_/A sky130_fd_sc_hd__nand2b_2
Xg_row\[1\].g_col\[0\].pe_hold1895 g_row\[1\].g_col\[0\].pe_hold2832/X VGND VGND VPWR
+ VPWR g_row\[1\].g_col\[0\].pe_hold2833/A sky130_fd_sc_hd__clkbuf_2
Xg_row\[1\].g_col\[0\].pe_hold1873 g_row\[1\].g_col\[0\].pe_hold3013/X VGND VGND VPWR
+ VPWR g_row\[1\].g_col\[0\].pe__2737_/D sky130_fd_sc_hd__clkbuf_2
Xg_row\[0\].g_col\[1\].pe__1673_ g_row\[0\].g_col\[1\].pe__1673_/A g_row\[0\].g_col\[1\].pe__1673_/B
+ VGND VGND VPWR VPWR g_row\[0\].g_col\[1\].pe__1690_/B sky130_fd_sc_hd__xnor2_2
Xg_row\[1\].g_col\[1\].pe__2216_ g_row\[1\].g_col\[1\].pe__2030_/A g_row\[1\].g_col\[1\].pe__2313_/A2
+ g_row\[1\].g_col\[1\].pe__2313_/B1 g_row\[1\].g_col\[1\].pe__2278_/B2 VGND VGND
+ VPWR VPWR g_row\[1\].g_col\[1\].pe__2217_/B sky130_fd_sc_hd__a22o_2
Xg_row\[0\].g_col\[0\].pe__1657_ place1221/X g_row\[0\].g_col\[0\].pe__1657_/B VGND
+ VGND VPWR VPWR g_row\[0\].g_col\[0\].pe__1658_/B sky130_fd_sc_hd__nand2_2
XFILLER_50_841 VGND VGND VPWR VPWR sky130_fd_sc_hd__fill_1
XTAP_TAPCELL_ROW_66_1193 VGND VPWR sky130_fd_sc_hd__tapvpwrvgnd_1
Xg_row\[0\].g_col\[0\].pe__1588_ g_row\[0\].g_col\[0\].pe__1588_/A g_row\[0\].g_col\[0\].pe__1588_/B
+ VGND VGND VPWR VPWR g_row\[0\].g_col\[0\].pe__1588_/Y sky130_fd_sc_hd__nor2_2
Xg_row\[1\].g_col\[1\].pe__2147_ g_row\[1\].g_col\[1\].pe__2147_/A g_row\[1\].g_col\[1\].pe__2147_/B
+ VGND VGND VPWR VPWR g_row\[1\].g_col\[1\].pe__2162_/B sky130_fd_sc_hd__xor2_2
XFILLER_10_727 VGND VGND VPWR VPWR sky130_fd_sc_hd__fill_1
XFILLER_22_587 VGND VGND VPWR VPWR sky130_fd_sc_hd__fill_1
Xg_row\[1\].g_col\[1\].pe__2078_ g_row\[1\].g_col\[1\].pe__2078_/A g_row\[1\].g_col\[1\].pe__2078_/B
+ VGND VGND VPWR VPWR g_row\[1\].g_col\[1\].pe__2101_/A sky130_fd_sc_hd__xnor2_2
Xg_row\[0\].g_col\[0\].pe__2209_ g_row\[0\].g_col\[0\].pe__2348_/A g_row\[0\].g_col\[0\].pe__2209_/B
+ VGND VGND VPWR VPWR g_row\[0\].g_col\[0\].pe__2210_/B sky130_fd_sc_hd__xnor2_2
Xg_row\[0\].g_col\[1\].pe__2225_ g_row\[0\].g_col\[1\].pe__2174_/A g_row\[0\].g_col\[1\].pe__2174_/B
+ g_row\[0\].g_col\[1\].pe__2182_/B g_row\[0\].g_col\[1\].pe__2181_/B g_row\[0\].g_col\[1\].pe__2181_/A
+ VGND VGND VPWR VPWR g_row\[0\].g_col\[1\].pe__2226_/B sky130_fd_sc_hd__a32o_2
Xg_row\[0\].g_col\[1\].pe__2156_ g_row\[0\].g_col\[1\].pe__2155_/B g_row\[0\].g_col\[1\].pe__2300_/A
+ g_row\[0\].g_col\[1\].pe__2200_/A VGND VGND VPWR VPWR g_row\[0\].g_col\[1\].pe__2157_/B
+ sky130_fd_sc_hd__a21o_2
Xg_row\[0\].g_col\[1\].pe__2087_ g_row\[0\].g_col\[1\].pe__2087_/A g_row\[0\].g_col\[1\].pe__2087_/B
+ g_row\[0\].g_col\[1\].pe__2087_/C g_row\[0\].g_col\[1\].pe__2087_/D VGND VGND VPWR
+ VPWR g_row\[0\].g_col\[1\].pe__2091_/A sky130_fd_sc_hd__nand4_2
XFILLER_39_55 VGND VGND VPWR VPWR sky130_fd_sc_hd__fill_1
Xhold2151 hold2185/X VGND VGND VPWR VPWR hold2186/A sky130_fd_sc_hd__clkbuf_2
Xhold2162 hold2170/X VGND VGND VPWR VPWR hold2162/X sky130_fd_sc_hd__clkbuf_2
XFILLER_85_760 VGND VGND VPWR VPWR sky130_fd_sc_hd__decap_3
XTAP_TAPCELL_ROW_4_263 VGND VPWR sky130_fd_sc_hd__tapvpwrvgnd_1
XTAP_TAPCELL_ROW_4_274 VGND VPWR sky130_fd_sc_hd__tapvpwrvgnd_1
XTAP_TAPCELL_ROW_86_1503 VGND VPWR sky130_fd_sc_hd__tapvpwrvgnd_1
Xhold1450 hold3208/X VGND VGND VPWR VPWR hold3209/A sky130_fd_sc_hd__clkbuf_2
Xhold1461 hold2502/X VGND VGND VPWR VPWR hold2503/A sky130_fd_sc_hd__clkbuf_2
XFILLER_45_635 VGND VGND VPWR VPWR sky130_fd_sc_hd__decap_3
XFILLER_57_473 VGND VGND VPWR VPWR sky130_fd_sc_hd__fill_2
XFILLER_72_421 VGND VGND VPWR VPWR sky130_fd_sc_hd__fill_2
Xhold1472 hold3233/X VGND VGND VPWR VPWR hold3234/A sky130_fd_sc_hd__clkbuf_2
Xhold1483 hold3250/X VGND VGND VPWR VPWR hold3251/A sky130_fd_sc_hd__clkbuf_2
Xhold1494 hold2538/X VGND VGND VPWR VPWR hold2539/A sky130_fd_sc_hd__clkbuf_2
XFILLER_33_819 VGND VGND VPWR VPWR sky130_fd_sc_hd__fill_2
Xg_row\[1\].g_col\[0\].pe_place822 g_row\[1\].g_col\[0\].pe__2590_/A VGND VGND VPWR
+ VPWR g_row\[1\].g_col\[0\].pe__2559_/A sky130_fd_sc_hd__buf_6
Xg_row\[1\].g_col\[0\].pe_place844 g_row\[1\].g_col\[0\].pe__1541_/X VGND VGND VPWR
+ VPWR g_row\[1\].g_col\[0\].pe__2074_/B1 sky130_fd_sc_hd__buf_6
XFILLER_41_841 VGND VGND VPWR VPWR sky130_fd_sc_hd__fill_1
XTAP_TAPCELL_ROW_43_858 VGND VPWR sky130_fd_sc_hd__tapvpwrvgnd_1
XFILLER_71_42 VGND VGND VPWR VPWR sky130_fd_sc_hd__fill_1
XFILLER_9_569 VGND VGND VPWR VPWR sky130_fd_sc_hd__decap_3
XTAP_TAPCELL_ROW_23_560 VGND VPWR sky130_fd_sc_hd__tapvpwrvgnd_1
Xg_row\[1\].g_col\[0\].pe__2551_ g_row\[1\].g_col\[0\].pe__2551_/A g_row\[1\].g_col\[0\].pe__2551_/B
+ g_row\[1\].g_col\[0\].pe__2551_/C VGND VGND VPWR VPWR g_row\[1\].g_col\[0\].pe__2551_/Y
+ sky130_fd_sc_hd__nand3_2
XFILLER_68_716 VGND VGND VPWR VPWR sky130_fd_sc_hd__fill_1
Xg_row\[1\].g_col\[1\].pe_hold1981 g_row\[1\].g_col\[1\].pe__2603_/X VGND VGND VPWR
+ VPWR g_row\[1\].g_col\[1\].pe__2604_/C1 sky130_fd_sc_hd__clkbuf_2
Xg_row\[1\].g_col\[1\].pe_hold1970 g_row\[1\].g_col\[1\].pe__1391_/X VGND VGND VPWR
+ VPWR g_row\[1\].g_col\[1\].pe__2731_/D sky130_fd_sc_hd__clkbuf_2
Xg_row\[1\].g_col\[0\].pe__2482_ g_row\[1\].g_col\[0\].pe__2494_/A g_row\[1\].g_col\[0\].pe__2482_/B
+ VGND VGND VPWR VPWR g_row\[1\].g_col\[0\].pe__2508_/B sky130_fd_sc_hd__nor2_2
Xg_row\[1\].g_col\[0\].pe__1502_ g_row\[1\].g_col\[0\].pe__2735_/Q g_row\[1\].g_col\[0\].pe__2734_/Q
+ VGND VGND VPWR VPWR g_row\[1\].g_col\[0\].pe__1504_/A sky130_fd_sc_hd__and2_2
XFILLER_36_602 VGND VGND VPWR VPWR sky130_fd_sc_hd__decap_3
Xg_row\[1\].g_col\[1\].pe__1380_ g_row\[1\].g_col\[1\].pe__1380_/A1 g_row\[1\].g_col\[1\].pe__2686_/B
+ g_row\[1\].g_col\[1\].pe__1376_/X g_row\[1\].g_col\[1\].pe__2666_/B1 VGND VGND VPWR
+ VPWR g_row\[1\].g_col\[1\].pe__1380_/X sky130_fd_sc_hd__o211a_2
XFILLER_75_270 VGND VGND VPWR VPWR sky130_fd_sc_hd__fill_2
Xg_row\[0\].g_col\[0\].pe__2560_ g_row\[0\].g_col\[0\].pe__2560_/A1 g_row\[0\].g_col\[0\].pe__2591_/A2
+ g_row\[0\].g_col\[0\].pe__2591_/B1 g_row\[0\].g_col\[0\].pe__2559_/X VGND VGND VPWR
+ VPWR g_row\[0\].g_col\[0\].pe__2560_/X sky130_fd_sc_hd__a22o_2
Xg_row\[1\].g_col\[0\].pe__1364_ g_row\[1\].g_col\[0\].pe__2768_/Q VGND VGND VPWR
+ VPWR g_row\[1\].g_col\[0\].pe__2478_/A sky130_fd_sc_hd__inv_2
XFILLER_35_123 VGND VGND VPWR VPWR sky130_fd_sc_hd__fill_1
XFILLER_35_156 VGND VGND VPWR VPWR sky130_fd_sc_hd__fill_2
XFILLER_36_668 VGND VGND VPWR VPWR sky130_fd_sc_hd__decap_3
Xg_row\[0\].g_col\[0\].pe__1511_ g_row\[0\].g_col\[0\].pe__1640_/A g_row\[0\].g_col\[0\].pe__1640_/B
+ g_row\[0\].g_col\[0\].pe__1510_/X VGND VGND VPWR VPWR g_row\[0\].g_col\[0\].pe__1550_/A
+ sky130_fd_sc_hd__a21oi_2
Xg_row\[0\].g_col\[0\].pe__2491_ g_row\[0\].g_col\[0\].pe__2491_/A g_row\[0\].g_col\[0\].pe__2491_/B
+ g_row\[0\].g_col\[0\].pe__2505_/A VGND VGND VPWR VPWR g_row\[0\].g_col\[0\].pe__2492_/B
+ sky130_fd_sc_hd__or3_2
XFILLER_32_841 VGND VGND VPWR VPWR sky130_fd_sc_hd__fill_1
Xg_row\[0\].g_col\[0\].pe__1442_ g_row\[0\].g_col\[0\].pe__1442_/A g_row\[0\].g_col\[0\].pe__1442_/B
+ VGND VGND VPWR VPWR g_row\[0\].g_col\[0\].pe__1479_/B sky130_fd_sc_hd__xnor2_2
Xg_row\[1\].g_col\[1\].pe__2001_ g_row\[1\].g_col\[1\].pe__2014_/B g_row\[1\].g_col\[1\].pe__2001_/B
+ VGND VGND VPWR VPWR g_row\[1\].g_col\[1\].pe__2002_/B sky130_fd_sc_hd__xnor2_2
XTAP_TAPCELL_ROW_21_519 VGND VPWR sky130_fd_sc_hd__tapvpwrvgnd_1
Xg_row\[0\].g_col\[1\].pe__2010_ g_row\[0\].g_col\[1\].pe__2010_/A g_row\[0\].g_col\[1\].pe__2010_/B
+ g_row\[0\].g_col\[1\].pe__2062_/A g_row\[0\].g_col\[1\].pe__2010_/D VGND VGND VPWR
+ VPWR g_row\[0\].g_col\[1\].pe__2010_/X sky130_fd_sc_hd__or4_4
Xg_row\[1\].g_col\[1\].pe__2765_ clkbuf_leaf_75_clk/X g_row\[1\].g_col\[1\].pe__2765_/D
+ VGND VGND VPWR VPWR g_row\[1\].g_col\[1\].pe__2765_/Q sky130_fd_sc_hd__dfxtp_2
Xg_row\[1\].g_col\[0\].pe__2749_ clkbuf_leaf_55_clk/X g_row\[1\].g_col\[0\].pe__2749_/D
+ VGND VGND VPWR VPWR g_row\[1\].g_col\[0\].pe__2749_/Q sky130_fd_sc_hd__dfxtp_2
XFILLER_59_727 VGND VGND VPWR VPWR sky130_fd_sc_hd__fill_1
XFILLER_86_502 VGND VGND VPWR VPWR sky130_fd_sc_hd__decap_3
Xg_row\[1\].g_col\[1\].pe__2696_ clkbuf_leaf_70_clk/X g_row\[1\].g_col\[1\].pe__2696_/D
+ VGND VGND VPWR VPWR g_row\[1\].g_col\[1\].pe__2696_/Q sky130_fd_sc_hd__dfxtp_2
Xg_row\[1\].g_col\[1\].pe__1716_ g_row\[1\].g_col\[1\].pe__2605_/B g_row\[1\].g_col\[1\].pe__1748_/B
+ g_row\[1\].g_col\[1\].pe__1738_/B1 g_row\[1\].g_col\[1\].pe__1805_/A2 VGND VGND
+ VPWR VPWR g_row\[1\].g_col\[1\].pe__1717_/B sky130_fd_sc_hd__a22o_2
Xg_row\[1\].g_col\[1\].pe__1647_ g_row\[1\].g_col\[1\].pe__1733_/A g_row\[1\].g_col\[1\].pe__1647_/B
+ VGND VGND VPWR VPWR g_row\[1\].g_col\[1\].pe__1688_/B sky130_fd_sc_hd__xor2_2
Xg_row\[1\].g_col\[0\].pe_hold3094 g_row\[1\].g_col\[0\].pe__2728_/Q VGND VGND VPWR
+ VPWR g_row\[1\].g_col\[0\].pe_hold3094/X sky130_fd_sc_hd__clkbuf_2
Xg_row\[1\].g_col\[0\].pe_hold3061 g_row\[1\].g_col\[0\].pe__2644_/X VGND VGND VPWR
+ VPWR g_row\[1\].g_col\[0\].pe_hold3061/X sky130_fd_sc_hd__clkbuf_2
XFILLER_86_568 VGND VGND VPWR VPWR sky130_fd_sc_hd__fill_1
XFILLER_27_624 VGND VGND VPWR VPWR sky130_fd_sc_hd__decap_3
XFILLER_73_218 VGND VGND VPWR VPWR sky130_fd_sc_hd__fill_1
XFILLER_82_730 VGND VGND VPWR VPWR sky130_fd_sc_hd__fill_2
XTAP_TAPCELL_ROW_1_222 VGND VPWR sky130_fd_sc_hd__tapvpwrvgnd_1
Xg_row\[1\].g_col\[1\].pe__1578_ g_row\[1\].g_col\[1\].pe__2125_/C g_row\[1\].g_col\[1\].pe__1578_/B
+ VGND VGND VPWR VPWR g_row\[1\].g_col\[1\].pe__1579_/B sky130_fd_sc_hd__xor2_2
Xg_row\[0\].g_col\[1\].pe__2774_ g_row\[0\].g_col\[1\].pe__2774_/A VGND VGND VPWR
+ VPWR g_row\[0\].g_col\[1\].pe__2774_/X sky130_fd_sc_hd__buf_2
XFILLER_27_679 VGND VGND VPWR VPWR sky130_fd_sc_hd__decap_3
XTAP_TAPCELL_ROW_68_1233 VGND VPWR sky130_fd_sc_hd__tapvpwrvgnd_1
Xg_row\[0\].g_col\[0\].pe__2758_ clkbuf_leaf_32_clk/X g_row\[0\].g_col\[0\].pe__2758_/D
+ VGND VGND VPWR VPWR g_row\[0\].g_col\[0\].pe__2758_/Q sky130_fd_sc_hd__dfxtp_2
Xg_row\[0\].g_col\[1\].pe__1725_ g_row\[0\].g_col\[1\].pe__1723_/A g_row\[0\].g_col\[1\].pe__1723_/B
+ g_row\[0\].g_col\[1\].pe__1745_/B g_row\[0\].g_col\[1\].pe__1745_/A VGND VGND VPWR
+ VPWR g_row\[0\].g_col\[1\].pe__1726_/B sky130_fd_sc_hd__a22oi_2
Xg_row\[1\].g_col\[0\].pe_hold1692 g_row\[1\].g_col\[0\].pe__2747_/Q VGND VGND VPWR
+ VPWR g_row\[1\].g_col\[0\].pe__2235_/A sky130_fd_sc_hd__clkbuf_2
XFILLER_14_329 VGND VGND VPWR VPWR sky130_fd_sc_hd__decap_3
XFILLER_26_156 VGND VGND VPWR VPWR sky130_fd_sc_hd__decap_3
Xg_row\[0\].g_col\[0\].pe__1709_ g_row\[0\].g_col\[0\].pe__1709_/A g_row\[0\].g_col\[0\].pe__1709_/B
+ VGND VGND VPWR VPWR g_row\[0\].g_col\[0\].pe__1736_/A sky130_fd_sc_hd__xor2_2
Xg_row\[0\].g_col\[0\].pe__2689_ g_row\[0\].g_col\[0\].pe__2689_/A g_row\[0\].g_col\[0\].pe__2724_/Q
+ g_row\[0\].g_col\[0\].pe__2689_/CIN VGND VGND VPWR VPWR g_row\[0\].g_col\[0\].pe__1616_/A2
+ g_row\[0\].g_col\[0\].pe__2689_/SUM sky130_fd_sc_hd__fa_1
XFILLER_23_841 VGND VGND VPWR VPWR sky130_fd_sc_hd__fill_1
XTAP_TAPCELL_ROW_81_1422 VGND VPWR sky130_fd_sc_hd__tapvpwrvgnd_1
Xg_row\[0\].g_col\[1\].pe__1656_ g_row\[0\].g_col\[1\].pe__1656_/A g_row\[0\].g_col\[1\].pe__1656_/B
+ VGND VGND VPWR VPWR g_row\[0\].g_col\[1\].pe__1659_/A sky130_fd_sc_hd__xor2_2
XTAP_TAPCELL_ROW_40_806 VGND VPWR sky130_fd_sc_hd__tapvpwrvgnd_1
XTAP_TAPCELL_ROW_40_817 VGND VPWR sky130_fd_sc_hd__tapvpwrvgnd_1
Xg_row\[0\].g_col\[1\].pe__1587_ g_row\[0\].g_col\[1\].pe__1587_/A g_row\[0\].g_col\[1\].pe__1587_/B
+ VGND VGND VPWR VPWR g_row\[0\].g_col\[1\].pe__1594_/A sky130_fd_sc_hd__xor2_2
XTAP_TAPCELL_ROW_79_1395 VGND VPWR sky130_fd_sc_hd__tapvpwrvgnd_1
Xg_row\[0\].g_col\[1\].pe__2208_ g_row\[0\].g_col\[1\].pe__2703_/Q g_row\[0\].g_col\[1\].pe__1471_/X
+ g_row\[0\].g_col\[1\].pe__1474_/Y g_row\[0\].g_col\[1\].pe__1965_/A VGND VGND VPWR
+ VPWR g_row\[0\].g_col\[1\].pe__2209_/B sky130_fd_sc_hd__a22o_2
XFILLER_2_701 VGND VGND VPWR VPWR sky130_fd_sc_hd__decap_3
Xg_row\[0\].g_col\[1\].pe__2139_ g_row\[0\].g_col\[1\].pe__2621_/B g_row\[0\].g_col\[1\].pe__2313_/A2
+ g_row\[0\].g_col\[1\].pe__1541_/X g_row\[0\].g_col\[1\].pe__2177_/A1 VGND VGND VPWR
+ VPWR g_row\[0\].g_col\[1\].pe__2140_/B sky130_fd_sc_hd__a22o_2
XTAP_TAPCELL_ROW_9_344 VGND VPWR sky130_fd_sc_hd__tapvpwrvgnd_1
XTAP_TAPCELL_ROW_92_1584 VGND VPWR sky130_fd_sc_hd__tapvpwrvgnd_1
XTAP_TAPCELL_ROW_92_1595 VGND VPWR sky130_fd_sc_hd__tapvpwrvgnd_1
XFILLER_85_590 VGND VGND VPWR VPWR sky130_fd_sc_hd__decap_3
XTAP_TAPCELL_ROW_48_928 VGND VPWR sky130_fd_sc_hd__tapvpwrvgnd_1
XTAP_TAPCELL_ROW_28_630 VGND VPWR sky130_fd_sc_hd__tapvpwrvgnd_1
XFILLER_17_167 VGND VGND VPWR VPWR sky130_fd_sc_hd__fill_1
XFILLER_60_413 VGND VGND VPWR VPWR sky130_fd_sc_hd__decap_3
Xg_row\[0\].g_col\[0\].pe_hold3126 g_row\[0\].g_col\[0\].pe__2725_/Q VGND VGND VPWR
+ VPWR g_row\[0\].g_col\[0\].pe__2684_/A sky130_fd_sc_hd__clkbuf_2
XFILLER_32_115 VGND VGND VPWR VPWR sky130_fd_sc_hd__fill_1
Xg_row\[1\].g_col\[0\].pe__1982_ g_row\[1\].g_col\[0\].pe__2163_/A g_row\[1\].g_col\[0\].pe__1982_/B
+ VGND VGND VPWR VPWR g_row\[1\].g_col\[0\].pe__1985_/B sky130_fd_sc_hd__nand2_2
XFILLER_5_572 VGND VGND VPWR VPWR sky130_fd_sc_hd__decap_3
Xg_row\[1\].g_col\[0\].pe__2603_ g_row\[1\].g_col\[0\].pe__2639_/A g_row\[1\].g_col\[0\].pe__2603_/B
+ VGND VGND VPWR VPWR g_row\[1\].g_col\[0\].pe__2603_/X sky130_fd_sc_hd__or2_2
Xg_row\[0\].g_col\[0\].pe__1991_ g_row\[0\].g_col\[0\].pe__1991_/A g_row\[0\].g_col\[0\].pe__1991_/B
+ g_row\[0\].g_col\[0\].pe__1991_/C g_row\[0\].g_col\[0\].pe__1991_/D VGND VGND VPWR
+ VPWR g_row\[0\].g_col\[0\].pe__1991_/X sky130_fd_sc_hd__and4_4
Xg_row\[1\].g_col\[0\].pe__2534_ g_row\[1\].g_col\[0\].pe__2559_/A g_row\[1\].g_col\[0\].pe__2534_/B
+ g_row\[1\].g_col\[0\].pe__2534_/C VGND VGND VPWR VPWR g_row\[1\].g_col\[0\].pe__2534_/X
+ sky130_fd_sc_hd__or3_2
XFILLER_68_546 VGND VGND VPWR VPWR sky130_fd_sc_hd__decap_3
Xg_row\[1\].g_col\[1\].pe__2481_ g_row\[1\].g_col\[1\].pe__2494_/B g_row\[1\].g_col\[1\].pe__2585_/A
+ VGND VGND VPWR VPWR g_row\[1\].g_col\[1\].pe__2482_/B sky130_fd_sc_hd__nor2_2
Xg_row\[1\].g_col\[1\].pe__1501_ g_row\[1\].g_col\[1\].pe__1501_/A g_row\[1\].g_col\[1\].pe__1510_/B
+ VGND VGND VPWR VPWR g_row\[1\].g_col\[1\].pe__1640_/A sky130_fd_sc_hd__xnor2_2
Xg_row\[1\].g_col\[1\].pe__1432_ g_row\[1\].g_col\[1\].pe__1728_/A g_row\[1\].g_col\[1\].pe__1432_/B
+ VGND VGND VPWR VPWR g_row\[1\].g_col\[1\].pe__1481_/A sky130_fd_sc_hd__xnor2_2
Xg_row\[1\].g_col\[0\].pe__2465_ g_row\[1\].g_col\[0\].pe__2526_/A g_row\[1\].g_col\[0\].pe__2526_/B
+ g_row\[1\].g_col\[0\].pe__2464_/X g_row\[1\].g_col\[0\].pe__2458_/A VGND VGND VPWR
+ VPWR g_row\[1\].g_col\[0\].pe__2538_/C sky130_fd_sc_hd__a211o_2
XFILLER_83_538 VGND VGND VPWR VPWR sky130_fd_sc_hd__decap_3
Xg_row\[1\].g_col\[0\].pe__2396_ place1268/X g_row\[1\].g_col\[0\].pe__2396_/B VGND
+ VGND VPWR VPWR g_row\[1\].g_col\[0\].pe__2753_/D sky130_fd_sc_hd__nor2_8
Xg_row\[1\].g_col\[0\].pe__1416_ g_row\[1\].g_col\[0\].pe__2725_/Q g_row\[1\].g_col\[0\].pe__2724_/Q
+ VGND VGND VPWR VPWR g_row\[1\].g_col\[0\].pe__1416_/X sky130_fd_sc_hd__xor2_2
XFILLER_36_421 VGND VGND VPWR VPWR sky130_fd_sc_hd__decap_3
XFILLER_48_281 VGND VGND VPWR VPWR sky130_fd_sc_hd__fill_1
XFILLER_64_730 VGND VGND VPWR VPWR sky130_fd_sc_hd__decap_3
Xg_row\[0\].g_col\[0\].pe__2612_ g_row\[0\].g_col\[0\].pe__2623_/A place1212/A VGND
+ VGND VPWR VPWR g_row\[0\].g_col\[0\].pe__2612_/X sky130_fd_sc_hd__or2_2
Xg_row\[1\].g_col\[1\].pe__1363_ g_row\[1\].g_col\[1\].pe__2767_/Q g_row\[1\].g_col\[1\].pe__1363_/B
+ VGND VGND VPWR VPWR output1409/A sky130_fd_sc_hd__xnor2_2
Xg_row\[1\].g_col\[0\].pe__1347_ g_row\[1\].g_col\[0\].pe__2759_/Q g_row\[1\].g_col\[0\].pe__2758_/Q
+ g_row\[1\].g_col\[0\].pe__2757_/Q g_row\[1\].g_col\[0\].pe__2775_/A VGND VGND VPWR
+ VPWR g_row\[1\].g_col\[0\].pe__1348_/B sky130_fd_sc_hd__or4_2
XFILLER_23_126 VGND VGND VPWR VPWR sky130_fd_sc_hd__fill_2
Xg_row\[0\].g_col\[0\].pe__2474_ g_row\[0\].g_col\[0\].pe__2766_/Q g_row\[0\].g_col\[0\].pe__2474_/B
+ VGND VGND VPWR VPWR g_row\[0\].g_col\[0\].pe__2474_/Y sky130_fd_sc_hd__xnor2_2
Xg_row\[0\].g_col\[1\].pe__1510_ g_row\[0\].g_col\[1\].pe__1501_/A g_row\[0\].g_col\[1\].pe__1510_/B
+ VGND VGND VPWR VPWR g_row\[0\].g_col\[1\].pe__1510_/X sky130_fd_sc_hd__and2b_2
Xg_row\[0\].g_col\[1\].pe__2490_ g_row\[0\].g_col\[1\].pe__2490_/A g_row\[0\].g_col\[1\].pe__2490_/B
+ VGND VGND VPWR VPWR g_row\[0\].g_col\[1\].pe__2571_/A sky130_fd_sc_hd__nor2_2
XTAP_TAPCELL_ROW_63_1152 VGND VPWR sky130_fd_sc_hd__tapvpwrvgnd_1
Xg_row\[0\].g_col\[1\].pe__1441_ g_row\[0\].g_col\[1\].pe__1624_/A g_row\[0\].g_col\[1\].pe__1441_/B
+ VGND VGND VPWR VPWR g_row\[0\].g_col\[1\].pe__1442_/B sky130_fd_sc_hd__xor2_2
Xg_row\[0\].g_col\[0\].pe_hold2981 _320_/Q VGND VGND VPWR VPWR g_row\[0\].g_col\[0\].pe_hold2981/X
+ sky130_fd_sc_hd__clkbuf_2
Xg_row\[0\].g_col\[0\].pe__1356_ g_row\[0\].g_col\[0\].pe__2763_/Q g_row\[0\].g_col\[0\].pe__1355_/B
+ g_row\[0\].g_col\[0\].pe__2771_/Q VGND VGND VPWR VPWR g_row\[0\].g_col\[0\].pe__1357_/B
+ sky130_fd_sc_hd__o21a_2
Xg_row\[0\].g_col\[1\].pe__1372_ place1241/X _276_/Q VGND VGND VPWR VPWR g_row\[0\].g_col\[1\].pe__1372_/X
+ sky130_fd_sc_hd__and2_2
XTAP_TAPCELL_ROW_6_303 VGND VPWR sky130_fd_sc_hd__tapvpwrvgnd_1
Xg_row\[1\].g_col\[1\].pe__2748_ clkbuf_leaf_76_clk/X g_row\[1\].g_col\[1\].pe__2748_/D
+ VGND VGND VPWR VPWR g_row\[1\].g_col\[1\].pe__2748_/Q sky130_fd_sc_hd__dfxtp_2
XFILLER_59_524 VGND VGND VPWR VPWR sky130_fd_sc_hd__fill_1
Xg_row\[1\].g_col\[1\].pe__2679_ g_row\[1\].g_col\[1\].pe__2679_/A1 g_row\[1\].g_col\[1\].pe__2686_/B
+ g_row\[1\].g_col\[1\].pe__2678_/Y g_row\[1\].g_col\[1\].pe__2679_/C1 VGND VGND VPWR
+ VPWR g_row\[1\].g_col\[1\].pe__2679_/X sky130_fd_sc_hd__o211a_2
XFILLER_15_627 VGND VGND VPWR VPWR sky130_fd_sc_hd__decap_3
XFILLER_54_251 VGND VGND VPWR VPWR sky130_fd_sc_hd__fill_1
XFILLER_54_262 VGND VGND VPWR VPWR sky130_fd_sc_hd__decap_3
Xg_row\[0\].g_col\[1\].pe__2757_ _279_/CLK g_row\[0\].g_col\[1\].pe__2757_/D VGND
+ VGND VPWR VPWR g_row\[0\].g_col\[1\].pe__2757_/Q sky130_fd_sc_hd__dfxtp_2
XFILLER_70_755 VGND VGND VPWR VPWR sky130_fd_sc_hd__fill_1
X_310_ _314_/CLK _310_/D VGND VGND VPWR VPWR _310_/Q sky130_fd_sc_hd__dfxtp_2
Xg_row\[0\].g_col\[1\].pe__1708_ g_row\[0\].g_col\[1\].pe__1709_/A g_row\[0\].g_col\[1\].pe__1709_/B
+ VGND VGND VPWR VPWR g_row\[0\].g_col\[1\].pe__1714_/A sky130_fd_sc_hd__nand2_2
Xg_row\[0\].g_col\[1\].pe_hold1854 g_row\[0\].g_col\[1\].pe__2764_/Q VGND VGND VPWR
+ VPWR g_row\[0\].g_col\[1\].pe__2564_/A1 sky130_fd_sc_hd__clkbuf_2
Xg_row\[0\].g_col\[1\].pe__2688_ g_row\[0\].g_col\[1\].pe__2736_/Q g_row\[0\].g_col\[1\].pe__2737_/Q
+ g_row\[0\].g_col\[1\].pe__2688_/CIN VGND VGND VPWR VPWR g_row\[0\].g_col\[1\].pe__1901_/B1
+ g_row\[0\].g_col\[1\].pe_place937/A sky130_fd_sc_hd__fa_1
Xg_row\[0\].g_col\[1\].pe__1639_ g_row\[0\].g_col\[1\].pe__1840_/A g_row\[0\].g_col\[1\].pe__1840_/B
+ VGND VGND VPWR VPWR g_row\[0\].g_col\[1\].pe__1834_/A sky130_fd_sc_hd__xnor2_2
XFILLER_22_170 VGND VGND VPWR VPWR sky130_fd_sc_hd__decap_3
X_241_ _269_/A _241_/B_N VGND VGND VPWR VPWR _241_/Y sky130_fd_sc_hd__nor2b_4
XFILLER_10_365 VGND VGND VPWR VPWR sky130_fd_sc_hd__decap_3
XFILLER_2_597 VGND VGND VPWR VPWR sky130_fd_sc_hd__fill_1
XFILLER_38_719 VGND VGND VPWR VPWR sky130_fd_sc_hd__decap_3
XFILLER_65_505 VGND VGND VPWR VPWR sky130_fd_sc_hd__decap_3
Xg_row\[1\].g_col\[0\].pe__2250_ g_row\[1\].g_col\[0\].pe__2250_/A g_row\[1\].g_col\[0\].pe__2250_/B
+ VGND VGND VPWR VPWR g_row\[1\].g_col\[0\].pe__2251_/B sky130_fd_sc_hd__nand2_2
XFILLER_93_51 VGND VGND VPWR VPWR sky130_fd_sc_hd__fill_1
Xg_row\[1\].g_col\[0\].pe__2181_ g_row\[1\].g_col\[0\].pe__2181_/A g_row\[1\].g_col\[0\].pe__2181_/B
+ VGND VGND VPWR VPWR g_row\[1\].g_col\[0\].pe__2182_/B sky130_fd_sc_hd__xor2_2
XFILLER_18_498 VGND VGND VPWR VPWR sky130_fd_sc_hd__decap_3
XFILLER_61_733 VGND VGND VPWR VPWR sky130_fd_sc_hd__fill_2
XFILLER_73_582 VGND VGND VPWR VPWR sky130_fd_sc_hd__decap_3
Xg_row\[0\].g_col\[0\].pe_hold2255 g_row\[0\].g_col\[0\].pe__2681_/X VGND VGND VPWR
+ VPWR g_row\[0\].g_col\[0\].pe__2723_/D sky130_fd_sc_hd__clkbuf_2
Xg_row\[0\].g_col\[0\].pe_hold2266 g_row\[0\].g_col\[0\].pe__2594_/A1 VGND VGND VPWR
+ VPWR g_row\[0\].g_col\[0\].pe__2403_/A sky130_fd_sc_hd__clkbuf_2
Xg_row\[0\].g_col\[0\].pe_hold2277 g_row\[0\].g_col\[0\].pe__2687_/A1 VGND VGND VPWR
+ VPWR g_row\[0\].g_col\[0\].pe__2648_/A2 sky130_fd_sc_hd__clkbuf_2
Xg_row\[0\].g_col\[1\].pe_place825 g_row\[0\].g_col\[1\].pe__2590_/A VGND VGND VPWR
+ VPWR g_row\[0\].g_col\[1\].pe__2586_/A sky130_fd_sc_hd__buf_6
XTAP_TAPCELL_ROW_31_669 VGND VPWR sky130_fd_sc_hd__tapvpwrvgnd_1
Xclkbuf_leaf_40_clk clkbuf_4_6_0_clk/X VGND VGND VPWR VPWR clkbuf_leaf_40_clk/X sky130_fd_sc_hd__clkbuf_16
Xg_row\[0\].g_col\[0\].pe__2190_ g_row\[0\].g_col\[0\].pe__2190_/A g_row\[0\].g_col\[0\].pe__2190_/B
+ VGND VGND VPWR VPWR g_row\[0\].g_col\[0\].pe__2228_/B sky130_fd_sc_hd__nor2_2
Xg_row\[0\].g_col\[0\].pe_hold2288 g_row\[0\].g_col\[0\].pe_hold2312/X VGND VGND VPWR
+ VPWR g_row\[0\].g_col\[0\].pe__1387_/A sky130_fd_sc_hd__clkbuf_2
Xg_row\[0\].g_col\[0\].pe_hold2299 g_row\[0\].g_col\[0\].pe__2604_/X VGND VGND VPWR
+ VPWR g_row\[0\].g_col\[0\].pe__2691_/D sky130_fd_sc_hd__clkbuf_2
Xg_row\[0\].g_col\[1\].pe_place858 g_row\[0\].g_col\[1\].pe__1474_/Y VGND VGND VPWR
+ VPWR g_row\[0\].g_col\[1\].pe__2247_/B1 sky130_fd_sc_hd__buf_6
XFILLER_61_3 VGND VGND VPWR VPWR sky130_fd_sc_hd__fill_1
XTAP_TAPCELL_ROW_11_371 VGND VPWR sky130_fd_sc_hd__tapvpwrvgnd_1
XTAP_TAPCELL_ROW_11_382 VGND VPWR sky130_fd_sc_hd__tapvpwrvgnd_1
Xg_row\[1\].g_col\[1\].pe__1981_ g_row\[1\].g_col\[1\].pe__2725_/Q g_row\[1\].g_col\[1\].pe__2682_/A
+ g_row\[1\].g_col\[1\].pe__2704_/Q VGND VGND VPWR VPWR g_row\[1\].g_col\[1\].pe__1981_/Y
+ sky130_fd_sc_hd__nand3_2
Xg_row\[1\].g_col\[0\].pe__1965_ g_row\[1\].g_col\[0\].pe__1965_/A g_row\[1\].g_col\[0\].pe__2026_/B
+ VGND VGND VPWR VPWR g_row\[1\].g_col\[0\].pe__1968_/B sky130_fd_sc_hd__nand2_2
Xg_row\[1\].g_col\[0\].pe__1896_ g_row\[1\].g_col\[0\].pe__1896_/A g_row\[1\].g_col\[0\].pe__1885_/A
+ VGND VGND VPWR VPWR g_row\[1\].g_col\[0\].pe__1941_/A sky130_fd_sc_hd__or2b_2
Xhold3407 hold3407/A VGND VGND VPWR VPWR hold3407/X sky130_fd_sc_hd__clkbuf_2
Xoutput1368 output1368/A VGND VGND VPWR VPWR results_flat[21] sky130_fd_sc_hd__buf_2
Xoutput1357 output1357/A VGND VGND VPWR VPWR results_flat[11] sky130_fd_sc_hd__buf_2
Xhold3429 hold3429/A VGND VGND VPWR VPWR hold3429/X sky130_fd_sc_hd__clkbuf_2
Xhold3418 hold3418/A VGND VGND VPWR VPWR hold3418/X sky130_fd_sc_hd__clkbuf_2
Xhold2706 _233_/Y VGND VGND VPWR VPWR hold2706/X sky130_fd_sc_hd__clkbuf_2
Xhold2717 hold3472/X VGND VGND VPWR VPWR _173_/B_N sky130_fd_sc_hd__clkbuf_2
Xhold2728 hold3533/X VGND VGND VPWR VPWR hold3534/A sky130_fd_sc_hd__clkbuf_2
Xoutput1379 output1379/A VGND VGND VPWR VPWR results_flat[31] sky130_fd_sc_hd__buf_2
Xg_row\[1\].g_col\[1\].pe__2533_ g_row\[1\].g_col\[1\].pe__2533_/A g_row\[1\].g_col\[1\].pe__2533_/B
+ VGND VGND VPWR VPWR g_row\[1\].g_col\[1\].pe__2534_/C sky130_fd_sc_hd__and2_2
Xg_row\[0\].g_col\[1\].pe__1990_ g_row\[0\].g_col\[1\].pe__1988_/X g_row\[0\].g_col\[1\].pe__1987_/Y
+ g_row\[0\].g_col\[1\].pe__1981_/Y g_row\[0\].g_col\[1\].pe__1980_/X g_row\[0\].g_col\[1\].pe__1919_/B
+ VGND VGND VPWR VPWR g_row\[0\].g_col\[1\].pe__1991_/D sky130_fd_sc_hd__o2111ai_2
Xg_row\[0\].g_col\[0\].pe__1974_ g_row\[0\].g_col\[0\].pe__1974_/A g_row\[0\].g_col\[0\].pe__1974_/B
+ g_row\[0\].g_col\[0\].pe__1974_/C g_row\[0\].g_col\[0\].pe__1974_/D VGND VGND VPWR
+ VPWR g_row\[0\].g_col\[0\].pe__1978_/A sky130_fd_sc_hd__and4_4
Xhold2739 hold3503/X VGND VGND VPWR VPWR hold3504/A sky130_fd_sc_hd__clkbuf_2
Xg_row\[1\].g_col\[0\].pe__2517_ g_row\[1\].g_col\[0\].pe__2510_/X g_row\[1\].g_col\[0\].pe__2516_/X
+ g_row\[1\].g_col\[0\].pe__2403_/Y g_row\[1\].g_col\[0\].pe__1838_/X VGND VGND VPWR
+ VPWR g_row\[1\].g_col\[0\].pe__2517_/Y sky130_fd_sc_hd__a211oi_2
XFILLER_68_376 VGND VGND VPWR VPWR sky130_fd_sc_hd__fill_1
Xg_row\[1\].g_col\[1\].pe__2464_ g_row\[1\].g_col\[1\].pe__2759_/Q g_row\[1\].g_col\[1\].pe__2464_/B
+ VGND VGND VPWR VPWR g_row\[1\].g_col\[1\].pe__2464_/X sky130_fd_sc_hd__and2_2
Xg_row\[1\].g_col\[0\].pe__2448_ g_row\[1\].g_col\[0\].pe__2743_/Q VGND VGND VPWR
+ VPWR g_row\[1\].g_col\[0\].pe__2451_/A sky130_fd_sc_hd__inv_2
XFILLER_56_549 VGND VGND VPWR VPWR sky130_fd_sc_hd__decap_3
Xg_row\[1\].g_col\[1\].pe__2395_ g_row\[1\].g_col\[1\].pe__2404_/A1 g_row\[1\].g_col\[1\].pe__2395_/A2
+ g_row\[1\].g_col\[1\].pe__2393_/Y g_row\[1\].g_col\[1\].pe__2394_/X VGND VGND VPWR
+ VPWR g_row\[1\].g_col\[1\].pe__2396_/B sky130_fd_sc_hd__o22a_4
Xg_row\[1\].g_col\[1\].pe__1415_ g_row\[1\].g_col\[1\].pe__2725_/Q g_row\[1\].g_col\[1\].pe__2682_/A
+ g_row\[1\].g_col\[1\].pe__1785_/A VGND VGND VPWR VPWR g_row\[1\].g_col\[1\].pe__1415_/Y
+ sky130_fd_sc_hd__o21ai_2
Xg_row\[1\].g_col\[1\].pe__1346_ g_row\[1\].g_col\[1\].pe__2759_/Q g_row\[1\].g_col\[1\].pe__1346_/B
+ VGND VGND VPWR VPWR output1401/A sky130_fd_sc_hd__xor2_2
Xg_row\[1\].g_col\[0\].pe__2379_ g_row\[1\].g_col\[0\].pe__2356_/A g_row\[1\].g_col\[0\].pe__2375_/B
+ g_row\[1\].g_col\[0\].pe__2010_/A VGND VGND VPWR VPWR g_row\[1\].g_col\[0\].pe__2379_/Y
+ sky130_fd_sc_hd__a21oi_2
Xg_row\[0\].g_col\[1\].pe__2611_ g_row\[0\].g_col\[1\].pe__2624_/A1 place1213/X g_row\[0\].g_col\[1\].pe__2626_/B1
+ g_row\[0\].g_col\[1\].pe__2611_/C1 VGND VGND VPWR VPWR g_row\[0\].g_col\[1\].pe__2611_/X
+ sky130_fd_sc_hd__o211a_2
XFILLER_51_210 VGND VGND VPWR VPWR sky130_fd_sc_hd__fill_1
XFILLER_52_722 VGND VGND VPWR VPWR sky130_fd_sc_hd__decap_3
XFILLER_64_582 VGND VGND VPWR VPWR sky130_fd_sc_hd__decap_3
XFILLER_91_390 VGND VGND VPWR VPWR sky130_fd_sc_hd__fill_2
Xg_row\[0\].g_col\[1\].pe__2542_ g_row\[0\].g_col\[1\].pe__2592_/A g_row\[0\].g_col\[1\].pe__2542_/B
+ VGND VGND VPWR VPWR g_row\[0\].g_col\[1\].pe__2760_/D sky130_fd_sc_hd__and2_2
XTAP_TAPCELL_ROW_19_493 VGND VPWR sky130_fd_sc_hd__tapvpwrvgnd_1
Xg_row\[0\].g_col\[0\].pe__2526_ g_row\[0\].g_col\[0\].pe__2526_/A g_row\[0\].g_col\[0\].pe__2526_/B
+ VGND VGND VPWR VPWR g_row\[0\].g_col\[0\].pe__2526_/X sky130_fd_sc_hd__or2_2
XFILLER_11_129 VGND VGND VPWR VPWR sky130_fd_sc_hd__decap_3
Xg_row\[0\].g_col\[0\].pe__2457_ g_row\[0\].g_col\[0\].pe__2758_/Q g_row\[0\].g_col\[0\].pe__2457_/B
+ VGND VGND VPWR VPWR g_row\[0\].g_col\[0\].pe__2458_/B sky130_fd_sc_hd__and2b_2
Xg_row\[0\].g_col\[1\].pe__2473_ g_row\[0\].g_col\[1\].pe__2491_/B g_row\[0\].g_col\[1\].pe__2505_/A
+ g_row\[0\].g_col\[1\].pe__2491_/A VGND VGND VPWR VPWR g_row\[0\].g_col\[1\].pe__2492_/A
+ sky130_fd_sc_hd__o21ai_2
XTAP_TAPCELL_ROW_50_956 VGND VPWR sky130_fd_sc_hd__tapvpwrvgnd_1
XTAP_TAPCELL_ROW_50_967 VGND VPWR sky130_fd_sc_hd__tapvpwrvgnd_1
Xclkbuf_leaf_31_clk clkbuf_4_6_0_clk/X VGND VGND VPWR VPWR _324_/CLK sky130_fd_sc_hd__clkbuf_16
Xg_row\[0\].g_col\[0\].pe__1408_ place1269/X g_row\[0\].g_col\[0\].pe__1408_/B VGND
+ VGND VPWR VPWR g_row\[0\].g_col\[0\].pe__2738_/D sky130_fd_sc_hd__nor2_2
Xg_row\[0\].g_col\[0\].pe__2388_ g_row\[0\].g_col\[0\].pe__2388_/A g_row\[0\].g_col\[0\].pe__2388_/B
+ VGND VGND VPWR VPWR g_row\[0\].g_col\[0\].pe__2390_/A sky130_fd_sc_hd__nand2_2
Xg_row\[0\].g_col\[1\].pe__1424_ g_row\[0\].g_col\[1\].pe__1424_/A g_row\[0\].g_col\[1\].pe__1424_/B
+ VGND VGND VPWR VPWR g_row\[0\].g_col\[1\].pe__1424_/Y sky130_fd_sc_hd__nand2_2
Xg_row\[0\].g_col\[1\].pe__1355_ g_row\[0\].g_col\[1\].pe__2763_/Q g_row\[0\].g_col\[1\].pe__1355_/B
+ VGND VGND VPWR VPWR output1370/A sky130_fd_sc_hd__xor2_2
XFILLER_4_818 VGND VGND VPWR VPWR sky130_fd_sc_hd__fill_1
XTAP_TAPCELL_ROW_76_1343 VGND VPWR sky130_fd_sc_hd__tapvpwrvgnd_1
XTAP_TAPCELL_ROW_76_1354 VGND VPWR sky130_fd_sc_hd__tapvpwrvgnd_1
XFILLER_87_630 VGND VGND VPWR VPWR sky130_fd_sc_hd__fill_2
Xclkbuf_leaf_98_clk clkbuf_4_2_0_clk/X VGND VGND VPWR VPWR _340_/CLK sky130_fd_sc_hd__clkbuf_16
XFILLER_47_505 VGND VGND VPWR VPWR sky130_fd_sc_hd__decap_3
Xg_row\[0\].g_col\[1\].pe_hold2352 g_row\[0\].g_col\[1\].pe__2700_/Q VGND VGND VPWR
+ VPWR g_row\[0\].g_col\[1\].pe__2623_/B sky130_fd_sc_hd__clkbuf_2
Xg_row\[0\].g_col\[1\].pe_hold2341 place1195/X VGND VGND VPWR VPWR g_row\[0\].g_col\[1\].pe__2631_/A2
+ sky130_fd_sc_hd__clkbuf_2
Xg_row\[0\].g_col\[1\].pe_hold2330 g_row\[0\].g_col\[1\].pe__2514_/Y VGND VGND VPWR
+ VPWR g_row\[0\].g_col\[1\].pe__2756_/D sky130_fd_sc_hd__clkbuf_2
XFILLER_63_21 VGND VGND VPWR VPWR sky130_fd_sc_hd__fill_1
XTAP_TAPCELL_ROW_38_780 VGND VPWR sky130_fd_sc_hd__tapvpwrvgnd_1
Xg_row\[0\].g_col\[1\].pe_hold2396 g_row\[0\].g_col\[1\].pe__2774_/A VGND VGND VPWR
+ VPWR g_row\[0\].g_col\[1\].pe_hold2396/X sky130_fd_sc_hd__clkbuf_2
Xg_row\[0\].g_col\[1\].pe_hold2385 g_row\[0\].g_col\[1\].pe__2744_/Q VGND VGND VPWR
+ VPWR g_row\[0\].g_col\[1\].pe__2065_/A sky130_fd_sc_hd__clkbuf_2
Xg_row\[0\].g_col\[1\].pe_hold2374 g_row\[0\].g_col\[1\].pe__2306_/X VGND VGND VPWR
+ VPWR g_row\[0\].g_col\[1\].pe__2307_/B sky130_fd_sc_hd__clkbuf_2
XFILLER_63_43 VGND VGND VPWR VPWR sky130_fd_sc_hd__fill_2
XFILLER_70_552 VGND VGND VPWR VPWR sky130_fd_sc_hd__decap_3
XFILLER_70_596 VGND VGND VPWR VPWR sky130_fd_sc_hd__decap_3
Xclkbuf_leaf_22_clk clkload2/A VGND VGND VPWR VPWR clkbuf_leaf_22_clk/X sky130_fd_sc_hd__clkbuf_16
XFILLER_11_663 VGND VGND VPWR VPWR sky130_fd_sc_hd__fill_1
XFILLER_7_601 VGND VGND VPWR VPWR sky130_fd_sc_hd__fill_2
XFILLER_7_623 VGND VGND VPWR VPWR sky130_fd_sc_hd__decap_3
XFILLER_10_162 VGND VGND VPWR VPWR sky130_fd_sc_hd__fill_2
X_155_ _173_/A _155_/B_N VGND VGND VPWR VPWR _155_/Y sky130_fd_sc_hd__nor2b_4
Xg_row\[1\].g_col\[0\].pe__1750_ g_row\[1\].g_col\[0\].pe__1808_/A g_row\[1\].g_col\[0\].pe__1750_/B
+ VGND VGND VPWR VPWR g_row\[1\].g_col\[0\].pe__1756_/A sky130_fd_sc_hd__xnor2_2
XFILLER_88_40 VGND VGND VPWR VPWR sky130_fd_sc_hd__fill_1
Xg_row\[1\].g_col\[0\].pe__1681_ place1096/X g_row\[1\].g_col\[0\].pe__1729_/A2 g_row\[1\].g_col\[0\].pe__1729_/A3
+ g_row\[1\].g_col\[0\].pe__1729_/B1 place1093/X VGND VGND VPWR VPWR g_row\[1\].g_col\[0\].pe__1682_/B
+ sky130_fd_sc_hd__a32o_2
XFILLER_69_129 VGND VGND VPWR VPWR sky130_fd_sc_hd__fill_2
Xg_row\[1\].g_col\[0\].pe_hold2915 _303_/Q VGND VGND VPWR VPWR g_row\[1\].g_col\[0\].pe_hold2915/X
+ sky130_fd_sc_hd__clkbuf_2
XFILLER_66_803 VGND VGND VPWR VPWR sky130_fd_sc_hd__fill_1
Xclkbuf_leaf_89_clk clkload1/A VGND VGND VPWR VPWR clkload11/A sky130_fd_sc_hd__clkbuf_16
Xg_row\[1\].g_col\[0\].pe_hold2948 g_row\[1\].g_col\[0\].pe__2619_/X VGND VGND VPWR
+ VPWR g_row\[1\].g_col\[0\].pe_hold2948/X sky130_fd_sc_hd__clkbuf_2
Xg_row\[1\].g_col\[0\].pe_hold2926 g_row\[1\].g_col\[0\].pe_hold2926/A VGND VGND VPWR
+ VPWR g_row\[1\].g_col\[0\].pe__2626_/A2 sky130_fd_sc_hd__clkbuf_2
XFILLER_38_505 VGND VGND VPWR VPWR sky130_fd_sc_hd__fill_1
XFILLER_77_173 VGND VGND VPWR VPWR sky130_fd_sc_hd__fill_2
Xg_row\[1\].g_col\[0\].pe_hold2959 _293_/Q VGND VGND VPWR VPWR g_row\[1\].g_col\[0\].pe_hold2959/X
+ sky130_fd_sc_hd__clkbuf_2
Xg_row\[1\].g_col\[0\].pe__2302_ g_row\[1\].g_col\[0\].pe__2238_/X g_row\[1\].g_col\[0\].pe__2263_/B
+ g_row\[1\].g_col\[0\].pe__2261_/Y VGND VGND VPWR VPWR g_row\[1\].g_col\[0\].pe__2302_/Y
+ sky130_fd_sc_hd__a21oi_2
XFILLER_93_666 VGND VGND VPWR VPWR sky130_fd_sc_hd__fill_2
Xg_row\[0\].g_col\[0\].pe__1690_ g_row\[0\].g_col\[0\].pe__1690_/A g_row\[0\].g_col\[0\].pe__1690_/B
+ VGND VGND VPWR VPWR g_row\[0\].g_col\[0\].pe__1722_/B sky130_fd_sc_hd__xor2_2
Xg_row\[1\].g_col\[0\].pe__2233_ g_row\[1\].g_col\[0\].pe__2233_/A g_row\[1\].g_col\[0\].pe__2298_/A
+ g_row\[1\].g_col\[0\].pe__2233_/C VGND VGND VPWR VPWR g_row\[1\].g_col\[0\].pe__2233_/X
+ sky130_fd_sc_hd__and3_2
XFILLER_19_785 VGND VGND VPWR VPWR sky130_fd_sc_hd__fill_2
XFILLER_92_176 VGND VGND VPWR VPWR sky130_fd_sc_hd__fill_1
Xg_row\[1\].g_col\[1\].pe__2180_ g_row\[1\].g_col\[1\].pe__2213_/A g_row\[1\].g_col\[1\].pe__2213_/B
+ VGND VGND VPWR VPWR g_row\[1\].g_col\[1\].pe__2181_/B sky130_fd_sc_hd__xor2_2
Xg_row\[1\].g_col\[0\].pe__2164_ g_row\[1\].g_col\[0\].pe__1461_/A g_row\[1\].g_col\[0\].pe__1461_/B
+ g_row\[1\].g_col\[0\].pe__1983_/Y VGND VGND VPWR VPWR g_row\[1\].g_col\[0\].pe__2165_/C
+ sky130_fd_sc_hd__a21o_2
Xg_row\[1\].g_col\[0\].pe__2095_ g_row\[1\].g_col\[0\].pe__2184_/C g_row\[1\].g_col\[0\].pe__2095_/B
+ VGND VGND VPWR VPWR g_row\[1\].g_col\[0\].pe__2097_/A sky130_fd_sc_hd__nand2_2
XFILLER_61_596 VGND VGND VPWR VPWR sky130_fd_sc_hd__decap_3
XTAP_TAPCELL_ROW_16_452 VGND VPWR sky130_fd_sc_hd__tapvpwrvgnd_1
Xg_row\[0\].g_col\[0\].pe__2311_ g_row\[0\].g_col\[0\].pe__2311_/A g_row\[0\].g_col\[0\].pe__2311_/B
+ VGND VGND VPWR VPWR g_row\[0\].g_col\[0\].pe__2319_/A sky130_fd_sc_hd__nand2_2
XTAP_TAPCELL_ROW_60_1111 VGND VPWR sky130_fd_sc_hd__tapvpwrvgnd_1
Xclkbuf_leaf_13_clk clkbuf_4_0_0_clk/X VGND VGND VPWR VPWR clkbuf_leaf_13_clk/X sky130_fd_sc_hd__clkbuf_16
Xg_row\[0\].g_col\[0\].pe__2242_ g_row\[0\].g_col\[0\].pe__2083_/A g_row\[0\].g_col\[0\].pe__2279_/A2
+ g_row\[0\].g_col\[0\].pe__2279_/B1 g_row\[0\].g_col\[0\].pe__2030_/A VGND VGND VPWR
+ VPWR g_row\[0\].g_col\[0\].pe__2243_/B sky130_fd_sc_hd__a22o_2
Xg_row\[0\].g_col\[0\].pe_hold2096 g_row\[0\].g_col\[0\].pe__2568_/X VGND VGND VPWR
+ VPWR g_row\[0\].g_col\[0\].pe__2569_/B sky130_fd_sc_hd__clkbuf_2
Xg_row\[0\].g_col\[0\].pe__2173_ g_row\[0\].g_col\[0\].pe__2222_/A g_row\[0\].g_col\[0\].pe__2253_/A
+ VGND VGND VPWR VPWR g_row\[0\].g_col\[0\].pe__2183_/A sky130_fd_sc_hd__xnor2_2
Xg_row\[1\].g_col\[1\].pe__1964_ g_row\[1\].g_col\[1\].pe__1964_/A g_row\[1\].g_col\[1\].pe__1964_/B
+ VGND VGND VPWR VPWR g_row\[1\].g_col\[1\].pe__1997_/A sky130_fd_sc_hd__xnor2_2
Xg_row\[1\].g_col\[0\].pe__1948_ g_row\[1\].g_col\[0\].pe__2514_/A g_row\[1\].g_col\[0\].pe__1948_/B
+ VGND VGND VPWR VPWR g_row\[1\].g_col\[0\].pe__2741_/D sky130_fd_sc_hd__nor2_2
XTAP_TAPCELL_ROW_58_1073 VGND VPWR sky130_fd_sc_hd__tapvpwrvgnd_1
XTAP_TAPCELL_ROW_58_1084 VGND VPWR sky130_fd_sc_hd__tapvpwrvgnd_1
Xhold3204 hold3204/A VGND VGND VPWR VPWR hold3204/X sky130_fd_sc_hd__clkbuf_2
Xhold3215 hold3215/A VGND VGND VPWR VPWR hold3215/X sky130_fd_sc_hd__clkbuf_2
Xg_row\[1\].g_col\[1\].pe__1895_ g_row\[1\].g_col\[1\].pe__1843_/A g_row\[1\].g_col\[1\].pe__1843_/B
+ g_row\[1\].g_col\[1\].pe__1891_/B VGND VGND VPWR VPWR g_row\[1\].g_col\[1\].pe__1895_/X
+ sky130_fd_sc_hd__a21bo_2
Xg_row\[1\].g_col\[0\].pe__1879_ g_row\[1\].g_col\[0\].pe__1879_/A g_row\[1\].g_col\[0\].pe__1879_/B
+ VGND VGND VPWR VPWR g_row\[1\].g_col\[0\].pe__1879_/Y sky130_fd_sc_hd__nor2_2
Xhold2503 hold2503/A VGND VGND VPWR VPWR _285_/D sky130_fd_sc_hd__clkbuf_2
Xhold3226 hold3226/A VGND VGND VPWR VPWR hold3226/X sky130_fd_sc_hd__clkbuf_2
Xhold3237 hold3237/A VGND VGND VPWR VPWR hold3237/X sky130_fd_sc_hd__clkbuf_2
Xhold3248 hold3248/A VGND VGND VPWR VPWR hold3248/X sky130_fd_sc_hd__clkbuf_2
XTAP_TAPCELL_ROW_71_1273 VGND VPWR sky130_fd_sc_hd__tapvpwrvgnd_1
Xhold2514 _213_/Y VGND VGND VPWR VPWR hold2514/X sky130_fd_sc_hd__clkbuf_2
Xhold2525 hold3297/X VGND VGND VPWR VPWR _267_/B_N sky130_fd_sc_hd__clkbuf_2
Xhold2536 hold3260/X VGND VGND VPWR VPWR hold3261/A sky130_fd_sc_hd__clkbuf_2
Xhold2547 hold3272/X VGND VGND VPWR VPWR hold3273/A sky130_fd_sc_hd__clkbuf_2
Xhold3259 hold3259/A VGND VGND VPWR VPWR hold3259/X sky130_fd_sc_hd__clkbuf_2
XFILLER_29_505 VGND VGND VPWR VPWR sky130_fd_sc_hd__decap_3
Xg_row\[0\].g_col\[0\].pe__1957_ place1214/X g_row\[0\].g_col\[0\].pe__2278_/A2 g_row\[0\].g_col\[0\].pe__2278_/B1
+ g_row\[0\].g_col\[0\].pe__1957_/B2 VGND VGND VPWR VPWR g_row\[0\].g_col\[0\].pe__1961_/A
+ sky130_fd_sc_hd__a22o_2
Xhold2558 hold3326/X VGND VGND VPWR VPWR hold3327/A sky130_fd_sc_hd__clkbuf_2
Xhold2569 hold2569/A VGND VGND VPWR VPWR _337_/D sky130_fd_sc_hd__clkbuf_2
Xg_row\[1\].g_col\[1\].pe__2516_ g_row\[1\].g_col\[1\].pe__2503_/B g_row\[1\].g_col\[1\].pe__2516_/B
+ VGND VGND VPWR VPWR g_row\[1\].g_col\[1\].pe__2516_/X sky130_fd_sc_hd__and2b_2
Xg_row\[0\].g_col\[1\].pe__1973_ g_row\[0\].g_col\[1\].pe__1972_/B g_row\[0\].g_col\[1\].pe__1972_/C
+ g_row\[0\].g_col\[1\].pe__2123_/A VGND VGND VPWR VPWR g_row\[0\].g_col\[1\].pe__1974_/D
+ sky130_fd_sc_hd__a21o_2
XFILLER_56_346 VGND VGND VPWR VPWR sky130_fd_sc_hd__decap_3
Xg_row\[1\].g_col\[1\].pe__2447_ g_row\[1\].g_col\[1\].pe__2497_/B VGND VGND VPWR
+ VPWR g_row\[1\].g_col\[1\].pe__2551_/B sky130_fd_sc_hd__inv_2
XFILLER_83_143 VGND VGND VPWR VPWR sky130_fd_sc_hd__decap_3
Xg_row\[0\].g_col\[0\].pe__1888_ g_row\[0\].g_col\[0\].pe__1888_/A g_row\[0\].g_col\[0\].pe__1888_/B
+ g_row\[0\].g_col\[0\].pe__1888_/C VGND VGND VPWR VPWR g_row\[0\].g_col\[0\].pe__1889_/B
+ sky130_fd_sc_hd__nor3_2
XFILLER_25_733 VGND VGND VPWR VPWR sky130_fd_sc_hd__fill_1
Xg_row\[1\].g_col\[1\].pe__2378_ g_row\[1\].g_col\[1\].pe__2358_/A g_row\[1\].g_col\[1\].pe__2358_/B
+ g_row\[1\].g_col\[1\].pe__2377_/Y VGND VGND VPWR VPWR g_row\[1\].g_col\[1\].pe__2378_/X
+ sky130_fd_sc_hd__a21o_2
XFILLER_52_530 VGND VGND VPWR VPWR sky130_fd_sc_hd__fill_2
Xg_row\[0\].g_col\[0\].pe__2509_ g_row\[0\].g_col\[0\].pe__2503_/B g_row\[0\].g_col\[0\].pe__2486_/B
+ g_row\[0\].g_col\[0\].pe__2509_/S VGND VGND VPWR VPWR g_row\[0\].g_col\[0\].pe__2509_/X
+ sky130_fd_sc_hd__mux2_1
Xg_row\[0\].g_col\[1\].pe__2525_ g_row\[0\].g_col\[1\].pe__2526_/A g_row\[0\].g_col\[1\].pe__2526_/B
+ VGND VGND VPWR VPWR g_row\[0\].g_col\[1\].pe__2525_/Y sky130_fd_sc_hd__nand2_2
XFILLER_33_46 VGND VGND VPWR VPWR sky130_fd_sc_hd__decap_3
XFILLER_33_57 VGND VGND VPWR VPWR sky130_fd_sc_hd__fill_2
Xg_row\[0\].g_col\[1\].pe__2456_ g_row\[0\].g_col\[1\].pe__2457_/B g_row\[0\].g_col\[1\].pe__2758_/Q
+ VGND VGND VPWR VPWR g_row\[0\].g_col\[1\].pe__2458_/A sky130_fd_sc_hd__and2b_2
Xg_row\[0\].g_col\[1\].pe__1407_ _274_/Q g_row\[0\].g_col\[1\].pe__2157_/A g_row\[0\].g_col\[1\].pe__2406_/B1
+ g_row\[0\].g_col\[1\].pe__2404_/B1 VGND VGND VPWR VPWR g_row\[0\].g_col\[1\].pe__1407_/X
+ sky130_fd_sc_hd__o2bb2a_2
XFILLER_20_471 VGND VGND VPWR VPWR sky130_fd_sc_hd__fill_1
Xg_row\[0\].g_col\[1\].pe__2387_ g_row\[0\].g_col\[1\].pe__2387_/A g_row\[0\].g_col\[1\].pe__2387_/B
+ VGND VGND VPWR VPWR g_row\[0\].g_col\[1\].pe__2391_/A sky130_fd_sc_hd__nand2_2
XFILLER_58_21 VGND VGND VPWR VPWR sky130_fd_sc_hd__fill_2
XFILLER_79_449 VGND VGND VPWR VPWR sky130_fd_sc_hd__decap_3
XFILLER_48_803 VGND VGND VPWR VPWR sky130_fd_sc_hd__fill_1
XFILLER_87_482 VGND VGND VPWR VPWR sky130_fd_sc_hd__fill_1
XFILLER_47_335 VGND VGND VPWR VPWR sky130_fd_sc_hd__fill_1
XTAP_TAPCELL_ROW_89_1545 VGND VPWR sky130_fd_sc_hd__tapvpwrvgnd_1
XFILLER_47_357 VGND VGND VPWR VPWR sky130_fd_sc_hd__fill_1
XFILLER_90_603 VGND VGND VPWR VPWR sky130_fd_sc_hd__fill_2
XFILLER_16_722 VGND VGND VPWR VPWR sky130_fd_sc_hd__decap_3
XFILLER_74_75 VGND VGND VPWR VPWR sky130_fd_sc_hd__fill_1
XFILLER_16_755 VGND VGND VPWR VPWR sky130_fd_sc_hd__fill_1
XFILLER_55_390 VGND VGND VPWR VPWR sky130_fd_sc_hd__fill_2
XTAP_TAPCELL_ROW_33_709 VGND VPWR sky130_fd_sc_hd__tapvpwrvgnd_1
XTAP_TAPCELL_ROW_13_400 VGND VPWR sky130_fd_sc_hd__tapvpwrvgnd_1
XFILLER_30_235 VGND VGND VPWR VPWR sky130_fd_sc_hd__decap_3
XTAP_TAPCELL_ROW_13_411 VGND VPWR sky130_fd_sc_hd__tapvpwrvgnd_1
XFILLER_30_268 VGND VGND VPWR VPWR sky130_fd_sc_hd__decap_3
X_207_ _219_/A _207_/B_N VGND VGND VPWR VPWR _207_/Y sky130_fd_sc_hd__nor2b_4
Xg_row\[1\].g_col\[0\].pe__1802_ g_row\[1\].g_col\[0\].pe__1785_/A g_row\[1\].g_col\[0\].pe__1806_/B
+ g_row\[1\].g_col\[0\].pe__1801_/X VGND VGND VPWR VPWR g_row\[1\].g_col\[0\].pe__1807_/B
+ sky130_fd_sc_hd__a21o_2
Xg_row\[1\].g_col\[0\].pe__1733_ g_row\[1\].g_col\[0\].pe__1733_/A g_row\[1\].g_col\[0\].pe__1733_/B
+ VGND VGND VPWR VPWR g_row\[1\].g_col\[0\].pe__1758_/B sky130_fd_sc_hd__xor2_2
Xg_row\[1\].g_col\[1\].pe__1680_ g_row\[1\].g_col\[1\].pe__1728_/A g_row\[1\].g_col\[1\].pe__1680_/B
+ VGND VGND VPWR VPWR g_row\[1\].g_col\[1\].pe__1686_/A sky130_fd_sc_hd__xnor2_2
Xg_row\[1\].g_col\[0\].pe__1664_ g_row\[1\].g_col\[0\].pe__1664_/A g_row\[1\].g_col\[0\].pe__1659_/A
+ VGND VGND VPWR VPWR g_row\[1\].g_col\[0\].pe__1664_/X sky130_fd_sc_hd__or2b_2
XFILLER_66_600 VGND VGND VPWR VPWR sky130_fd_sc_hd__decap_3
Xclkbuf_leaf_2_clk clkbuf_4_0_0_clk/X VGND VGND VPWR VPWR _274_/CLK sky130_fd_sc_hd__clkbuf_16
Xg_row\[0\].g_col\[0\].pe__1811_ g_row\[0\].g_col\[0\].pe__1811_/A g_row\[0\].g_col\[0\].pe__1811_/B
+ g_row\[0\].g_col\[0\].pe__1811_/C g_row\[0\].g_col\[0\].pe__1780_/A VGND VGND VPWR
+ VPWR g_row\[0\].g_col\[0\].pe__1811_/X sky130_fd_sc_hd__or4b_4
Xg_row\[1\].g_col\[0\].pe__1595_ g_row\[1\].g_col\[0\].pe__1591_/A g_row\[1\].g_col\[0\].pe__1593_/Y
+ g_row\[1\].g_col\[0\].pe__1594_/Y VGND VGND VPWR VPWR g_row\[1\].g_col\[0\].pe__1844_/A
+ sky130_fd_sc_hd__o21ai_2
Xg_row\[1\].g_col\[1\].pe__2301_ g_row\[1\].g_col\[1\].pe__1894_/Y g_row\[1\].g_col\[1\].pe__1895_/X
+ g_row\[1\].g_col\[1\].pe__2151_/X g_row\[1\].g_col\[1\].pe__2300_/B VGND VGND VPWR
+ VPWR g_row\[1\].g_col\[1\].pe__2304_/B sky130_fd_sc_hd__a211o_4
XFILLER_26_508 VGND VGND VPWR VPWR sky130_fd_sc_hd__decap_3
XFILLER_53_305 VGND VGND VPWR VPWR sky130_fd_sc_hd__decap_3
XFILLER_93_463 VGND VGND VPWR VPWR sky130_fd_sc_hd__fill_1
Xg_row\[0\].g_col\[0\].pe__1742_ g_row\[0\].g_col\[0\].pe__1719_/Y g_row\[0\].g_col\[0\].pe__1742_/B
+ VGND VGND VPWR VPWR g_row\[0\].g_col\[0\].pe__1743_/A sky130_fd_sc_hd__nand2b_2
Xg_row\[0\].g_col\[0\].pe__1673_ g_row\[0\].g_col\[0\].pe__1864_/A g_row\[0\].g_col\[0\].pe__1673_/B
+ VGND VGND VPWR VPWR g_row\[0\].g_col\[0\].pe__1690_/B sky130_fd_sc_hd__xnor2_2
Xg_row\[1\].g_col\[1\].pe__2232_ g_row\[1\].g_col\[1\].pe__2161_/Y g_row\[1\].g_col\[1\].pe__2200_/B
+ g_row\[1\].g_col\[1\].pe__2231_/Y VGND VGND VPWR VPWR g_row\[1\].g_col\[1\].pe__2233_/C
+ sky130_fd_sc_hd__o21a_2
Xg_row\[1\].g_col\[0\].pe__2216_ g_row\[1\].g_col\[0\].pe__2030_/A g_row\[1\].g_col\[0\].pe__2313_/A2
+ g_row\[1\].g_col\[0\].pe__1541_/X place1086/X VGND VGND VPWR VPWR g_row\[1\].g_col\[0\].pe__2217_/B
+ sky130_fd_sc_hd__a22o_2
XFILLER_0_72 VGND VGND VPWR VPWR sky130_fd_sc_hd__fill_1
XFILLER_0_83 VGND VGND VPWR VPWR sky130_fd_sc_hd__fill_1
Xg_row\[1\].g_col\[1\].pe__2163_ g_row\[1\].g_col\[1\].pe__2163_/A g_row\[1\].g_col\[1\].pe__2163_/B
+ VGND VGND VPWR VPWR g_row\[1\].g_col\[1\].pe__2165_/B sky130_fd_sc_hd__nand2_2
Xg_row\[1\].g_col\[0\].pe__2147_ g_row\[1\].g_col\[0\].pe__2147_/A g_row\[1\].g_col\[0\].pe__2147_/B
+ VGND VGND VPWR VPWR g_row\[1\].g_col\[0\].pe__2162_/B sky130_fd_sc_hd__xor2_2
XFILLER_80_179 VGND VGND VPWR VPWR sky130_fd_sc_hd__fill_2
XFILLER_61_393 VGND VGND VPWR VPWR sky130_fd_sc_hd__fill_1
Xg_row\[1\].g_col\[1\].pe__2094_ g_row\[1\].g_col\[1\].pe__2094_/A g_row\[1\].g_col\[1\].pe__2094_/B
+ g_row\[1\].g_col\[1\].pe__2094_/C VGND VGND VPWR VPWR g_row\[1\].g_col\[1\].pe__2095_/B
+ sky130_fd_sc_hd__nand3_2
Xg_row\[1\].g_col\[0\].pe__2078_ g_row\[1\].g_col\[0\].pe__2078_/A g_row\[1\].g_col\[0\].pe__2078_/B
+ VGND VGND VPWR VPWR g_row\[1\].g_col\[0\].pe__2101_/A sky130_fd_sc_hd__xnor2_2
Xg_row\[0\].g_col\[1\].pe__2310_ g_row\[0\].g_col\[1\].pe__2318_/A g_row\[0\].g_col\[1\].pe__2310_/B
+ g_row\[0\].g_col\[1\].pe__2276_/B VGND VGND VPWR VPWR g_row\[0\].g_col\[1\].pe__2337_/A
+ sky130_fd_sc_hd__or3b_2
Xg_row\[0\].g_col\[1\].pe__2241_ g_row\[0\].g_col\[1\].pe__2241_/A1 g_row\[0\].g_col\[1\].pe__1558_/B
+ g_row\[0\].g_col\[1\].pe__2388_/B g_row\[0\].g_col\[1\].pe__2621_/B VGND VGND VPWR
+ VPWR g_row\[0\].g_col\[1\].pe__2277_/A sky130_fd_sc_hd__a22o_2
Xg_row\[0\].g_col\[0\].pe__2225_ g_row\[0\].g_col\[0\].pe__2174_/A g_row\[0\].g_col\[0\].pe__2174_/B
+ g_row\[0\].g_col\[0\].pe__2182_/B g_row\[0\].g_col\[0\].pe__2181_/B g_row\[0\].g_col\[0\].pe__2181_/A
+ VGND VGND VPWR VPWR g_row\[0\].g_col\[0\].pe__2226_/B sky130_fd_sc_hd__a32o_2
Xg_row\[0\].g_col\[0\].pe__2156_ g_row\[0\].g_col\[0\].pe__2155_/B g_row\[0\].g_col\[0\].pe__2300_/A
+ g_row\[0\].g_col\[0\].pe__2200_/A VGND VGND VPWR VPWR g_row\[0\].g_col\[0\].pe__2157_/B
+ sky130_fd_sc_hd__a21o_2
Xg_row\[0\].g_col\[1\].pe__2172_ g_row\[0\].g_col\[1\].pe__2172_/A g_row\[0\].g_col\[1\].pe__2172_/B
+ VGND VGND VPWR VPWR g_row\[0\].g_col\[1\].pe__2253_/A sky130_fd_sc_hd__xor2_2
XTAP_TAPCELL_ROW_73_1302 VGND VPWR sky130_fd_sc_hd__tapvpwrvgnd_1
Xg_row\[0\].g_col\[0\].pe__2087_ g_row\[0\].g_col\[0\].pe__2087_/A g_row\[0\].g_col\[0\].pe__2087_/B
+ g_row\[0\].g_col\[0\].pe__2087_/C g_row\[0\].g_col\[0\].pe__2087_/D VGND VGND VPWR
+ VPWR g_row\[0\].g_col\[0\].pe__2091_/A sky130_fd_sc_hd__nand4_2
Xg_row\[1\].g_col\[1\].pe__1947_ g_row\[1\].g_col\[1\].pe__1944_/Y g_row\[1\].g_col\[1\].pe__2008_/A
+ g_row\[1\].g_col\[1\].pe__1947_/B1 g_row\[1\].g_col\[1\].pe__2404_/A1 VGND VGND
+ VPWR VPWR g_row\[1\].g_col\[1\].pe__1948_/B sky130_fd_sc_hd__o2bb2a_2
Xhold3023 hold3023/A VGND VGND VPWR VPWR hold3023/X sky130_fd_sc_hd__clkbuf_2
Xg_row\[1\].g_col\[1\].pe__1878_ g_row\[1\].g_col\[1\].pe__1878_/A g_row\[1\].g_col\[1\].pe__1878_/B
+ VGND VGND VPWR VPWR g_row\[1\].g_col\[1\].pe__1936_/A sky130_fd_sc_hd__xnor2_2
Xhold1610 hold3546/X VGND VGND VPWR VPWR hold2771/A sky130_fd_sc_hd__clkbuf_2
Xhold1621 hold3590/X VGND VGND VPWR VPWR hold3591/A sky130_fd_sc_hd__clkbuf_2
Xhold1632 hold2808/X VGND VGND VPWR VPWR hold2809/A sky130_fd_sc_hd__clkbuf_2
Xg_row\[0\].g_col\[1\].pe__1956_ g_row\[0\].g_col\[1\].pe__1916_/A g_row\[0\].g_col\[1\].pe__1916_/B
+ g_row\[0\].g_col\[1\].pe__1955_/X VGND VGND VPWR VPWR g_row\[0\].g_col\[1\].pe__1963_/A
+ sky130_fd_sc_hd__a21o_2
XFILLER_57_666 VGND VGND VPWR VPWR sky130_fd_sc_hd__decap_3
XFILLER_72_614 VGND VGND VPWR VPWR sky130_fd_sc_hd__decap_3
XFILLER_84_463 VGND VGND VPWR VPWR sky130_fd_sc_hd__fill_2
XFILLER_84_474 VGND VGND VPWR VPWR sky130_fd_sc_hd__fill_2
Xg_row\[0\].g_col\[1\].pe__1887_ g_row\[0\].g_col\[1\].pe__1888_/A g_row\[0\].g_col\[1\].pe__1888_/B
+ g_row\[0\].g_col\[1\].pe__1888_/C VGND VGND VPWR VPWR g_row\[0\].g_col\[1\].pe__1951_/A
+ sky130_fd_sc_hd__o21a_2
XFILLER_25_552 VGND VGND VPWR VPWR sky130_fd_sc_hd__decap_3
XFILLER_44_349 VGND VGND VPWR VPWR sky130_fd_sc_hd__fill_1
XFILLER_71_135 VGND VGND VPWR VPWR sky130_fd_sc_hd__fill_2
XTAP_TAPCELL_ROW_84_1464 VGND VPWR sky130_fd_sc_hd__tapvpwrvgnd_1
XTAP_TAPCELL_ROW_84_1475 VGND VPWR sky130_fd_sc_hd__tapvpwrvgnd_1
Xg_row\[0\].g_col\[1\].pe__2508_ g_row\[0\].g_col\[1\].pe__2508_/A g_row\[0\].g_col\[1\].pe__2508_/B
+ VGND VGND VPWR VPWR g_row\[0\].g_col\[1\].pe__2508_/Y sky130_fd_sc_hd__xnor2_2
XFILLER_8_217 VGND VGND VPWR VPWR sky130_fd_sc_hd__fill_1
XFILLER_9_729 VGND VGND VPWR VPWR sky130_fd_sc_hd__decap_3
Xg_row\[0\].g_col\[0\].pe_place1202 place1201/A VGND VGND VPWR VPWR g_row\[0\].g_col\[0\].pe__1970_/A
+ sky130_fd_sc_hd__buf_6
Xg_row\[0\].g_col\[1\].pe__2439_ g_row\[0\].g_col\[1\].pe__2439_/A g_row\[0\].g_col\[1\].pe__2439_/B
+ VGND VGND VPWR VPWR g_row\[0\].g_col\[1\].pe__2439_/Y sky130_fd_sc_hd__xnor2_2
Xg_row\[0\].g_col\[0\].pe_place1224 g_row\[0\].g_col\[0\].pe__2595_/A VGND VGND VPWR
+ VPWR g_row\[0\].g_col\[0\].pe__2592_/A sky130_fd_sc_hd__buf_6
XFILLER_69_31 VGND VGND VPWR VPWR sky130_fd_sc_hd__decap_3
Xg_row\[1\].g_col\[1\].pe_hold2842 g_row\[1\].g_col\[1\].pe__2712_/Q VGND VGND VPWR
+ VPWR g_row\[1\].g_col\[1\].pe__2653_/B sky130_fd_sc_hd__clkbuf_2
XFILLER_79_202 VGND VGND VPWR VPWR sky130_fd_sc_hd__decap_3
Xg_row\[1\].g_col\[1\].pe_hold2864 g_row\[1\].g_col\[1\].pe__2658_/X VGND VGND VPWR
+ VPWR g_row\[1\].g_col\[1\].pe_hold2864/X sky130_fd_sc_hd__clkbuf_2
XFILLER_0_673 VGND VGND VPWR VPWR sky130_fd_sc_hd__decap_3
XFILLER_88_780 VGND VGND VPWR VPWR sky130_fd_sc_hd__fill_1
XFILLER_47_110 VGND VGND VPWR VPWR sky130_fd_sc_hd__fill_2
XFILLER_48_622 VGND VGND VPWR VPWR sky130_fd_sc_hd__decap_3
XFILLER_48_633 VGND VGND VPWR VPWR sky130_fd_sc_hd__decap_3
XFILLER_87_290 VGND VGND VPWR VPWR sky130_fd_sc_hd__fill_1
Xhold3590 hold3590/A VGND VGND VPWR VPWR hold3590/X sky130_fd_sc_hd__clkbuf_2
Xg_row\[1\].g_col\[0\].pe__1380_ g_row\[1\].g_col\[0\].pe__1380_/A1 g_row\[1\].g_col\[0\].pe__2684_/B
+ g_row\[1\].g_col\[0\].pe__1376_/X g_row\[1\].g_col\[0\].pe__2687_/C1 VGND VGND VPWR
+ VPWR g_row\[1\].g_col\[0\].pe__1380_/X sky130_fd_sc_hd__o211a_2
XFILLER_48_666 VGND VGND VPWR VPWR sky130_fd_sc_hd__decap_3
XFILLER_48_699 VGND VGND VPWR VPWR sky130_fd_sc_hd__fill_1
Xg_row\[1\].g_col\[0\].pe__2001_ g_row\[1\].g_col\[0\].pe__2014_/B g_row\[1\].g_col\[0\].pe__2001_/B
+ VGND VGND VPWR VPWR g_row\[1\].g_col\[0\].pe__2002_/B sky130_fd_sc_hd__xnor2_2
XFILLER_70_190 VGND VGND VPWR VPWR sky130_fd_sc_hd__fill_2
Xg_row\[0\].g_col\[0\].pe__2010_ g_row\[0\].g_col\[0\].pe__2010_/A g_row\[0\].g_col\[0\].pe__2010_/B
+ g_row\[0\].g_col\[0\].pe__2062_/A g_row\[0\].g_col\[0\].pe__2010_/D VGND VGND VPWR
+ VPWR g_row\[0\].g_col\[0\].pe__2010_/X sky130_fd_sc_hd__or4_4
Xg_row\[1\].g_col\[1\].pe__1801_ g_row\[1\].g_col\[1\].pe__2690_/Q g_row\[1\].g_col\[1\].pe__1801_/B
+ g_row\[1\].g_col\[1\].pe__1801_/C VGND VGND VPWR VPWR g_row\[1\].g_col\[1\].pe__1801_/X
+ sky130_fd_sc_hd__and3_2
Xg_row\[1\].g_col\[0\].pe__2765_ clkbuf_leaf_56_clk/X g_row\[1\].g_col\[0\].pe__2765_/D
+ VGND VGND VPWR VPWR g_row\[1\].g_col\[0\].pe__2765_/Q sky130_fd_sc_hd__dfxtp_2
XTAP_TAPCELL_ROW_55_1032 VGND VPWR sky130_fd_sc_hd__tapvpwrvgnd_1
Xg_row\[1\].g_col\[1\].pe__1732_ g_row\[1\].g_col\[1\].pe__2605_/B g_row\[1\].g_col\[1\].pe__1732_/A2
+ g_row\[1\].g_col\[1\].pe__1732_/B1 g_row\[1\].g_col\[1\].pe__1805_/A2 VGND VGND
+ VPWR VPWR g_row\[1\].g_col\[1\].pe__1733_/B sky130_fd_sc_hd__a22o_2
Xg_row\[1\].g_col\[0\].pe__1716_ hold2198/A g_row\[1\].g_col\[0\].pe__1748_/B g_row\[1\].g_col\[0\].pe__1738_/B1
+ place1104/X VGND VGND VPWR VPWR g_row\[1\].g_col\[0\].pe__1717_/B sky130_fd_sc_hd__a22o_2
Xg_row\[1\].g_col\[1\].pe__1663_ g_row\[1\].g_col\[1\].pe__1663_/A g_row\[1\].g_col\[1\].pe__1663_/B
+ VGND VGND VPWR VPWR g_row\[1\].g_col\[1\].pe__1697_/B sky130_fd_sc_hd__xnor2_2
Xg_row\[1\].g_col\[0\].pe__2696_ _308_/CLK g_row\[1\].g_col\[0\].pe__2696_/D VGND
+ VGND VPWR VPWR place1094/A sky130_fd_sc_hd__dfxtp_2
XFILLER_58_408 VGND VGND VPWR VPWR sky130_fd_sc_hd__decap_3
XFILLER_79_780 VGND VGND VPWR VPWR sky130_fd_sc_hd__decap_3
XPHY_EDGE_ROW_7_Right_7 VGND VGND VPWR VPWR sky130_fd_sc_hd__decap_3
Xg_row\[1\].g_col\[0\].pe__1647_ g_row\[1\].g_col\[0\].pe__1733_/A g_row\[1\].g_col\[0\].pe__1647_/B
+ VGND VGND VPWR VPWR g_row\[1\].g_col\[0\].pe__1688_/B sky130_fd_sc_hd__xor2_2
XFILLER_66_430 VGND VGND VPWR VPWR sky130_fd_sc_hd__fill_2
Xg_row\[1\].g_col\[1\].pe__1594_ g_row\[1\].g_col\[1\].pe__1594_/A g_row\[1\].g_col\[1\].pe__1594_/B
+ VGND VGND VPWR VPWR g_row\[1\].g_col\[1\].pe__1594_/Y sky130_fd_sc_hd__nand2_2
Xg_row\[1\].g_col\[0\].pe_hold1830 g_row\[1\].g_col\[0\].pe__2554_/X VGND VGND VPWR
+ VPWR g_row\[1\].g_col\[0\].pe__2555_/B sky130_fd_sc_hd__clkbuf_2
Xg_row\[1\].g_col\[0\].pe__1578_ g_row\[1\].g_col\[0\].pe__2125_/C g_row\[1\].g_col\[0\].pe__1578_/B
+ VGND VGND VPWR VPWR g_row\[1\].g_col\[0\].pe__1579_/B sky130_fd_sc_hd__xor2_2
Xg_row\[0\].g_col\[1\].pe__1810_ g_row\[0\].g_col\[1\].pe__1811_/A g_row\[0\].g_col\[1\].pe__1811_/B
+ g_row\[0\].g_col\[1\].pe__1803_/Y g_row\[0\].g_col\[1\].pe__1808_/X g_row\[0\].g_col\[1\].pe__1809_/X
+ VGND VGND VPWR VPWR g_row\[0\].g_col\[1\].pe__1810_/X sky130_fd_sc_hd__o41a_2
Xg_row\[1\].g_col\[0\].pe_hold1863 g_row\[1\].g_col\[0\].pe__2608_/X VGND VGND VPWR
+ VPWR g_row\[1\].g_col\[0\].pe__2693_/D sky130_fd_sc_hd__clkbuf_2
Xg_row\[1\].g_col\[0\].pe_hold1841 g_row\[1\].g_col\[0\].pe_hold3117/X VGND VGND VPWR
+ VPWR g_row\[1\].g_col\[0\].pe__1950_/B sky130_fd_sc_hd__clkbuf_2
Xg_row\[0\].g_col\[1\].pe_hold2907 g_row\[0\].g_col\[1\].pe__2675_/Y VGND VGND VPWR
+ VPWR g_row\[0\].g_col\[1\].pe__2678_/B sky130_fd_sc_hd__clkbuf_2
XFILLER_53_113 VGND VGND VPWR VPWR sky130_fd_sc_hd__fill_2
Xg_row\[0\].g_col\[0\].pe__1725_ g_row\[0\].g_col\[0\].pe__1723_/A g_row\[0\].g_col\[0\].pe__1723_/B
+ g_row\[0\].g_col\[0\].pe__1745_/B g_row\[0\].g_col\[0\].pe__1745_/A VGND VGND VPWR
+ VPWR g_row\[0\].g_col\[0\].pe__1726_/B sky130_fd_sc_hd__a22oi_2
Xg_row\[0\].g_col\[1\].pe__1741_ g_row\[0\].g_col\[1\].pe__1776_/A g_row\[0\].g_col\[1\].pe__1776_/B
+ g_row\[0\].g_col\[1\].pe__1740_/Y VGND VGND VPWR VPWR g_row\[0\].g_col\[1\].pe__1815_/B
+ sky130_fd_sc_hd__a21oi_2
Xg_row\[1\].g_col\[0\].pe_hold1885 g_row\[1\].g_col\[0\].pe__1400_/X VGND VGND VPWR
+ VPWR g_row\[1\].g_col\[0\].pe__1401_/B1 sky130_fd_sc_hd__clkbuf_2
Xg_row\[1\].g_col\[0\].pe_hold1874 g_row\[1\].g_col\[0\].pe_hold3046/X VGND VGND VPWR
+ VPWR g_row\[1\].g_col\[0\].pe_hold3047/A sky130_fd_sc_hd__clkbuf_2
XFILLER_54_669 VGND VGND VPWR VPWR sky130_fd_sc_hd__decap_3
Xg_row\[0\].g_col\[1\].pe__1672_ g_row\[0\].g_col\[1\].pe__1805_/A2 g_row\[0\].g_col\[1\].pe__1715_/B
+ g_row\[0\].g_col\[1\].pe__1863_/B1 g_row\[0\].g_col\[1\].pe__2599_/B VGND VGND VPWR
+ VPWR g_row\[0\].g_col\[1\].pe__1673_/B sky130_fd_sc_hd__a22o_2
Xg_row\[1\].g_col\[1\].pe__2215_ g_row\[1\].g_col\[1\].pe__2241_/B2 g_row\[1\].g_col\[1\].pe__2363_/A2
+ g_row\[1\].g_col\[1\].pe__2388_/B g_row\[1\].g_col\[1\].pe__2215_/B2 VGND VGND VPWR
+ VPWR g_row\[1\].g_col\[1\].pe__2239_/A sky130_fd_sc_hd__a22o_2
Xg_row\[0\].g_col\[0\].pe__1656_ g_row\[0\].g_col\[0\].pe__1656_/A g_row\[0\].g_col\[0\].pe__1656_/B
+ VGND VGND VPWR VPWR g_row\[0\].g_col\[0\].pe__1659_/A sky130_fd_sc_hd__xor2_2
XTAP_TAPCELL_ROW_66_1194 VGND VPWR sky130_fd_sc_hd__tapvpwrvgnd_1
Xg_row\[0\].g_col\[0\].pe__1587_ g_row\[0\].g_col\[0\].pe__1587_/A g_row\[0\].g_col\[0\].pe__1587_/B
+ VGND VGND VPWR VPWR g_row\[0\].g_col\[0\].pe__1594_/A sky130_fd_sc_hd__xor2_2
Xg_row\[1\].g_col\[1\].pe__2146_ g_row\[1\].g_col\[1\].pe__2192_/A g_row\[1\].g_col\[1\].pe__2192_/B
+ VGND VGND VPWR VPWR g_row\[1\].g_col\[1\].pe__2147_/B sky130_fd_sc_hd__xor2_2
XFILLER_22_555 VGND VGND VPWR VPWR sky130_fd_sc_hd__decap_3
Xg_row\[1\].g_col\[1\].pe__2077_ g_row\[1\].g_col\[1\].pe__2077_/A g_row\[1\].g_col\[1\].pe__2119_/B
+ VGND VGND VPWR VPWR g_row\[1\].g_col\[1\].pe__2078_/B sky130_fd_sc_hd__xnor2_2
Xg_row\[0\].g_col\[0\].pe__2208_ g_row\[0\].g_col\[0\].pe__2121_/A g_row\[0\].g_col\[0\].pe__1471_/X
+ g_row\[0\].g_col\[0\].pe__1474_/Y g_row\[0\].g_col\[0\].pe__2083_/A VGND VGND VPWR
+ VPWR g_row\[0\].g_col\[0\].pe__2209_/B sky130_fd_sc_hd__a22o_2
Xg_row\[0\].g_col\[1\].pe__2224_ g_row\[0\].g_col\[1\].pe__2258_/A g_row\[0\].g_col\[1\].pe__2258_/B
+ VGND VGND VPWR VPWR g_row\[0\].g_col\[1\].pe__2226_/A sky130_fd_sc_hd__xor2_2
Xg_row\[0\].g_col\[1\].pe__2155_ g_row\[0\].g_col\[1\].pe__2200_/A g_row\[0\].g_col\[1\].pe__2155_/B
+ g_row\[0\].g_col\[1\].pe__2300_/A VGND VGND VPWR VPWR g_row\[0\].g_col\[1\].pe__2155_/X
+ sky130_fd_sc_hd__and3_2
Xg_row\[0\].g_col\[0\].pe__2139_ g_row\[0\].g_col\[0\].pe__2241_/B2 g_row\[0\].g_col\[0\].pe__2279_/A2
+ g_row\[0\].g_col\[0\].pe__2279_/B1 g_row\[0\].g_col\[0\].pe__2215_/B2 VGND VGND
+ VPWR VPWR g_row\[0\].g_col\[0\].pe__2140_/B sky130_fd_sc_hd__a22o_2
Xg_row\[0\].g_col\[1\].pe__2086_ g_row\[0\].g_col\[1\].pe__2085_/B g_row\[0\].g_col\[1\].pe__2085_/C
+ g_row\[0\].g_col\[1\].pe__2123_/A VGND VGND VPWR VPWR g_row\[0\].g_col\[1\].pe__2087_/D
+ sky130_fd_sc_hd__a21o_2
XFILLER_77_706 VGND VGND VPWR VPWR sky130_fd_sc_hd__decap_3
XFILLER_89_533 VGND VGND VPWR VPWR sky130_fd_sc_hd__fill_1
XFILLER_89_599 VGND VGND VPWR VPWR sky130_fd_sc_hd__fill_2
XFILLER_39_67 VGND VGND VPWR VPWR sky130_fd_sc_hd__fill_2
XFILLER_76_238 VGND VGND VPWR VPWR sky130_fd_sc_hd__fill_1
Xhold2141 hold2990/X VGND VGND VPWR VPWR hold2141/X sky130_fd_sc_hd__clkbuf_2
XTAP_TAPCELL_ROW_4_264 VGND VPWR sky130_fd_sc_hd__tapvpwrvgnd_1
XTAP_TAPCELL_ROW_4_275 VGND VPWR sky130_fd_sc_hd__tapvpwrvgnd_1
XTAP_TAPCELL_ROW_86_1504 VGND VPWR sky130_fd_sc_hd__tapvpwrvgnd_1
Xhold1440 hold2424/X VGND VGND VPWR VPWR hold2425/A sky130_fd_sc_hd__clkbuf_2
Xhold1451 hold3212/X VGND VGND VPWR VPWR hold3213/A sky130_fd_sc_hd__clkbuf_2
Xhold2185 hold2185/A VGND VGND VPWR VPWR hold2185/X sky130_fd_sc_hd__clkbuf_2
XFILLER_29_176 VGND VGND VPWR VPWR sky130_fd_sc_hd__decap_3
XFILLER_45_614 VGND VGND VPWR VPWR sky130_fd_sc_hd__fill_2
Xhold1462 hold3159/X VGND VGND VPWR VPWR hold3160/A sky130_fd_sc_hd__clkbuf_2
Xhold1473 hold2484/X VGND VGND VPWR VPWR hold2485/A sky130_fd_sc_hd__clkbuf_2
Xhold1484 hold3254/X VGND VGND VPWR VPWR hold3255/A sky130_fd_sc_hd__clkbuf_2
Xhold1495 hold3285/X VGND VGND VPWR VPWR hold3286/A sky130_fd_sc_hd__clkbuf_2
Xg_row\[0\].g_col\[1\].pe__1939_ g_row\[0\].g_col\[1\].pe__1939_/A g_row\[0\].g_col\[1\].pe__1939_/B
+ VGND VGND VPWR VPWR g_row\[0\].g_col\[1\].pe__1941_/C sky130_fd_sc_hd__xnor2_2
XFILLER_55_55 VGND VGND VPWR VPWR sky130_fd_sc_hd__fill_1
Xg_row\[1\].g_col\[0\].pe_place823 g_row\[1\].g_col\[0\].pe__2510_/X VGND VGND VPWR
+ VPWR g_row\[1\].g_col\[0\].pe__2590_/A sky130_fd_sc_hd__buf_6
Xg_row\[1\].g_col\[0\].pe_place845 g_row\[1\].g_col\[0\].pe__2313_/A2 VGND VGND VPWR
+ VPWR g_row\[1\].g_col\[0\].pe__1549_/B sky130_fd_sc_hd__buf_6
XTAP_TAPCELL_ROW_43_848 VGND VPWR sky130_fd_sc_hd__tapvpwrvgnd_1
XTAP_TAPCELL_ROW_43_859 VGND VPWR sky130_fd_sc_hd__tapvpwrvgnd_1
XTAP_TAPCELL_ROW_23_550 VGND VPWR sky130_fd_sc_hd__tapvpwrvgnd_1
XFILLER_9_559 VGND VGND VPWR VPWR sky130_fd_sc_hd__fill_1
XTAP_TAPCELL_ROW_23_561 VGND VPWR sky130_fd_sc_hd__tapvpwrvgnd_1
Xinput1350 hold3504/X VGND VGND VPWR VPWR hold3505/A sky130_fd_sc_hd__buf_2
XFILLER_5_754 VGND VGND VPWR VPWR sky130_fd_sc_hd__decap_3
XFILLER_4_264 VGND VGND VPWR VPWR sky130_fd_sc_hd__fill_1
Xg_row\[1\].g_col\[1\].pe_hold1982 g_row\[1\].g_col\[1\].pe__2604_/X VGND VGND VPWR
+ VPWR g_row\[1\].g_col\[1\].pe__2691_/D sky130_fd_sc_hd__clkbuf_2
Xg_row\[1\].g_col\[1\].pe_hold1960 g_row\[1\].g_col\[1\].pe_hold3071/X VGND VGND VPWR
+ VPWR g_row\[1\].g_col\[1\].pe__1399_/A1 sky130_fd_sc_hd__clkbuf_2
Xg_row\[1\].g_col\[0\].pe__2481_ g_row\[1\].g_col\[0\].pe__2494_/B g_row\[1\].g_col\[0\].pe__2585_/A
+ VGND VGND VPWR VPWR g_row\[1\].g_col\[0\].pe__2482_/B sky130_fd_sc_hd__nor2_2
Xg_row\[1\].g_col\[0\].pe__1501_ g_row\[1\].g_col\[0\].pe__1501_/A g_row\[1\].g_col\[0\].pe__1510_/B
+ VGND VGND VPWR VPWR g_row\[1\].g_col\[0\].pe__1640_/A sky130_fd_sc_hd__xnor2_2
Xg_row\[1\].g_col\[0\].pe__1432_ g_row\[1\].g_col\[0\].pe__1642_/A g_row\[1\].g_col\[0\].pe__1432_/B
+ VGND VGND VPWR VPWR g_row\[1\].g_col\[0\].pe__1481_/A sky130_fd_sc_hd__xnor2_2
Xg_row\[1\].g_col\[0\].pe__1363_ g_row\[1\].g_col\[0\].pe__2767_/Q g_row\[1\].g_col\[0\].pe__1363_/B
+ VGND VGND VPWR VPWR output1392/A sky130_fd_sc_hd__xnor2_2
XFILLER_35_113 VGND VGND VPWR VPWR sky130_fd_sc_hd__fill_1
XFILLER_36_625 VGND VGND VPWR VPWR sky130_fd_sc_hd__fill_2
Xg_row\[0\].g_col\[0\].pe__1510_ g_row\[0\].g_col\[0\].pe__1501_/A g_row\[0\].g_col\[0\].pe__1510_/B
+ VGND VGND VPWR VPWR g_row\[0\].g_col\[0\].pe__1510_/X sky130_fd_sc_hd__and2b_2
XFILLER_51_617 VGND VGND VPWR VPWR sky130_fd_sc_hd__decap_3
Xg_row\[0\].g_col\[0\].pe__2490_ g_row\[0\].g_col\[0\].pe__2490_/A g_row\[0\].g_col\[0\].pe__2490_/B
+ VGND VGND VPWR VPWR g_row\[0\].g_col\[0\].pe__2571_/A sky130_fd_sc_hd__nor2_2
Xg_row\[1\].g_col\[1\].pe__2000_ g_row\[1\].g_col\[1\].pe__1935_/A g_row\[1\].g_col\[1\].pe__1998_/X
+ g_row\[1\].g_col\[1\].pe__1999_/X VGND VGND VPWR VPWR g_row\[1\].g_col\[1\].pe__2001_/B
+ sky130_fd_sc_hd__o21a_2
XFILLER_51_639 VGND VGND VPWR VPWR sky130_fd_sc_hd__decap_3
Xg_row\[0\].g_col\[0\].pe__1441_ g_row\[0\].g_col\[0\].pe__1789_/A g_row\[0\].g_col\[0\].pe__1441_/B
+ VGND VGND VPWR VPWR g_row\[0\].g_col\[0\].pe__1442_/B sky130_fd_sc_hd__xor2_2
Xg_row\[0\].g_col\[0\].pe__1372_ place1262/X _276_/Q VGND VGND VPWR VPWR g_row\[0\].g_col\[0\].pe__2684_/B
+ sky130_fd_sc_hd__and2_2
XFILLER_8_592 VGND VGND VPWR VPWR sky130_fd_sc_hd__fill_2
Xg_row\[1\].g_col\[1\].pe__2764_ clkbuf_leaf_75_clk/X g_row\[1\].g_col\[1\].pe__2764_/D
+ VGND VGND VPWR VPWR g_row\[1\].g_col\[1\].pe__2764_/Q sky130_fd_sc_hd__dfxtp_2
Xg_row\[1\].g_col\[1\].pe__1715_ g_row\[1\].g_col\[1\].pe__2599_/B g_row\[1\].g_col\[1\].pe__1715_/B
+ VGND VGND VPWR VPWR g_row\[1\].g_col\[1\].pe__1724_/S sky130_fd_sc_hd__nand2_2
Xg_row\[1\].g_col\[0\].pe__2748_ clkbuf_leaf_54_clk/X g_row\[1\].g_col\[0\].pe__2748_/D
+ VGND VGND VPWR VPWR g_row\[1\].g_col\[0\].pe__2748_/Q sky130_fd_sc_hd__dfxtp_2
XFILLER_59_706 VGND VGND VPWR VPWR sky130_fd_sc_hd__fill_1
Xg_row\[1\].g_col\[1\].pe__2695_ clkbuf_leaf_70_clk/X g_row\[1\].g_col\[1\].pe__2695_/D
+ VGND VGND VPWR VPWR g_row\[1\].g_col\[1\].pe__2695_/Q sky130_fd_sc_hd__dfxtp_2
Xg_row\[1\].g_col\[0\].pe__2679_ g_row\[1\].g_col\[0\].pe__2398_/A g_row\[1\].g_col\[0\].pe__2679_/A2
+ g_row\[1\].g_col\[0\].pe__2678_/Y g_row\[1\].g_col\[0\].pe__2679_/C1 VGND VGND VPWR
+ VPWR g_row\[1\].g_col\[0\].pe__2679_/X sky130_fd_sc_hd__o211a_2
Xg_row\[1\].g_col\[1\].pe__1646_ g_row\[1\].g_col\[1\].pe__2612_/B g_row\[1\].g_col\[1\].pe__1732_/A2
+ g_row\[1\].g_col\[1\].pe__1732_/B1 g_row\[1\].g_col\[1\].pe__2694_/Q VGND VGND VPWR
+ VPWR g_row\[1\].g_col\[1\].pe__1647_/B sky130_fd_sc_hd__a22o_2
Xg_row\[1\].g_col\[1\].pe__1577_ g_row\[1\].g_col\[1\].pe__1970_/A g_row\[1\].g_col\[1\].pe__1982_/B
+ g_row\[1\].g_col\[1\].pe__1424_/Y g_row\[1\].g_col\[1\].pe__1608_/A1 VGND VGND VPWR
+ VPWR g_row\[1\].g_col\[1\].pe__1578_/B sky130_fd_sc_hd__a22o_2
Xg_row\[1\].g_col\[0\].pe_hold3095 g_row\[1\].g_col\[0\].pe__1384_/X VGND VGND VPWR
+ VPWR g_row\[1\].g_col\[0\].pe_hold3095/X sky130_fd_sc_hd__clkbuf_2
XFILLER_27_636 VGND VGND VPWR VPWR sky130_fd_sc_hd__decap_3
XTAP_TAPCELL_ROW_1_223 VGND VPWR sky130_fd_sc_hd__tapvpwrvgnd_1
XTAP_TAPCELL_ROW_68_1223 VGND VPWR sky130_fd_sc_hd__tapvpwrvgnd_1
Xg_row\[1\].g_col\[0\].pe_hold1660 g_row\[1\].g_col\[0\].pe__2770_/Q VGND VGND VPWR
+ VPWR g_row\[1\].g_col\[0\].pe__2591_/A1 sky130_fd_sc_hd__clkbuf_2
XFILLER_27_658 VGND VGND VPWR VPWR sky130_fd_sc_hd__decap_3
XFILLER_27_669 VGND VGND VPWR VPWR sky130_fd_sc_hd__decap_3
XTAP_TAPCELL_ROW_68_1234 VGND VPWR sky130_fd_sc_hd__tapvpwrvgnd_1
Xg_row\[0\].g_col\[0\].pe__2757_ clkbuf_leaf_32_clk/X g_row\[0\].g_col\[0\].pe__2757_/D
+ VGND VGND VPWR VPWR g_row\[0\].g_col\[0\].pe__2757_/Q sky130_fd_sc_hd__dfxtp_2
Xg_row\[0\].g_col\[1\].pe__1724_ g_row\[0\].g_col\[1\].pe__1718_/B g_row\[0\].g_col\[1\].pe__2250_/A
+ g_row\[0\].g_col\[1\].pe__1724_/S VGND VGND VPWR VPWR g_row\[0\].g_col\[1\].pe__1745_/A
+ sky130_fd_sc_hd__mux2_1
Xg_row\[1\].g_col\[0\].pe_hold1693 g_row\[1\].g_col\[0\].pe__2436_/A VGND VGND VPWR
+ VPWR g_row\[1\].g_col\[0\].pe__2236_/B1 sky130_fd_sc_hd__clkbuf_2
XFILLER_41_105 VGND VGND VPWR VPWR sky130_fd_sc_hd__decap_3
Xg_row\[0\].g_col\[0\].pe__1708_ g_row\[0\].g_col\[0\].pe__1709_/A g_row\[0\].g_col\[0\].pe__1709_/B
+ VGND VGND VPWR VPWR g_row\[0\].g_col\[0\].pe__1714_/A sky130_fd_sc_hd__nand2_2
Xg_row\[0\].g_col\[0\].pe__2688_ g_row\[0\].g_col\[0\].pe__2736_/Q g_row\[0\].g_col\[0\].pe__2737_/Q
+ g_row\[0\].g_col\[0\].pe__2688_/CIN VGND VGND VPWR VPWR g_row\[0\].g_col\[0\].pe__2388_/B
+ g_row\[0\].g_col\[0\].pe__1558_/B sky130_fd_sc_hd__fa_1
XFILLER_35_691 VGND VGND VPWR VPWR sky130_fd_sc_hd__fill_1
XTAP_TAPCELL_ROW_81_1423 VGND VPWR sky130_fd_sc_hd__tapvpwrvgnd_1
Xg_row\[0\].g_col\[0\].pe__1639_ g_row\[0\].g_col\[0\].pe__1840_/A g_row\[0\].g_col\[0\].pe__1840_/B
+ VGND VGND VPWR VPWR g_row\[0\].g_col\[0\].pe__1834_/A sky130_fd_sc_hd__xnor2_2
Xg_row\[0\].g_col\[1\].pe__1655_ g_row\[0\].g_col\[1\].pe__1673_/A g_row\[0\].g_col\[1\].pe__1655_/B
+ VGND VGND VPWR VPWR g_row\[0\].g_col\[1\].pe__1656_/B sky130_fd_sc_hd__xnor2_2
XFILLER_22_341 VGND VGND VPWR VPWR sky130_fd_sc_hd__fill_2
XFILLER_34_190 VGND VGND VPWR VPWR sky130_fd_sc_hd__decap_3
XTAP_TAPCELL_ROW_40_807 VGND VPWR sky130_fd_sc_hd__tapvpwrvgnd_1
Xg_row\[0\].g_col\[1\].pe__1586_ g_row\[0\].g_col\[1\].pe__1634_/A g_row\[0\].g_col\[1\].pe__1634_/B
+ VGND VGND VPWR VPWR g_row\[0\].g_col\[1\].pe__1587_/B sky130_fd_sc_hd__xnor2_2
Xg_row\[1\].g_col\[1\].pe__2129_ g_row\[1\].g_col\[1\].pe__2129_/A g_row\[1\].g_col\[1\].pe__2129_/B
+ VGND VGND VPWR VPWR g_row\[1\].g_col\[1\].pe__2132_/A sky130_fd_sc_hd__nor2_2
XFILLER_22_385 VGND VGND VPWR VPWR sky130_fd_sc_hd__fill_2
XFILLER_41_57 VGND VGND VPWR VPWR sky130_fd_sc_hd__fill_2
XFILLER_41_79 VGND VGND VPWR VPWR sky130_fd_sc_hd__fill_1
Xg_row\[0\].g_col\[1\].pe__2207_ g_row\[0\].g_col\[1\].pe__2207_/A g_row\[0\].g_col\[1\].pe__2207_/B
+ VGND VGND VPWR VPWR g_row\[0\].g_col\[1\].pe__2210_/A sky130_fd_sc_hd__nand2_2
XTAP_TAPCELL_ROW_79_1396 VGND VPWR sky130_fd_sc_hd__tapvpwrvgnd_1
Xg_row\[0\].g_col\[1\].pe__2138_ g_row\[0\].g_col\[1\].pe__2616_/B g_row\[0\].g_col\[1\].pe__2177_/A2
+ g_row\[0\].g_col\[1\].pe__2215_/B1 g_row\[0\].g_col\[1\].pe__2138_/B2 VGND VGND
+ VPWR VPWR g_row\[0\].g_col\[1\].pe__2174_/A sky130_fd_sc_hd__a22o_2
XFILLER_1_223 VGND VGND VPWR VPWR sky130_fd_sc_hd__fill_1
XFILLER_2_735 VGND VGND VPWR VPWR sky130_fd_sc_hd__decap_3
XTAP_TAPCELL_ROW_9_345 VGND VPWR sky130_fd_sc_hd__tapvpwrvgnd_1
Xg_row\[0\].g_col\[1\].pe__2069_ g_row\[0\].g_col\[1\].pe__2058_/A g_row\[0\].g_col\[1\].pe__2058_/B
+ g_row\[0\].g_col\[1\].pe__2068_/Y VGND VGND VPWR VPWR g_row\[0\].g_col\[1\].pe__2117_/A
+ sky130_fd_sc_hd__o21ba_2
XTAP_TAPCELL_ROW_92_1585 VGND VPWR sky130_fd_sc_hd__tapvpwrvgnd_1
XTAP_TAPCELL_ROW_92_1596 VGND VPWR sky130_fd_sc_hd__tapvpwrvgnd_1
Xplace1280 _199_/A VGND VGND VPWR VPWR _203_/A sky130_fd_sc_hd__buf_6
XFILLER_1_278 VGND VGND VPWR VPWR sky130_fd_sc_hd__fill_2
XFILLER_2_29 VGND VGND VPWR VPWR sky130_fd_sc_hd__fill_2
XFILLER_18_625 VGND VGND VPWR VPWR sky130_fd_sc_hd__fill_2
XFILLER_64_219 VGND VGND VPWR VPWR sky130_fd_sc_hd__fill_2
XTAP_TAPCELL_ROW_48_929 VGND VPWR sky130_fd_sc_hd__tapvpwrvgnd_1
XFILLER_17_113 VGND VGND VPWR VPWR sky130_fd_sc_hd__decap_3
XFILLER_17_124 VGND VGND VPWR VPWR sky130_fd_sc_hd__decap_3
XFILLER_18_658 VGND VGND VPWR VPWR sky130_fd_sc_hd__decap_3
XFILLER_18_669 VGND VGND VPWR VPWR sky130_fd_sc_hd__decap_3
XTAP_TAPCELL_ROW_28_631 VGND VPWR sky130_fd_sc_hd__tapvpwrvgnd_1
XFILLER_33_606 VGND VGND VPWR VPWR sky130_fd_sc_hd__decap_3
XFILLER_33_617 VGND VGND VPWR VPWR sky130_fd_sc_hd__decap_3
XFILLER_73_775 VGND VGND VPWR VPWR sky130_fd_sc_hd__decap_3
Xg_row\[0\].g_col\[0\].pe_hold1703 ANTENNA_43/DIODE VGND VGND VPWR VPWR g_row\[0\].g_col\[0\].pe__2266_/A
+ sky130_fd_sc_hd__clkbuf_2
XFILLER_9_334 VGND VGND VPWR VPWR sky130_fd_sc_hd__fill_2
XFILLER_70_8 VGND VGND VPWR VPWR sky130_fd_sc_hd__decap_3
XFILLER_9_345 VGND VGND VPWR VPWR sky130_fd_sc_hd__fill_1
Xg_row\[1\].g_col\[0\].pe__1981_ g_row\[1\].g_col\[0\].pe__2725_/Q g_row\[1\].g_col\[0\].pe__2682_/A
+ g_row\[1\].g_col\[0\].pe__2163_/A VGND VGND VPWR VPWR g_row\[1\].g_col\[0\].pe__1981_/Y
+ sky130_fd_sc_hd__nand3_2
Xg_row\[0\].g_col\[0\].pe__1990_ g_row\[0\].g_col\[0\].pe__1988_/X g_row\[0\].g_col\[0\].pe__1987_/Y
+ g_row\[0\].g_col\[0\].pe__1981_/Y g_row\[0\].g_col\[0\].pe__1980_/X g_row\[0\].g_col\[0\].pe__1919_/B
+ VGND VGND VPWR VPWR g_row\[0\].g_col\[0\].pe__1991_/D sky130_fd_sc_hd__o2111ai_2
Xg_row\[1\].g_col\[0\].pe__2533_ g_row\[1\].g_col\[0\].pe__2533_/A g_row\[1\].g_col\[0\].pe__2533_/B
+ VGND VGND VPWR VPWR g_row\[1\].g_col\[0\].pe__2534_/C sky130_fd_sc_hd__and2_2
Xg_row\[1\].g_col\[1\].pe__2480_ g_row\[1\].g_col\[1\].pe__2478_/A g_row\[1\].g_col\[1\].pe__2478_/B
+ g_row\[1\].g_col\[1\].pe__2479_/X VGND VGND VPWR VPWR g_row\[1\].g_col\[1\].pe__2585_/A
+ sky130_fd_sc_hd__o21ai_2
Xg_row\[1\].g_col\[1\].pe__1500_ g_row\[1\].g_col\[1\].pe__1500_/A g_row\[1\].g_col\[1\].pe__1500_/B
+ VGND VGND VPWR VPWR g_row\[1\].g_col\[1\].pe__1510_/B sky130_fd_sc_hd__xor2_2
XFILLER_56_709 VGND VGND VPWR VPWR sky130_fd_sc_hd__fill_2
Xg_row\[1\].g_col\[1\].pe__1431_ g_row\[1\].g_col\[1\].pe__1727_/A1 g_row\[1\].g_col\[1\].pe__2625_/B
+ g_row\[1\].g_col\[1\].pe__1970_/A g_row\[1\].g_col\[1\].pe__1727_/B2 VGND VGND VPWR
+ VPWR g_row\[1\].g_col\[1\].pe__1432_/B sky130_fd_sc_hd__a22o_2
Xg_row\[1\].g_col\[0\].pe__2464_ g_row\[1\].g_col\[0\].pe__2759_/Q g_row\[1\].g_col\[0\].pe__2464_/B
+ VGND VGND VPWR VPWR g_row\[1\].g_col\[0\].pe__2464_/X sky130_fd_sc_hd__and2_2
XFILLER_64_720 VGND VGND VPWR VPWR sky130_fd_sc_hd__fill_2
XFILLER_76_580 VGND VGND VPWR VPWR sky130_fd_sc_hd__decap_3
Xg_row\[0\].g_col\[0\].pe__2611_ g_row\[0\].g_col\[0\].pe__2628_/A1 g_row\[0\].g_col\[0\].pe__2611_/A2
+ g_row\[0\].g_col\[0\].pe__2628_/B1 g_row\[0\].g_col\[0\].pe__2610_/X VGND VGND VPWR
+ VPWR g_row\[0\].g_col\[0\].pe__2611_/X sky130_fd_sc_hd__o211a_2
Xg_row\[1\].g_col\[0\].pe__2395_ g_row\[1\].g_col\[0\].pe__2663_/A g_row\[1\].g_col\[0\].pe__2395_/A2
+ g_row\[1\].g_col\[0\].pe__2393_/Y g_row\[1\].g_col\[0\].pe__2394_/X VGND VGND VPWR
+ VPWR g_row\[1\].g_col\[0\].pe__2396_/B sky130_fd_sc_hd__o22a_4
Xg_row\[1\].g_col\[0\].pe__1415_ g_row\[1\].g_col\[0\].pe__2725_/Q g_row\[1\].g_col\[0\].pe__2724_/Q
+ g_row\[1\].g_col\[0\].pe__1870_/A VGND VGND VPWR VPWR g_row\[1\].g_col\[0\].pe__1415_/Y
+ sky130_fd_sc_hd__o21ai_2
Xg_row\[1\].g_col\[1\].pe__1362_ g_row\[1\].g_col\[1\].pe__2766_/Q g_row\[1\].g_col\[1\].pe__1361_/B
+ g_row\[1\].g_col\[1\].pe__2776_/A VGND VGND VPWR VPWR g_row\[1\].g_col\[1\].pe__1363_/B
+ sky130_fd_sc_hd__o21ai_2
Xg_row\[1\].g_col\[0\].pe__1346_ g_row\[1\].g_col\[0\].pe__2759_/Q g_row\[1\].g_col\[0\].pe__1346_/B
+ VGND VGND VPWR VPWR output1383/A sky130_fd_sc_hd__xor2_2
XFILLER_36_477 VGND VGND VPWR VPWR sky130_fd_sc_hd__decap_3
Xg_row\[0\].g_col\[0\].pe__2542_ g_row\[0\].g_col\[0\].pe__2555_/A g_row\[0\].g_col\[0\].pe__2542_/B
+ VGND VGND VPWR VPWR g_row\[0\].g_col\[0\].pe__2760_/D sky130_fd_sc_hd__and2_2
Xg_row\[0\].g_col\[0\].pe__2473_ g_row\[0\].g_col\[0\].pe__2491_/B g_row\[0\].g_col\[0\].pe__2505_/A
+ g_row\[0\].g_col\[0\].pe__2491_/A VGND VGND VPWR VPWR g_row\[0\].g_col\[0\].pe__2492_/A
+ sky130_fd_sc_hd__o21ai_2
XFILLER_51_458 VGND VGND VPWR VPWR sky130_fd_sc_hd__fill_2
XFILLER_51_469 VGND VGND VPWR VPWR sky130_fd_sc_hd__decap_3
XTAP_TAPCELL_ROW_63_1153 VGND VPWR sky130_fd_sc_hd__tapvpwrvgnd_1
Xg_row\[0\].g_col\[0\].pe__1424_ g_row\[0\].g_col\[0\].pe__1424_/A g_row\[0\].g_col\[0\].pe__1424_/B
+ VGND VGND VPWR VPWR g_row\[0\].g_col\[0\].pe__1424_/Y sky130_fd_sc_hd__nand2_2
Xg_row\[0\].g_col\[1\].pe__1440_ g_row\[0\].g_col\[1\].pe__1704_/A2 g_row\[0\].g_col\[1\].pe__1732_/A2
+ g_row\[0\].g_col\[1\].pe__1732_/B1 g_row\[0\].g_col\[1\].pe__1727_/A2 VGND VGND
+ VPWR VPWR g_row\[0\].g_col\[1\].pe__1441_/B sky130_fd_sc_hd__a22o_2
Xg_row\[0\].g_col\[0\].pe_hold2982 g_row\[0\].g_col\[0\].pe__1396_/A VGND VGND VPWR
+ VPWR g_row\[0\].g_col\[0\].pe__2664_/A2 sky130_fd_sc_hd__clkbuf_2
Xg_row\[0\].g_col\[1\].pe__1371_ g_row\[0\].g_col\[1\].pe__2424_/A g_row\[0\].g_col\[1\].pe__1371_/B
+ VGND VGND VPWR VPWR output1378/A sky130_fd_sc_hd__xnor2_2
Xg_row\[0\].g_col\[0\].pe__1355_ g_row\[0\].g_col\[0\].pe__2763_/Q g_row\[0\].g_col\[0\].pe__1355_/B
+ VGND VGND VPWR VPWR output1416/A sky130_fd_sc_hd__xor2_2
XTAP_TAPCELL_ROW_6_304 VGND VPWR sky130_fd_sc_hd__tapvpwrvgnd_1
Xg_row\[1\].g_col\[1\].pe__2747_ clkbuf_leaf_77_clk/X g_row\[1\].g_col\[1\].pe__2747_/D
+ VGND VGND VPWR VPWR g_row\[1\].g_col\[1\].pe__2747_/Q sky130_fd_sc_hd__dfxtp_2
Xg_row\[1\].g_col\[1\].pe__2678_ g_row\[1\].g_col\[1\].pe__2686_/B g_row\[1\].g_col\[1\].pe__2678_/B
+ VGND VGND VPWR VPWR g_row\[1\].g_col\[1\].pe__2678_/Y sky130_fd_sc_hd__nand2_2
Xg_row\[1\].g_col\[1\].pe__1629_ g_row\[1\].g_col\[1\].pe__1629_/A g_row\[1\].g_col\[1\].pe__1629_/B
+ VGND VGND VPWR VPWR g_row\[1\].g_col\[1\].pe__1883_/A sky130_fd_sc_hd__xnor2_2
XFILLER_36_46 VGND VGND VPWR VPWR sky130_fd_sc_hd__fill_1
XFILLER_70_701 VGND VGND VPWR VPWR sky130_fd_sc_hd__decap_3
Xg_row\[0\].g_col\[1\].pe__2756_ clkbuf_leaf_3_clk/X g_row\[0\].g_col\[1\].pe__2756_/D
+ VGND VGND VPWR VPWR g_row\[0\].g_col\[1\].pe__2775_/A sky130_fd_sc_hd__dfxtp_2
XFILLER_15_639 VGND VGND VPWR VPWR sky130_fd_sc_hd__decap_3
Xg_row\[0\].g_col\[1\].pe__1707_ g_row\[0\].g_col\[1\].pe__1707_/A g_row\[0\].g_col\[1\].pe__1707_/B
+ VGND VGND VPWR VPWR g_row\[0\].g_col\[1\].pe__1709_/B sky130_fd_sc_hd__xor2_2
Xg_row\[0\].g_col\[1\].pe_hold1855 g_row\[0\].g_col\[1\].pe__2564_/X VGND VGND VPWR
+ VPWR g_row\[0\].g_col\[1\].pe__2565_/B sky130_fd_sc_hd__clkbuf_2
Xg_row\[0\].g_col\[1\].pe_hold1844 g_row\[0\].g_col\[1\].pe__2760_/Q VGND VGND VPWR
+ VPWR g_row\[0\].g_col\[1\].pe__2541_/A1 sky130_fd_sc_hd__clkbuf_2
Xg_row\[0\].g_col\[1\].pe__2687_ g_row\[0\].g_col\[1\].pe__2673_/C g_row\[0\].g_col\[1\].pe__2680_/B
+ g_row\[0\].g_col\[1\].pe__2686_/X g_row\[0\].g_col\[1\].pe__2687_/C1 VGND VGND VPWR
+ VPWR g_row\[0\].g_col\[1\].pe__2687_/X sky130_fd_sc_hd__o211a_2
Xg_row\[0\].g_col\[1\].pe__1638_ g_row\[0\].g_col\[1\].pe__1844_/A g_row\[0\].g_col\[1\].pe__1844_/B
+ VGND VGND VPWR VPWR g_row\[0\].g_col\[1\].pe__1840_/B sky130_fd_sc_hd__xnor2_2
XTAP_TAPCELL_ROW_53_998 VGND VPWR sky130_fd_sc_hd__tapvpwrvgnd_1
X_171_ _171_/A _171_/B_N VGND VGND VPWR VPWR _171_/Y sky130_fd_sc_hd__nor2b_4
Xg_row\[0\].g_col\[1\].pe__1569_ g_row\[0\].g_col\[1\].pe__2019_/B2 g_row\[0\].g_col\[1\].pe__1657_/B
+ g_row\[0\].g_col\[1\].pe__2247_/B1 g_row\[0\].g_col\[1\].pe__1957_/B2 VGND VGND
+ VPWR VPWR g_row\[0\].g_col\[1\].pe__1570_/B sky130_fd_sc_hd__a22o_2
XFILLER_77_311 VGND VGND VPWR VPWR sky130_fd_sc_hd__fill_2
XFILLER_89_160 VGND VGND VPWR VPWR sky130_fd_sc_hd__fill_2
Xg_row\[1\].g_col\[0\].pe__2180_ g_row\[1\].g_col\[0\].pe__2213_/A g_row\[1\].g_col\[0\].pe__2213_/B
+ VGND VGND VPWR VPWR g_row\[1\].g_col\[0\].pe__2181_/B sky130_fd_sc_hd__xor2_2
XFILLER_92_369 VGND VGND VPWR VPWR sky130_fd_sc_hd__fill_1
XFILLER_33_425 VGND VGND VPWR VPWR sky130_fd_sc_hd__decap_3
XFILLER_45_274 VGND VGND VPWR VPWR sky130_fd_sc_hd__fill_2
XFILLER_73_594 VGND VGND VPWR VPWR sky130_fd_sc_hd__decap_3
XFILLER_33_469 VGND VGND VPWR VPWR sky130_fd_sc_hd__decap_3
XFILLER_14_683 VGND VGND VPWR VPWR sky130_fd_sc_hd__decap_3
Xg_row\[0\].g_col\[0\].pe_hold2267 g_row\[0\].g_col\[0\].pe__2404_/X VGND VGND VPWR
+ VPWR g_row\[0\].g_col\[0\].pe__2405_/B sky130_fd_sc_hd__clkbuf_2
XFILLER_13_193 VGND VGND VPWR VPWR sky130_fd_sc_hd__fill_2
Xg_row\[0\].g_col\[0\].pe_hold2289 g_row\[0\].g_col\[0\].pe__2656_/X VGND VGND VPWR
+ VPWR g_row\[0\].g_col\[0\].pe__2713_/D sky130_fd_sc_hd__clkbuf_2
Xg_row\[0\].g_col\[1\].pe_place859 g_row\[0\].g_col\[1\].pe__1471_/X VGND VGND VPWR
+ VPWR g_row\[0\].g_col\[1\].pe__1657_/B sky130_fd_sc_hd__buf_6
Xg_row\[1\].g_col\[1\].pe__1980_ g_row\[1\].g_col\[1\].pe__1980_/A g_row\[1\].g_col\[1\].pe__1980_/B
+ g_row\[1\].g_col\[1\].pe__1980_/C VGND VGND VPWR VPWR g_row\[1\].g_col\[1\].pe__1980_/X
+ sky130_fd_sc_hd__or3_4
XTAP_TAPCELL_ROW_11_372 VGND VPWR sky130_fd_sc_hd__tapvpwrvgnd_1
Xg_row\[1\].g_col\[0\].pe__1964_ g_row\[1\].g_col\[0\].pe__1964_/A g_row\[1\].g_col\[0\].pe__1964_/B
+ VGND VGND VPWR VPWR g_row\[1\].g_col\[0\].pe__1997_/A sky130_fd_sc_hd__xnor2_2
XFILLER_54_3 VGND VGND VPWR VPWR sky130_fd_sc_hd__decap_3
Xg_row\[1\].g_col\[0\].pe__1895_ g_row\[1\].g_col\[0\].pe__1843_/A g_row\[1\].g_col\[0\].pe__1843_/B
+ g_row\[1\].g_col\[0\].pe__1891_/B VGND VGND VPWR VPWR g_row\[1\].g_col\[0\].pe__1895_/X
+ sky130_fd_sc_hd__a21bo_2
Xhold3408 hold3408/A VGND VGND VPWR VPWR hold3408/X sky130_fd_sc_hd__clkbuf_2
Xoutput1358 output1358/A VGND VGND VPWR VPWR results_flat[12] sky130_fd_sc_hd__buf_2
Xhold3419 hold3419/A VGND VGND VPWR VPWR hold3419/X sky130_fd_sc_hd__clkbuf_2
XFILLER_69_834 VGND VGND VPWR VPWR sky130_fd_sc_hd__fill_2
Xhold2707 hold2707/A VGND VGND VPWR VPWR _322_/D sky130_fd_sc_hd__clkbuf_2
Xhold2718 _173_/Y VGND VGND VPWR VPWR hold2718/X sky130_fd_sc_hd__clkbuf_2
Xhold2729 hold2729/A VGND VGND VPWR VPWR _193_/B_N sky130_fd_sc_hd__clkbuf_2
Xoutput1369 output1369/A VGND VGND VPWR VPWR results_flat[22] sky130_fd_sc_hd__buf_2
Xg_row\[1\].g_col\[1\].pe__2532_ g_row\[1\].g_col\[1\].pe__2533_/A g_row\[1\].g_col\[1\].pe__2533_/B
+ VGND VGND VPWR VPWR g_row\[1\].g_col\[1\].pe__2534_/B sky130_fd_sc_hd__nor2_2
XFILLER_84_804 VGND VGND VPWR VPWR sky130_fd_sc_hd__fill_2
Xg_row\[0\].g_col\[0\].pe__1973_ g_row\[0\].g_col\[0\].pe__1972_/B g_row\[0\].g_col\[0\].pe__1972_/C
+ g_row\[0\].g_col\[0\].pe__2165_/A VGND VGND VPWR VPWR g_row\[0\].g_col\[0\].pe__1974_/D
+ sky130_fd_sc_hd__a21o_2
Xg_row\[1\].g_col\[0\].pe__2516_ g_row\[1\].g_col\[0\].pe__2503_/B g_row\[1\].g_col\[0\].pe__2516_/B
+ VGND VGND VPWR VPWR g_row\[1\].g_col\[0\].pe__2516_/X sky130_fd_sc_hd__and2b_2
XFILLER_56_517 VGND VGND VPWR VPWR sky130_fd_sc_hd__decap_3
Xg_row\[1\].g_col\[1\].pe__2463_ g_row\[1\].g_col\[1\].pe__2519_/A g_row\[1\].g_col\[1\].pe__2519_/B
+ g_row\[1\].g_col\[1\].pe__2462_/Y VGND VGND VPWR VPWR g_row\[1\].g_col\[1\].pe__2526_/B
+ sky130_fd_sc_hd__o21ai_2
Xg_row\[1\].g_col\[0\].pe__2447_ g_row\[1\].g_col\[0\].pe__2497_/B VGND VGND VPWR
+ VPWR g_row\[1\].g_col\[0\].pe__2551_/B sky130_fd_sc_hd__inv_2
Xg_row\[1\].g_col\[1\].pe__2394_ g_row\[1\].g_col\[1\].pe__2378_/X g_row\[1\].g_col\[1\].pe__2384_/Y
+ g_row\[1\].g_col\[1\].pe__2392_/Y g_row\[1\].g_col\[1\].pe__2394_/B1 VGND VGND VPWR
+ VPWR g_row\[1\].g_col\[1\].pe__2394_/X sky130_fd_sc_hd__a31o_2
Xg_row\[1\].g_col\[1\].pe__1414_ g_row\[1\].g_col\[1\].pe__2725_/Q g_row\[1\].g_col\[1\].pe__2682_/A
+ g_row\[1\].g_col\[1\].pe__1785_/A VGND VGND VPWR VPWR g_row\[1\].g_col\[1\].pe__1414_/X
+ sky130_fd_sc_hd__a21o_2
XFILLER_83_369 VGND VGND VPWR VPWR sky130_fd_sc_hd__fill_2
Xg_row\[1\].g_col\[1\].pe__1345_ g_row\[1\].g_col\[1\].pe__2758_/Q g_row\[1\].g_col\[1\].pe__2757_/Q
+ g_row\[1\].g_col\[1\].pe__2775_/A g_row\[1\].g_col\[1\].pe__1348_/A VGND VGND VPWR
+ VPWR g_row\[1\].g_col\[1\].pe__1346_/B sky130_fd_sc_hd__o31a_2
Xg_row\[1\].g_col\[0\].pe__2378_ g_row\[1\].g_col\[0\].pe__2358_/A g_row\[1\].g_col\[0\].pe__2358_/B
+ g_row\[1\].g_col\[0\].pe__2377_/Y VGND VGND VPWR VPWR g_row\[1\].g_col\[0\].pe__2378_/X
+ sky130_fd_sc_hd__a21o_2
Xg_row\[0\].g_col\[1\].pe__2610_ g_row\[0\].g_col\[1\].pe__2663_/A g_row\[0\].g_col\[1\].pe__2610_/B
+ VGND VGND VPWR VPWR g_row\[0\].g_col\[1\].pe__2610_/X sky130_fd_sc_hd__or2_2
Xg_row\[0\].g_col\[0\].pe__2525_ g_row\[0\].g_col\[0\].pe__2526_/A g_row\[0\].g_col\[0\].pe__2526_/B
+ VGND VGND VPWR VPWR g_row\[0\].g_col\[0\].pe__2525_/Y sky130_fd_sc_hd__nand2_2
Xg_row\[0\].g_col\[1\].pe__2541_ g_row\[0\].g_col\[1\].pe__2541_/A1 g_row\[0\].g_col\[1\].pe__2406_/Y
+ g_row\[0\].g_col\[1\].pe__2591_/B1 g_row\[0\].g_col\[1\].pe__2540_/X VGND VGND VPWR
+ VPWR g_row\[0\].g_col\[1\].pe__2542_/B sky130_fd_sc_hd__a22o_2
XTAP_TAPCELL_ROW_19_494 VGND VPWR sky130_fd_sc_hd__tapvpwrvgnd_1
Xg_row\[0\].g_col\[1\].pe__2472_ g_row\[0\].g_col\[1\].pe__2765_/Q g_row\[0\].g_col\[1\].pe__2472_/B
+ VGND VGND VPWR VPWR g_row\[0\].g_col\[1\].pe__2491_/A sky130_fd_sc_hd__xnor2_2
Xg_row\[0\].g_col\[0\].pe__2456_ g_row\[0\].g_col\[0\].pe__2457_/B g_row\[0\].g_col\[0\].pe__2758_/Q
+ VGND VGND VPWR VPWR g_row\[0\].g_col\[0\].pe__2458_/A sky130_fd_sc_hd__and2b_2
Xg_row\[0\].g_col\[1\].pe__1423_ g_row\[0\].g_col\[1\].pe__2726_/Q g_row\[0\].g_col\[1\].pe__2727_/Q
+ g_row\[0\].g_col\[1\].pe__2125_/C VGND VGND VPWR VPWR g_row\[0\].g_col\[1\].pe__1424_/B
+ sky130_fd_sc_hd__or3b_4
XFILLER_20_642 VGND VGND VPWR VPWR sky130_fd_sc_hd__fill_2
XTAP_TAPCELL_ROW_50_957 VGND VPWR sky130_fd_sc_hd__tapvpwrvgnd_1
Xg_row\[0\].g_col\[0\].pe__1407_ _274_/Q g_row\[0\].g_col\[0\].pe__2157_/A g_row\[0\].g_col\[0\].pe__2676_/A
+ g_row\[0\].g_col\[0\].pe__2404_/B1 VGND VGND VPWR VPWR g_row\[0\].g_col\[0\].pe__1407_/X
+ sky130_fd_sc_hd__o2bb2a_2
Xg_row\[0\].g_col\[0\].pe__2387_ g_row\[0\].g_col\[0\].pe__2387_/A g_row\[0\].g_col\[0\].pe__2387_/B
+ VGND VGND VPWR VPWR g_row\[0\].g_col\[0\].pe__2391_/A sky130_fd_sc_hd__nand2_2
Xg_row\[0\].g_col\[1\].pe__1354_ g_row\[0\].g_col\[1\].pe__2771_/Q g_row\[0\].g_col\[1\].pe__2762_/Q
+ g_row\[0\].g_col\[1\].pe__1353_/B VGND VGND VPWR VPWR g_row\[0\].g_col\[1\].pe__1355_/B
+ sky130_fd_sc_hd__a21o_2
XTAP_TAPCELL_ROW_76_1344 VGND VPWR sky130_fd_sc_hd__tapvpwrvgnd_1
XTAP_TAPCELL_ROW_76_1355 VGND VPWR sky130_fd_sc_hd__tapvpwrvgnd_1
XFILLER_59_300 VGND VGND VPWR VPWR sky130_fd_sc_hd__fill_2
XFILLER_19_219 VGND VGND VPWR VPWR sky130_fd_sc_hd__fill_1
XFILLER_86_174 VGND VGND VPWR VPWR sky130_fd_sc_hd__decap_3
XFILLER_87_686 VGND VGND VPWR VPWR sky130_fd_sc_hd__decap_3
Xg_row\[0\].g_col\[1\].pe_hold3054 g_row\[0\].g_col\[1\].pe__2731_/Q VGND VGND VPWR
+ VPWR g_row\[0\].g_col\[1\].pe__1391_/A1 sky130_fd_sc_hd__clkbuf_2
XFILLER_55_561 VGND VGND VPWR VPWR sky130_fd_sc_hd__decap_3
XFILLER_62_509 VGND VGND VPWR VPWR sky130_fd_sc_hd__decap_3
Xg_row\[0\].g_col\[1\].pe_hold2353 g_row\[0\].g_col\[1\].pe__2623_/X VGND VGND VPWR
+ VPWR g_row\[0\].g_col\[1\].pe__2624_/C1 sky130_fd_sc_hd__clkbuf_2
Xg_row\[0\].g_col\[1\].pe_hold2342 _336_/Q VGND VGND VPWR VPWR g_row\[0\].g_col\[1\].pe_hold2342/X
+ sky130_fd_sc_hd__clkbuf_2
Xg_row\[0\].g_col\[1\].pe_hold2331 g_row\[0\].g_col\[1\].pe__2746_/Q VGND VGND VPWR
+ VPWR g_row\[0\].g_col\[1\].pe__2160_/A sky130_fd_sc_hd__clkbuf_2
XTAP_TAPCELL_ROW_38_781 VGND VPWR sky130_fd_sc_hd__tapvpwrvgnd_1
Xg_row\[0\].g_col\[1\].pe_hold2386 g_row\[0\].g_col\[1\].pe__2445_/A VGND VGND VPWR
+ VPWR g_row\[0\].g_col\[1\].pe__2114_/A2 sky130_fd_sc_hd__clkbuf_2
Xg_row\[0\].g_col\[1\].pe_hold2375 g_row\[0\].g_col\[1\].pe__2747_/Q VGND VGND VPWR
+ VPWR g_row\[0\].g_col\[1\].pe__2235_/A sky130_fd_sc_hd__clkbuf_2
Xg_row\[0\].g_col\[1\].pe_hold2364 g_row\[0\].g_col\[1\].pe__2604_/X VGND VGND VPWR
+ VPWR g_row\[0\].g_col\[1\].pe__2691_/D sky130_fd_sc_hd__clkbuf_2
Xg_row\[0\].g_col\[1\].pe__2739_ clkbuf_leaf_10_clk/X g_row\[0\].g_col\[1\].pe__2739_/D
+ VGND VGND VPWR VPWR g_row\[0\].g_col\[1\].pe__2739_/Q sky130_fd_sc_hd__dfxtp_2
XFILLER_70_542 VGND VGND VPWR VPWR sky130_fd_sc_hd__fill_1
Xg_row\[0\].g_col\[1\].pe_hold2397 g_row\[0\].g_col\[1\].pe__2639_/B VGND VGND VPWR
+ VPWR g_row\[0\].g_col\[1\].pe__2397_/B sky130_fd_sc_hd__clkbuf_2
XFILLER_70_575 VGND VGND VPWR VPWR sky130_fd_sc_hd__decap_3
XFILLER_42_299 VGND VGND VPWR VPWR sky130_fd_sc_hd__fill_1
X_223_ _235_/A _223_/B_N VGND VGND VPWR VPWR _223_/Y sky130_fd_sc_hd__nor2b_4
XFILLER_10_185 VGND VGND VPWR VPWR sky130_fd_sc_hd__fill_1
XFILLER_6_123 VGND VGND VPWR VPWR sky130_fd_sc_hd__fill_1
XFILLER_7_646 VGND VGND VPWR VPWR sky130_fd_sc_hd__decap_3
XFILLER_3_841 VGND VGND VPWR VPWR sky130_fd_sc_hd__fill_1
Xg_row\[1\].g_col\[0\].pe__1680_ g_row\[1\].g_col\[0\].pe__1808_/A g_row\[1\].g_col\[0\].pe__1680_/B
+ VGND VGND VPWR VPWR g_row\[1\].g_col\[0\].pe__1686_/A sky130_fd_sc_hd__xnor2_2
XPHY_EDGE_ROW_0_Left_94 VGND VGND VPWR VPWR sky130_fd_sc_hd__decap_3
Xg_row\[1\].g_col\[0\].pe_hold2927 _306_/Q VGND VGND VPWR VPWR g_row\[1\].g_col\[0\].pe_hold2927/X
+ sky130_fd_sc_hd__clkbuf_2
Xg_row\[1\].g_col\[0\].pe_hold2916 g_row\[1\].g_col\[0\].pe_hold2916/A VGND VGND VPWR
+ VPWR g_row\[1\].g_col\[0\].pe__2624_/A2 sky130_fd_sc_hd__clkbuf_2
XFILLER_66_826 VGND VGND VPWR VPWR sky130_fd_sc_hd__fill_2
XFILLER_77_141 VGND VGND VPWR VPWR sky130_fd_sc_hd__fill_1
Xg_row\[1\].g_col\[0\].pe__2301_ g_row\[1\].g_col\[0\].pe__1894_/Y g_row\[1\].g_col\[0\].pe__1895_/X
+ g_row\[1\].g_col\[0\].pe__2151_/X g_row\[1\].g_col\[0\].pe__2300_/B VGND VGND VPWR
+ VPWR g_row\[1\].g_col\[0\].pe__2304_/B sky130_fd_sc_hd__a211o_4
XFILLER_93_645 VGND VGND VPWR VPWR sky130_fd_sc_hd__fill_2
Xg_row\[1\].g_col\[0\].pe__2232_ g_row\[1\].g_col\[0\].pe__2161_/Y g_row\[1\].g_col\[0\].pe__2200_/B
+ g_row\[1\].g_col\[0\].pe__2231_/Y VGND VGND VPWR VPWR g_row\[1\].g_col\[0\].pe__2233_/C
+ sky130_fd_sc_hd__o21a_2
XFILLER_34_712 VGND VGND VPWR VPWR sky130_fd_sc_hd__fill_2
Xg_row\[1\].g_col\[0\].pe__2163_ g_row\[1\].g_col\[0\].pe__2163_/A g_row\[1\].g_col\[0\].pe__2163_/B
+ VGND VGND VPWR VPWR g_row\[1\].g_col\[0\].pe__2165_/B sky130_fd_sc_hd__nand2_2
XFILLER_33_244 VGND VGND VPWR VPWR sky130_fd_sc_hd__fill_1
XFILLER_61_531 VGND VGND VPWR VPWR sky130_fd_sc_hd__decap_3
Xg_row\[1\].g_col\[0\].pe__2094_ g_row\[1\].g_col\[0\].pe__2125_/C g_row\[1\].g_col\[0\].pe__2094_/B
+ g_row\[1\].g_col\[0\].pe__2094_/C VGND VGND VPWR VPWR g_row\[1\].g_col\[0\].pe__2095_/B
+ sky130_fd_sc_hd__nand3_2
XFILLER_61_564 VGND VGND VPWR VPWR sky130_fd_sc_hd__decap_3
XFILLER_61_575 VGND VGND VPWR VPWR sky130_fd_sc_hd__decap_3
XTAP_TAPCELL_ROW_16_453 VGND VPWR sky130_fd_sc_hd__tapvpwrvgnd_1
Xg_row\[0\].g_col\[0\].pe__2310_ g_row\[0\].g_col\[0\].pe__2318_/A g_row\[0\].g_col\[0\].pe__2310_/B
+ g_row\[0\].g_col\[0\].pe__2276_/B VGND VGND VPWR VPWR g_row\[0\].g_col\[0\].pe__2337_/A
+ sky130_fd_sc_hd__or3b_2
Xg_row\[0\].g_col\[0\].pe_hold2020 g_row\[0\].g_col\[0\].pe__2661_/X VGND VGND VPWR
+ VPWR g_row\[0\].g_col\[0\].pe__2662_/C1 sky130_fd_sc_hd__clkbuf_2
XTAP_TAPCELL_ROW_60_1112 VGND VPWR sky130_fd_sc_hd__tapvpwrvgnd_1
Xg_row\[0\].g_col\[0\].pe__2241_ g_row\[0\].g_col\[0\].pe__1970_/A g_row\[0\].g_col\[0\].pe__2278_/A2
+ g_row\[0\].g_col\[0\].pe__2278_/B1 g_row\[0\].g_col\[0\].pe__2241_/B2 VGND VGND
+ VPWR VPWR g_row\[0\].g_col\[0\].pe__2277_/A sky130_fd_sc_hd__a22o_2
Xg_row\[0\].g_col\[0\].pe_hold2086 g_row\[0\].g_col\[0\].pe__2763_/Q VGND VGND VPWR
+ VPWR g_row\[0\].g_col\[0\].pe__2560_/A1 sky130_fd_sc_hd__clkbuf_2
Xg_row\[0\].g_col\[0\].pe__2172_ g_row\[0\].g_col\[0\].pe__2172_/A g_row\[0\].g_col\[0\].pe__2172_/B
+ VGND VGND VPWR VPWR g_row\[0\].g_col\[0\].pe__2253_/A sky130_fd_sc_hd__xor2_2
Xg_row\[1\].g_col\[1\].pe__1963_ g_row\[1\].g_col\[1\].pe__1963_/A g_row\[1\].g_col\[1\].pe__1963_/B
+ VGND VGND VPWR VPWR g_row\[1\].g_col\[1\].pe__1964_/B sky130_fd_sc_hd__xor2_2
Xg_row\[1\].g_col\[0\].pe__1947_ g_row\[1\].g_col\[0\].pe__1944_/Y g_row\[1\].g_col\[0\].pe__2008_/A
+ g_row\[1\].g_col\[0\].pe__1947_/B1 g_row\[1\].g_col\[0\].pe__2404_/A1 VGND VGND
+ VPWR VPWR g_row\[1\].g_col\[0\].pe__1948_/B sky130_fd_sc_hd__o2bb2a_2
XFILLER_6_690 VGND VGND VPWR VPWR sky130_fd_sc_hd__fill_1
XTAP_TAPCELL_ROW_58_1074 VGND VPWR sky130_fd_sc_hd__tapvpwrvgnd_1
XTAP_TAPCELL_ROW_58_1085 VGND VPWR sky130_fd_sc_hd__tapvpwrvgnd_1
Xhold3205 hold3205/A VGND VGND VPWR VPWR hold3205/X sky130_fd_sc_hd__clkbuf_2
Xg_row\[1\].g_col\[1\].pe__1894_ g_row\[1\].g_col\[1\].pe__1894_/A g_row\[1\].g_col\[1\].pe__1894_/B
+ VGND VGND VPWR VPWR g_row\[1\].g_col\[1\].pe__1894_/Y sky130_fd_sc_hd__nand2_2
Xg_row\[1\].g_col\[0\].pe__1878_ g_row\[1\].g_col\[0\].pe__1878_/A g_row\[1\].g_col\[0\].pe__1878_/B
+ VGND VGND VPWR VPWR g_row\[1\].g_col\[0\].pe__1936_/A sky130_fd_sc_hd__xnor2_2
Xhold2504 hold3249/X VGND VGND VPWR VPWR hold3250/A sky130_fd_sc_hd__clkbuf_2
Xhold3216 hold3216/A VGND VGND VPWR VPWR hold3216/X sky130_fd_sc_hd__clkbuf_2
Xhold3227 hold3227/A VGND VGND VPWR VPWR hold3227/X sky130_fd_sc_hd__clkbuf_2
Xhold3238 hold3238/A VGND VGND VPWR VPWR hold3238/X sky130_fd_sc_hd__clkbuf_2
Xhold3249 b_inputs_flat[25] VGND VGND VPWR VPWR hold3249/X sky130_fd_sc_hd__clkbuf_2
XFILLER_69_653 VGND VGND VPWR VPWR sky130_fd_sc_hd__decap_3
Xhold2515 hold2515/A VGND VGND VPWR VPWR _312_/D sky130_fd_sc_hd__clkbuf_2
Xhold2526 _267_/Y VGND VGND VPWR VPWR hold2526/X sky130_fd_sc_hd__clkbuf_2
Xhold2537 hold3262/X VGND VGND VPWR VPWR _251_/B_N sky130_fd_sc_hd__clkbuf_2
XFILLER_69_686 VGND VGND VPWR VPWR sky130_fd_sc_hd__fill_1
XTAP_TAPCELL_ROW_71_1274 VGND VPWR sky130_fd_sc_hd__tapvpwrvgnd_1
Xg_row\[0\].g_col\[0\].pe__1956_ g_row\[0\].g_col\[0\].pe__1916_/A g_row\[0\].g_col\[0\].pe__1916_/B
+ g_row\[0\].g_col\[0\].pe__1955_/X VGND VGND VPWR VPWR g_row\[0\].g_col\[0\].pe__1963_/A
+ sky130_fd_sc_hd__a21o_2
Xhold2548 hold3274/X VGND VGND VPWR VPWR hold3275/A sky130_fd_sc_hd__clkbuf_2
Xhold2559 hold3328/X VGND VGND VPWR VPWR hold3329/A sky130_fd_sc_hd__clkbuf_2
Xg_row\[0\].g_col\[1\].pe__1972_ g_row\[0\].g_col\[1\].pe__2123_/A g_row\[0\].g_col\[1\].pe__1972_/B
+ g_row\[0\].g_col\[1\].pe__1972_/C VGND VGND VPWR VPWR g_row\[0\].g_col\[1\].pe__1974_/C
+ sky130_fd_sc_hd__nand3_2
XFILLER_84_645 VGND VGND VPWR VPWR sky130_fd_sc_hd__fill_1
Xg_row\[1\].g_col\[1\].pe__2446_ g_row\[1\].g_col\[1\].pe__2761_/Q g_row\[1\].g_col\[1\].pe__2446_/B
+ VGND VGND VPWR VPWR g_row\[1\].g_col\[1\].pe__2497_/B sky130_fd_sc_hd__and2b_2
XFILLER_72_818 VGND VGND VPWR VPWR sky130_fd_sc_hd__fill_1
Xg_row\[0\].g_col\[0\].pe__1887_ g_row\[0\].g_col\[0\].pe__1888_/A g_row\[0\].g_col\[0\].pe__1888_/B
+ g_row\[0\].g_col\[0\].pe__1888_/C VGND VGND VPWR VPWR g_row\[0\].g_col\[0\].pe__1951_/A
+ sky130_fd_sc_hd__o21a_2
Xg_row\[1\].g_col\[1\].pe__2377_ g_row\[1\].g_col\[1\].pe__2377_/A g_row\[1\].g_col\[1\].pe__2377_/B
+ VGND VGND VPWR VPWR g_row\[1\].g_col\[1\].pe__2377_/Y sky130_fd_sc_hd__nand2_2
XFILLER_24_222 VGND VGND VPWR VPWR sky130_fd_sc_hd__fill_1
XFILLER_52_542 VGND VGND VPWR VPWR sky130_fd_sc_hd__decap_3
XTAP_TAPCELL_ROW_35_740 VGND VPWR sky130_fd_sc_hd__tapvpwrvgnd_1
Xg_row\[0\].g_col\[0\].pe__2508_ g_row\[0\].g_col\[0\].pe__2508_/A g_row\[0\].g_col\[0\].pe__2508_/B
+ VGND VGND VPWR VPWR g_row\[0\].g_col\[0\].pe__2508_/Y sky130_fd_sc_hd__xnor2_2
Xg_row\[0\].g_col\[0\].pe__2439_ g_row\[0\].g_col\[0\].pe__2439_/A g_row\[0\].g_col\[0\].pe__2439_/B
+ VGND VGND VPWR VPWR g_row\[0\].g_col\[0\].pe__2439_/Y sky130_fd_sc_hd__xnor2_2
Xg_row\[0\].g_col\[1\].pe__2455_ g_row\[0\].g_col\[1\].pe__2455_/A g_row\[0\].g_col\[1\].pe__2455_/B
+ VGND VGND VPWR VPWR g_row\[0\].g_col\[1\].pe__2457_/B sky130_fd_sc_hd__xnor2_2
Xg_row\[0\].g_col\[1\].pe__1406_ g_row\[0\].g_col\[1\].pe__1406_/A VGND VGND VPWR
+ VPWR g_row\[0\].g_col\[1\].pe__1406_/Y sky130_fd_sc_hd__inv_2
Xg_row\[0\].g_col\[1\].pe__2386_ g_row\[0\].g_col\[1\].pe__2386_/A g_row\[0\].g_col\[1\].pe__2372_/A
+ VGND VGND VPWR VPWR g_row\[0\].g_col\[1\].pe__2387_/B sky130_fd_sc_hd__or2b_2
XFILLER_4_605 VGND VGND VPWR VPWR sky130_fd_sc_hd__decap_3
XPHY_EDGE_ROW_18_Left_112 VGND VGND VPWR VPWR sky130_fd_sc_hd__decap_3
XFILLER_3_159 VGND VGND VPWR VPWR sky130_fd_sc_hd__fill_1
XFILLER_47_314 VGND VGND VPWR VPWR sky130_fd_sc_hd__decap_3
XFILLER_75_656 VGND VGND VPWR VPWR sky130_fd_sc_hd__decap_3
XTAP_TAPCELL_ROW_89_1546 VGND VPWR sky130_fd_sc_hd__tapvpwrvgnd_1
XFILLER_16_701 VGND VGND VPWR VPWR sky130_fd_sc_hd__decap_3
XFILLER_90_615 VGND VGND VPWR VPWR sky130_fd_sc_hd__fill_1
XPHY_EDGE_ROW_27_Left_121 VGND VGND VPWR VPWR sky130_fd_sc_hd__decap_3
XFILLER_28_561 VGND VGND VPWR VPWR sky130_fd_sc_hd__decap_3
Xg_row\[0\].g_col\[1\].pe_hold2150 g_row\[0\].g_col\[1\].pe_hold2908/X VGND VGND VPWR
+ VPWR g_row\[0\].g_col\[1\].pe_hold2909/A sky130_fd_sc_hd__clkbuf_2
XFILLER_15_244 VGND VGND VPWR VPWR sky130_fd_sc_hd__fill_1
Xg_row\[0\].g_col\[1\].pe_hold2183 g_row\[0\].g_col\[1\].pe_hold2993/X VGND VGND VPWR
+ VPWR g_row\[0\].g_col\[1\].pe__2672_/C sky130_fd_sc_hd__clkbuf_2
XFILLER_15_299 VGND VGND VPWR VPWR sky130_fd_sc_hd__fill_2
XFILLER_30_225 VGND VGND VPWR VPWR sky130_fd_sc_hd__fill_2
XTAP_TAPCELL_ROW_13_401 VGND VPWR sky130_fd_sc_hd__tapvpwrvgnd_1
XTAP_TAPCELL_ROW_13_412 VGND VPWR sky130_fd_sc_hd__tapvpwrvgnd_1
XFILLER_7_454 VGND VGND VPWR VPWR sky130_fd_sc_hd__fill_2
XPHY_EDGE_ROW_36_Left_130 VGND VGND VPWR VPWR sky130_fd_sc_hd__decap_3
X_137_ _271_/A _137_/B_N VGND VGND VPWR VPWR _137_/Y sky130_fd_sc_hd__nor2b_4
Xg_row\[1\].g_col\[0\].pe__1801_ place1106/A g_row\[1\].g_col\[0\].pe__1801_/B g_row\[1\].g_col\[0\].pe__1801_/C
+ VGND VGND VPWR VPWR g_row\[1\].g_col\[0\].pe__1801_/X sky130_fd_sc_hd__and3_2
Xg_row\[1\].g_col\[0\].pe__1732_ place1102/X g_row\[1\].g_col\[0\].pe__1732_/A2 g_row\[1\].g_col\[0\].pe__1732_/B1
+ place1104/X VGND VGND VPWR VPWR g_row\[1\].g_col\[0\].pe__1733_/B sky130_fd_sc_hd__a22o_2
Xg_row\[1\].g_col\[0\].pe__1663_ g_row\[1\].g_col\[0\].pe__1663_/A g_row\[1\].g_col\[0\].pe__1663_/B
+ VGND VGND VPWR VPWR g_row\[1\].g_col\[0\].pe__1697_/B sky130_fd_sc_hd__xnor2_2
XFILLER_66_612 VGND VGND VPWR VPWR sky130_fd_sc_hd__decap_3
XFILLER_78_450 VGND VGND VPWR VPWR sky130_fd_sc_hd__fill_1
Xg_row\[0\].g_col\[0\].pe__1810_ g_row\[0\].g_col\[0\].pe__1811_/A g_row\[0\].g_col\[0\].pe__1811_/B
+ g_row\[0\].g_col\[0\].pe__1803_/Y g_row\[0\].g_col\[0\].pe__1808_/X g_row\[0\].g_col\[0\].pe__1809_/X
+ VGND VGND VPWR VPWR g_row\[0\].g_col\[0\].pe__1810_/X sky130_fd_sc_hd__o41a_2
Xg_row\[1\].g_col\[0\].pe__1594_ g_row\[1\].g_col\[0\].pe__1594_/A g_row\[1\].g_col\[0\].pe__1594_/B
+ VGND VGND VPWR VPWR g_row\[1\].g_col\[0\].pe__1594_/Y sky130_fd_sc_hd__nand2_2
XFILLER_65_122 VGND VGND VPWR VPWR sky130_fd_sc_hd__fill_2
XFILLER_66_645 VGND VGND VPWR VPWR sky130_fd_sc_hd__fill_2
Xg_row\[0\].g_col\[0\].pe__1741_ g_row\[0\].g_col\[0\].pe__1776_/A g_row\[0\].g_col\[0\].pe__1776_/B
+ g_row\[0\].g_col\[0\].pe__1740_/Y VGND VGND VPWR VPWR g_row\[0\].g_col\[0\].pe__1815_/B
+ sky130_fd_sc_hd__a21oi_2
Xg_row\[1\].g_col\[1\].pe__2300_ g_row\[1\].g_col\[1\].pe__2300_/A g_row\[1\].g_col\[1\].pe__2300_/B
+ VGND VGND VPWR VPWR g_row\[1\].g_col\[1\].pe__2304_/A sky130_fd_sc_hd__or2_2
XFILLER_93_453 VGND VGND VPWR VPWR sky130_fd_sc_hd__fill_2
Xg_row\[1\].g_col\[1\].pe__2231_ g_row\[1\].g_col\[1\].pe__2231_/A g_row\[1\].g_col\[1\].pe__2231_/B
+ VGND VGND VPWR VPWR g_row\[1\].g_col\[1\].pe__2231_/Y sky130_fd_sc_hd__nand2_2
XFILLER_19_561 VGND VGND VPWR VPWR sky130_fd_sc_hd__decap_3
XFILLER_53_317 VGND VGND VPWR VPWR sky130_fd_sc_hd__decap_3
XFILLER_81_626 VGND VGND VPWR VPWR sky130_fd_sc_hd__fill_2
Xg_row\[0\].g_col\[0\].pe__1672_ g_row\[0\].g_col\[0\].pe__1672_/A1 g_row\[0\].g_col\[0\].pe__1715_/B
+ g_row\[0\].g_col\[0\].pe__1863_/B1 place1222/X VGND VGND VPWR VPWR g_row\[0\].g_col\[0\].pe__1673_/B
+ sky130_fd_sc_hd__a22o_2
Xg_row\[1\].g_col\[0\].pe__2215_ g_row\[1\].g_col\[0\].pe__2241_/B2 g_row\[1\].g_col\[0\].pe__1558_/B
+ g_row\[1\].g_col\[0\].pe__2388_/B place1090/A VGND VGND VPWR VPWR g_row\[1\].g_col\[0\].pe__2239_/A
+ sky130_fd_sc_hd__a22o_2
XFILLER_81_659 VGND VGND VPWR VPWR sky130_fd_sc_hd__decap_3
Xg_row\[1\].g_col\[1\].pe__2162_ g_row\[1\].g_col\[1\].pe__2148_/A g_row\[1\].g_col\[1\].pe__2162_/B
+ VGND VGND VPWR VPWR g_row\[1\].g_col\[1\].pe__2231_/A sky130_fd_sc_hd__and2b_2
Xg_row\[1\].g_col\[0\].pe__2146_ g_row\[1\].g_col\[0\].pe__2192_/A g_row\[1\].g_col\[0\].pe__2192_/B
+ VGND VGND VPWR VPWR g_row\[1\].g_col\[0\].pe__2147_/B sky130_fd_sc_hd__xor2_2
XFILLER_22_704 VGND VGND VPWR VPWR sky130_fd_sc_hd__decap_3
Xg_row\[1\].g_col\[1\].pe__2093_ g_row\[1\].g_col\[1\].pe__2094_/B g_row\[1\].g_col\[1\].pe__2094_/C
+ g_row\[1\].g_col\[1\].pe__2094_/A VGND VGND VPWR VPWR g_row\[1\].g_col\[1\].pe__2184_/C
+ sky130_fd_sc_hd__a21o_2
XFILLER_21_225 VGND VGND VPWR VPWR sky130_fd_sc_hd__fill_1
Xg_row\[1\].g_col\[0\].pe__2077_ g_row\[1\].g_col\[0\].pe__2077_/A g_row\[1\].g_col\[0\].pe__2119_/B
+ VGND VGND VPWR VPWR g_row\[1\].g_col\[0\].pe__2078_/B sky130_fd_sc_hd__xnor2_2
Xg_row\[0\].g_col\[1\].pe__2240_ g_row\[0\].g_col\[1\].pe__2207_/B g_row\[0\].g_col\[1\].pe__2210_/B
+ g_row\[0\].g_col\[1\].pe__2207_/A VGND VGND VPWR VPWR g_row\[0\].g_col\[1\].pe__2288_/A
+ sky130_fd_sc_hd__a21bo_2
Xg_row\[0\].g_col\[0\].pe__2224_ g_row\[0\].g_col\[0\].pe__2258_/A g_row\[0\].g_col\[0\].pe__2258_/B
+ VGND VGND VPWR VPWR g_row\[0\].g_col\[0\].pe__2226_/A sky130_fd_sc_hd__xor2_2
Xg_row\[0\].g_col\[0\].pe__2155_ g_row\[0\].g_col\[0\].pe__2200_/A g_row\[0\].g_col\[0\].pe__2155_/B
+ g_row\[0\].g_col\[0\].pe__2300_/A VGND VGND VPWR VPWR g_row\[0\].g_col\[0\].pe__2155_/X
+ sky130_fd_sc_hd__and3_2
Xg_row\[0\].g_col\[1\].pe__2171_ g_row\[0\].g_col\[1\].pe__2209_/A g_row\[0\].g_col\[1\].pe__2171_/B
+ VGND VGND VPWR VPWR g_row\[0\].g_col\[1\].pe__2172_/B sky130_fd_sc_hd__xnor2_2
XTAP_TAPCELL_ROW_73_1303 VGND VPWR sky130_fd_sc_hd__tapvpwrvgnd_1
Xg_row\[0\].g_col\[0\].pe__2086_ g_row\[0\].g_col\[0\].pe__2085_/B g_row\[0\].g_col\[0\].pe__2085_/C
+ g_row\[0\].g_col\[0\].pe__2165_/A VGND VGND VPWR VPWR g_row\[0\].g_col\[0\].pe__2087_/D
+ sky130_fd_sc_hd__a21o_2
Xg_row\[1\].g_col\[1\].pe__1946_ g_row\[1\].g_col\[1\].pe__1946_/A VGND VGND VPWR
+ VPWR g_row\[1\].g_col\[1\].pe__2455_/A sky130_fd_sc_hd__inv_2
XFILLER_0_107 VGND VGND VPWR VPWR sky130_fd_sc_hd__fill_1
Xg_row\[1\].g_col\[1\].pe__1877_ g_row\[1\].g_col\[1\].pe__1932_/B g_row\[1\].g_col\[1\].pe__1877_/B
+ VGND VGND VPWR VPWR g_row\[1\].g_col\[1\].pe__1878_/B sky130_fd_sc_hd__xnor2_2
Xhold3035 hold3035/A VGND VGND VPWR VPWR hold3035/X sky130_fd_sc_hd__clkbuf_2
Xhold3057 hold3057/A VGND VGND VPWR VPWR hold3057/X sky130_fd_sc_hd__clkbuf_2
XFILLER_57_601 VGND VGND VPWR VPWR sky130_fd_sc_hd__decap_3
Xhold1600 hold3536/X VGND VGND VPWR VPWR hold3537/A sky130_fd_sc_hd__clkbuf_2
XFILLER_29_325 VGND VGND VPWR VPWR sky130_fd_sc_hd__decap_3
XFILLER_69_483 VGND VGND VPWR VPWR sky130_fd_sc_hd__fill_1
Xhold1611 hold2772/X VGND VGND VPWR VPWR hold2773/A sky130_fd_sc_hd__clkbuf_2
Xhold1622 hold3594/X VGND VGND VPWR VPWR hold2801/A sky130_fd_sc_hd__clkbuf_2
Xhold1633 hold1657/X VGND VGND VPWR VPWR hold1658/A sky130_fd_sc_hd__clkbuf_2
Xg_row\[0\].g_col\[1\].pe__1955_ g_row\[0\].g_col\[1\].pe__1955_/A g_row\[0\].g_col\[1\].pe__1955_/B
+ VGND VGND VPWR VPWR g_row\[0\].g_col\[1\].pe__1955_/X sky130_fd_sc_hd__and2_2
Xg_row\[0\].g_col\[0\].pe__1939_ g_row\[0\].g_col\[0\].pe__1939_/A g_row\[0\].g_col\[0\].pe__1939_/B
+ VGND VGND VPWR VPWR g_row\[0\].g_col\[0\].pe__1941_/C sky130_fd_sc_hd__xnor2_2
XFILLER_44_328 VGND VGND VPWR VPWR sky130_fd_sc_hd__fill_2
Xg_row\[1\].g_col\[1\].pe__2429_ g_row\[1\].g_col\[1\].pe__2751_/Q g_row\[1\].g_col\[1\].pe__2429_/B
+ VGND VGND VPWR VPWR g_row\[1\].g_col\[1\].pe__2478_/B sky130_fd_sc_hd__xnor2_2
Xg_row\[0\].g_col\[1\].pe__1886_ g_row\[0\].g_col\[1\].pe__1886_/A g_row\[0\].g_col\[1\].pe__1897_/B
+ VGND VGND VPWR VPWR g_row\[0\].g_col\[1\].pe__1888_/C sky130_fd_sc_hd__xnor2_2
XFILLER_25_564 VGND VGND VPWR VPWR sky130_fd_sc_hd__fill_1
XFILLER_52_361 VGND VGND VPWR VPWR sky130_fd_sc_hd__decap_3
XFILLER_71_169 VGND VGND VPWR VPWR sky130_fd_sc_hd__decap_3
XTAP_TAPCELL_ROW_84_1465 VGND VPWR sky130_fd_sc_hd__tapvpwrvgnd_1
XTAP_TAPCELL_ROW_84_1476 VGND VPWR sky130_fd_sc_hd__tapvpwrvgnd_1
XFILLER_9_708 VGND VGND VPWR VPWR sky130_fd_sc_hd__decap_3
Xg_row\[0\].g_col\[1\].pe__2507_ g_row\[0\].g_col\[1\].pe__2575_/A g_row\[0\].g_col\[1\].pe__2507_/B
+ VGND VGND VPWR VPWR g_row\[0\].g_col\[1\].pe__2507_/Y sky130_fd_sc_hd__nor2_2
Xg_row\[0\].g_col\[0\].pe_place1203 hold2339/A VGND VGND VPWR VPWR g_row\[0\].g_col\[0\].pe__2241_/B2
+ sky130_fd_sc_hd__buf_6
Xg_row\[0\].g_col\[1\].pe__2438_ g_row\[0\].g_col\[1\].pe__2764_/Q g_row\[0\].g_col\[1\].pe__2438_/B
+ VGND VGND VPWR VPWR g_row\[0\].g_col\[1\].pe__2471_/A sky130_fd_sc_hd__xnor2_2
Xg_row\[0\].g_col\[0\].pe_place1225 g_row\[0\].g_col\[0\].pe__1377_/Y VGND VGND VPWR
+ VPWR g_row\[0\].g_col\[0\].pe__2595_/A sky130_fd_sc_hd__buf_6
Xg_row\[0\].g_col\[1\].pe__2369_ g_row\[0\].g_col\[1\].pe__2368_/A g_row\[0\].g_col\[1\].pe__2368_/B
+ g_row\[0\].g_col\[1\].pe__2367_/X VGND VGND VPWR VPWR g_row\[0\].g_col\[1\].pe__2370_/B
+ sky130_fd_sc_hd__o21bai_2
Xg_row\[1\].g_col\[1\].pe_hold2843 g_row\[1\].g_col\[1\].pe__2653_/X VGND VGND VPWR
+ VPWR g_row\[1\].g_col\[1\].pe__2654_/C1 sky130_fd_sc_hd__clkbuf_2
XFILLER_69_65 VGND VGND VPWR VPWR sky130_fd_sc_hd__fill_2
Xg_row\[1\].g_col\[1\].pe_hold2865 g_row\[1\].g_col\[1\].pe__2716_/Q VGND VGND VPWR
+ VPWR g_row\[1\].g_col\[1\].pe__2661_/B sky130_fd_sc_hd__clkbuf_2
XFILLER_79_247 VGND VGND VPWR VPWR sky130_fd_sc_hd__fill_1
XFILLER_0_652 VGND VGND VPWR VPWR sky130_fd_sc_hd__fill_2
XFILLER_48_645 VGND VGND VPWR VPWR sky130_fd_sc_hd__fill_2
Xhold3591 hold3591/A VGND VGND VPWR VPWR hold3591/X sky130_fd_sc_hd__clkbuf_2
Xhold3580 hold3580/A VGND VGND VPWR VPWR hold3580/X sky130_fd_sc_hd__clkbuf_2
XFILLER_90_434 VGND VGND VPWR VPWR sky130_fd_sc_hd__fill_1
Xg_row\[1\].g_col\[0\].pe__2000_ g_row\[1\].g_col\[0\].pe__1935_/A g_row\[1\].g_col\[0\].pe__1998_/X
+ g_row\[1\].g_col\[0\].pe__1999_/X VGND VGND VPWR VPWR g_row\[1\].g_col\[0\].pe__2001_/B
+ sky130_fd_sc_hd__o21a_2
XFILLER_31_501 VGND VGND VPWR VPWR sky130_fd_sc_hd__decap_3
XFILLER_50_309 VGND VGND VPWR VPWR sky130_fd_sc_hd__fill_2
XFILLER_31_556 VGND VGND VPWR VPWR sky130_fd_sc_hd__decap_3
XFILLER_31_589 VGND VGND VPWR VPWR sky130_fd_sc_hd__fill_1
XFILLER_8_741 VGND VGND VPWR VPWR sky130_fd_sc_hd__fill_2
Xg_row\[0\].g_col\[1\].pe_place1170 g_row\[0\].g_col\[1\].pe__2656_/B1 VGND VGND VPWR
+ VPWR g_row\[0\].g_col\[1\].pe__2687_/C1 sky130_fd_sc_hd__buf_6
Xg_row\[1\].g_col\[1\].pe__1800_ g_row\[1\].g_col\[1\].pe__1808_/A g_row\[1\].g_col\[1\].pe__1800_/B
+ VGND VGND VPWR VPWR g_row\[1\].g_col\[1\].pe__1801_/C sky130_fd_sc_hd__xnor2_2
Xg_row\[1\].g_col\[0\].pe__2764_ clkbuf_leaf_56_clk/X g_row\[1\].g_col\[0\].pe__2764_/D
+ VGND VGND VPWR VPWR g_row\[1\].g_col\[0\].pe__2764_/Q sky130_fd_sc_hd__dfxtp_2
XTAP_TAPCELL_ROW_55_1033 VGND VPWR sky130_fd_sc_hd__tapvpwrvgnd_1
Xg_row\[1\].g_col\[1\].pe__1731_ g_row\[1\].g_col\[1\].pe__1734_/A g_row\[1\].g_col\[1\].pe__1734_/B
+ VGND VGND VPWR VPWR g_row\[1\].g_col\[1\].pe__1758_/A sky130_fd_sc_hd__xor2_2
Xg_row\[1\].g_col\[0\].pe__1715_ place1106/X g_row\[1\].g_col\[0\].pe__1715_/B VGND
+ VGND VPWR VPWR g_row\[1\].g_col\[0\].pe__1724_/S sky130_fd_sc_hd__nand2_2
XFILLER_86_707 VGND VGND VPWR VPWR sky130_fd_sc_hd__decap_3
Xg_row\[1\].g_col\[1\].pe__1662_ g_row\[1\].g_col\[1\].pe__1662_/A g_row\[1\].g_col\[1\].pe__1662_/B
+ VGND VGND VPWR VPWR g_row\[1\].g_col\[1\].pe__1663_/B sky130_fd_sc_hd__xor2_2
Xg_row\[1\].g_col\[0\].pe__2695_ _304_/CLK g_row\[1\].g_col\[0\].pe__2695_/D VGND
+ VGND VPWR VPWR hold1950/A sky130_fd_sc_hd__dfxtp_2
XFILLER_79_770 VGND VGND VPWR VPWR sky130_fd_sc_hd__fill_2
Xg_row\[1\].g_col\[0\].pe__1646_ place1096/X g_row\[1\].g_col\[0\].pe__1732_/A2 g_row\[1\].g_col\[0\].pe__1732_/B1
+ place1098/X VGND VGND VPWR VPWR g_row\[1\].g_col\[0\].pe__1647_/B sky130_fd_sc_hd__a22o_2
Xg_row\[1\].g_col\[1\].pe__1593_ g_row\[1\].g_col\[1\].pe__1594_/A g_row\[1\].g_col\[1\].pe__1594_/B
+ VGND VGND VPWR VPWR g_row\[1\].g_col\[1\].pe__1593_/Y sky130_fd_sc_hd__nor2_2
Xg_row\[1\].g_col\[0\].pe_hold1820 g_row\[1\].g_col\[0\].pe__2763_/Q VGND VGND VPWR
+ VPWR g_row\[1\].g_col\[0\].pe__2560_/A1 sky130_fd_sc_hd__clkbuf_2
Xg_row\[1\].g_col\[0\].pe__1577_ place1085/X g_row\[1\].g_col\[0\].pe__1982_/B g_row\[1\].g_col\[0\].pe__1424_/Y
+ place1087/X VGND VGND VPWR VPWR g_row\[1\].g_col\[0\].pe__1578_/B sky130_fd_sc_hd__a22o_2
XFILLER_27_807 VGND VGND VPWR VPWR sky130_fd_sc_hd__fill_2
Xg_row\[1\].g_col\[0\].pe_hold1842 g_row\[1\].g_col\[0\].pe__1950_/Y VGND VGND VPWR
+ VPWR g_row\[1\].g_col\[0\].pe__2011_/A1 sky130_fd_sc_hd__clkbuf_2
Xg_row\[1\].g_col\[0\].pe_hold1831 g_row\[1\].g_col\[0\].pe__2739_/Q VGND VGND VPWR
+ VPWR g_row\[1\].g_col\[0\].pe__1835_/A2 sky130_fd_sc_hd__clkbuf_2
Xg_row\[0\].g_col\[1\].pe_hold2908 g_row\[0\].g_col\[1\].pe__2677_/X VGND VGND VPWR
+ VPWR g_row\[0\].g_col\[1\].pe_hold2908/X sky130_fd_sc_hd__clkbuf_2
Xg_row\[0\].g_col\[0\].pe__1724_ g_row\[0\].g_col\[0\].pe__1718_/B ANTENNA_182/DIODE
+ g_row\[0\].g_col\[0\].pe__1724_/S VGND VGND VPWR VPWR g_row\[0\].g_col\[0\].pe__1745_/A
+ sky130_fd_sc_hd__mux2_1
Xg_row\[0\].g_col\[1\].pe__1740_ g_row\[0\].g_col\[1\].pe__1740_/A g_row\[0\].g_col\[1\].pe__1740_/B
+ VGND VGND VPWR VPWR g_row\[0\].g_col\[1\].pe__1740_/Y sky130_fd_sc_hd__nor2_2
Xg_row\[1\].g_col\[0\].pe_hold1897 g_row\[1\].g_col\[0\].pe_hold2848/X VGND VGND VPWR
+ VPWR g_row\[1\].g_col\[0\].pe_hold2849/A sky130_fd_sc_hd__clkbuf_2
Xg_row\[1\].g_col\[0\].pe_hold1886 g_row\[1\].g_col\[0\].pe__1401_/X VGND VGND VPWR
+ VPWR g_row\[1\].g_col\[0\].pe__2736_/D sky130_fd_sc_hd__clkbuf_2
Xg_row\[1\].g_col\[0\].pe_hold1875 g_row\[1\].g_col\[0\].pe_hold3048/X VGND VGND VPWR
+ VPWR g_row\[1\].g_col\[0\].pe__2735_/D sky130_fd_sc_hd__clkbuf_2
Xg_row\[1\].g_col\[0\].pe_hold1864 g_row\[1\].g_col\[0\].pe_hold2899/X VGND VGND VPWR
+ VPWR g_row\[1\].g_col\[0\].pe_hold2900/A sky130_fd_sc_hd__clkbuf_2
XFILLER_53_136 VGND VGND VPWR VPWR sky130_fd_sc_hd__decap_3
XFILLER_54_648 VGND VGND VPWR VPWR sky130_fd_sc_hd__decap_3
Xg_row\[0\].g_col\[0\].pe__1655_ g_row\[0\].g_col\[0\].pe__1864_/A g_row\[0\].g_col\[0\].pe__1655_/B
+ VGND VGND VPWR VPWR g_row\[0\].g_col\[0\].pe__1656_/B sky130_fd_sc_hd__xnor2_2
Xg_row\[0\].g_col\[1\].pe__1671_ g_row\[0\].g_col\[1\].pe__1816_/A g_row\[0\].g_col\[1\].pe__1671_/B
+ VGND VGND VPWR VPWR g_row\[0\].g_col\[1\].pe__1690_/A sky130_fd_sc_hd__xor2_2
Xg_row\[1\].g_col\[1\].pe__2214_ g_row\[1\].g_col\[1\].pe__2169_/B g_row\[1\].g_col\[1\].pe__2172_/B
+ g_row\[1\].g_col\[1\].pe__2167_/X VGND VGND VPWR VPWR g_row\[1\].g_col\[1\].pe__2219_/A
+ sky130_fd_sc_hd__a21o_2
XFILLER_62_670 VGND VGND VPWR VPWR sky130_fd_sc_hd__decap_3
XFILLER_22_523 VGND VGND VPWR VPWR sky130_fd_sc_hd__decap_3
XTAP_TAPCELL_ROW_45_890 VGND VPWR sky130_fd_sc_hd__tapvpwrvgnd_1
XTAP_TAPCELL_ROW_66_1195 VGND VPWR sky130_fd_sc_hd__tapvpwrvgnd_1
Xg_row\[0\].g_col\[0\].pe__1586_ g_row\[0\].g_col\[0\].pe__1634_/A g_row\[0\].g_col\[0\].pe__1634_/B
+ VGND VGND VPWR VPWR g_row\[0\].g_col\[0\].pe__1587_/B sky130_fd_sc_hd__xnor2_2
Xg_row\[1\].g_col\[1\].pe__2145_ g_row\[1\].g_col\[1\].pe__2145_/A g_row\[1\].g_col\[1\].pe__2104_/A
+ VGND VGND VPWR VPWR g_row\[1\].g_col\[1\].pe__2192_/B sky130_fd_sc_hd__nor2b_4
Xg_row\[1\].g_col\[0\].pe__2129_ g_row\[1\].g_col\[0\].pe__2129_/A g_row\[1\].g_col\[0\].pe__2129_/B
+ VGND VGND VPWR VPWR g_row\[1\].g_col\[0\].pe__2132_/A sky130_fd_sc_hd__nor2_2
XFILLER_10_718 VGND VGND VPWR VPWR sky130_fd_sc_hd__decap_3
XFILLER_22_567 VGND VGND VPWR VPWR sky130_fd_sc_hd__fill_1
Xg_row\[1\].g_col\[1\].pe__2076_ g_row\[1\].g_col\[1\].pe__2136_/A g_row\[1\].g_col\[1\].pe__2136_/B
+ VGND VGND VPWR VPWR g_row\[1\].g_col\[1\].pe__2119_/B sky130_fd_sc_hd__xor2_2
Xg_row\[0\].g_col\[0\].pe__2207_ g_row\[0\].g_col\[0\].pe__2207_/A g_row\[0\].g_col\[0\].pe__2207_/B
+ VGND VGND VPWR VPWR g_row\[0\].g_col\[0\].pe__2210_/A sky130_fd_sc_hd__nand2_2
Xg_row\[0\].g_col\[1\].pe__2223_ g_row\[0\].g_col\[1\].pe__2183_/A g_row\[0\].g_col\[1\].pe__2183_/B
+ g_row\[0\].g_col\[1\].pe__2222_/X VGND VGND VPWR VPWR g_row\[0\].g_col\[1\].pe__2258_/B
+ sky130_fd_sc_hd__o21ai_2
Xg_row\[0\].g_col\[1\].pe__2154_ g_row\[0\].g_col\[1\].pe__2062_/C g_row\[0\].g_col\[1\].pe__2150_/X
+ g_row\[0\].g_col\[1\].pe__2153_/X g_row\[0\].g_col\[1\].pe__2111_/A VGND VGND VPWR
+ VPWR g_row\[0\].g_col\[1\].pe__2300_/A sky130_fd_sc_hd__a211oi_2
Xg_row\[0\].g_col\[0\].pe__2138_ place1208/A g_row\[0\].g_col\[0\].pe__2278_/A2 g_row\[0\].g_col\[0\].pe__2278_/B1
+ place1210/A VGND VGND VPWR VPWR g_row\[0\].g_col\[0\].pe__2174_/A sky130_fd_sc_hd__a22o_2
Xg_row\[0\].g_col\[0\].pe__2069_ g_row\[0\].g_col\[0\].pe__2058_/A g_row\[0\].g_col\[0\].pe__2058_/B
+ g_row\[0\].g_col\[0\].pe__2068_/Y VGND VGND VPWR VPWR g_row\[0\].g_col\[0\].pe__2117_/A
+ sky130_fd_sc_hd__o21ba_2
Xg_row\[1\].g_col\[1\].pe__1929_ g_row\[1\].g_col\[1\].pe__1874_/A g_row\[1\].g_col\[1\].pe__1874_/B
+ g_row\[1\].g_col\[1\].pe__1928_/X VGND VGND VPWR VPWR g_row\[1\].g_col\[1\].pe__1994_/B
+ sky130_fd_sc_hd__a21oi_2
Xg_row\[0\].g_col\[1\].pe__2085_ g_row\[0\].g_col\[1\].pe__2123_/A g_row\[0\].g_col\[1\].pe__2085_/B
+ g_row\[0\].g_col\[1\].pe__2085_/C VGND VGND VPWR VPWR g_row\[0\].g_col\[1\].pe__2087_/C
+ sky130_fd_sc_hd__nand3_2
XFILLER_1_449 VGND VGND VPWR VPWR sky130_fd_sc_hd__fill_2
XFILLER_89_578 VGND VGND VPWR VPWR sky130_fd_sc_hd__fill_1
XFILLER_29_100 VGND VGND VPWR VPWR sky130_fd_sc_hd__fill_1
XFILLER_29_133 VGND VGND VPWR VPWR sky130_fd_sc_hd__fill_1
XTAP_TAPCELL_ROW_4_265 VGND VPWR sky130_fd_sc_hd__tapvpwrvgnd_1
Xhold1430 hold3135/X VGND VGND VPWR VPWR hold3136/A sky130_fd_sc_hd__clkbuf_2
Xhold1441 hold3166/X VGND VGND VPWR VPWR hold3167/A sky130_fd_sc_hd__clkbuf_2
Xhold1452 hold2454/X VGND VGND VPWR VPWR hold2455/A sky130_fd_sc_hd__clkbuf_2
Xhold2186 hold2186/A VGND VGND VPWR VPWR hold2186/X sky130_fd_sc_hd__clkbuf_2
XFILLER_17_328 VGND VGND VPWR VPWR sky130_fd_sc_hd__fill_1
XFILLER_29_166 VGND VGND VPWR VPWR sky130_fd_sc_hd__fill_2
XFILLER_57_497 VGND VGND VPWR VPWR sky130_fd_sc_hd__decap_3
XTAP_TAPCELL_ROW_4_276 VGND VPWR sky130_fd_sc_hd__tapvpwrvgnd_1
XTAP_TAPCELL_ROW_86_1505 VGND VPWR sky130_fd_sc_hd__tapvpwrvgnd_1
Xhold1463 hold3163/X VGND VGND VPWR VPWR hold3164/A sky130_fd_sc_hd__clkbuf_2
Xhold1474 hold3194/X VGND VGND VPWR VPWR hold3195/A sky130_fd_sc_hd__clkbuf_2
Xhold1485 hold2508/X VGND VGND VPWR VPWR hold2509/A sky130_fd_sc_hd__clkbuf_2
Xg_row\[0\].g_col\[1\].pe__1938_ g_row\[0\].g_col\[1\].pe__1938_/A g_row\[0\].g_col\[1\].pe__1952_/A
+ VGND VGND VPWR VPWR g_row\[0\].g_col\[1\].pe__1939_/B sky130_fd_sc_hd__xnor2_2
Xhold1496 hold3289/X VGND VGND VPWR VPWR hold3290/A sky130_fd_sc_hd__clkbuf_2
Xg_row\[0\].g_col\[1\].pe__1869_ g_row\[0\].g_col\[1\].pe__2121_/A g_row\[0\].g_col\[1\].pe__1414_/X
+ g_row\[0\].g_col\[1\].pe__1415_/Y g_row\[0\].g_col\[1\].pe__1801_/B g_row\[0\].g_col\[1\].pe__2163_/A
+ VGND VGND VPWR VPWR g_row\[0\].g_col\[1\].pe__1870_/B sky130_fd_sc_hd__a32o_2
XFILLER_72_489 VGND VGND VPWR VPWR sky130_fd_sc_hd__fill_2
Xg_row\[1\].g_col\[0\].pe_place846 g_row\[1\].g_col\[0\].pe__1504_/Y VGND VGND VPWR
+ VPWR g_row\[1\].g_col\[0\].pe__2313_/A2 sky130_fd_sc_hd__buf_6
XFILLER_53_681 VGND VGND VPWR VPWR sky130_fd_sc_hd__decap_3
XTAP_TAPCELL_ROW_43_849 VGND VPWR sky130_fd_sc_hd__tapvpwrvgnd_1
Xg_row\[0\].g_col\[0\].pe_hold1907 g_row\[0\].g_col\[0\].pe__2738_/Q VGND VGND VPWR
+ VPWR g_row\[0\].g_col\[0\].pe__1406_/A sky130_fd_sc_hd__clkbuf_2
XFILLER_13_567 VGND VGND VPWR VPWR sky130_fd_sc_hd__fill_1
XFILLER_71_55 VGND VGND VPWR VPWR sky130_fd_sc_hd__fill_1
XFILLER_40_386 VGND VGND VPWR VPWR sky130_fd_sc_hd__decap_3
XTAP_TAPCELL_ROW_23_551 VGND VPWR sky130_fd_sc_hd__tapvpwrvgnd_1
XTAP_TAPCELL_ROW_23_562 VGND VPWR sky130_fd_sc_hd__tapvpwrvgnd_1
Xg_row\[0\].g_col\[0\].pe_place1000 g_row\[0\].g_col\[0\].pe__2684_/B VGND VGND VPWR
+ VPWR g_row\[0\].g_col\[0\].pe__2686_/B sky130_fd_sc_hd__buf_6
XFILLER_5_700 VGND VGND VPWR VPWR sky130_fd_sc_hd__fill_1
Xinput1351 hold3140/X VGND VGND VPWR VPWR hold3141/A sky130_fd_sc_hd__buf_2
Xinput1340 hold3420/X VGND VGND VPWR VPWR hold3421/A sky130_fd_sc_hd__buf_2
Xg_row\[1\].g_col\[0\].pe__1500_ g_row\[1\].g_col\[0\].pe__1500_/A g_row\[1\].g_col\[0\].pe__1500_/B
+ VGND VGND VPWR VPWR g_row\[1\].g_col\[0\].pe__1510_/B sky130_fd_sc_hd__xor2_2
XFILLER_68_707 VGND VGND VPWR VPWR sky130_fd_sc_hd__decap_3
Xg_row\[1\].g_col\[1\].pe_hold1961 g_row\[1\].g_col\[1\].pe_hold3072/X VGND VGND VPWR
+ VPWR g_row\[1\].g_col\[1\].pe__2735_/D sky130_fd_sc_hd__clkbuf_2
Xg_row\[1\].g_col\[0\].pe__2480_ g_row\[1\].g_col\[0\].pe__2478_/A g_row\[1\].g_col\[0\].pe__2478_/B
+ g_row\[1\].g_col\[0\].pe__2479_/X VGND VGND VPWR VPWR g_row\[1\].g_col\[0\].pe__2585_/A
+ sky130_fd_sc_hd__o21ai_2
XFILLER_0_482 VGND VGND VPWR VPWR sky130_fd_sc_hd__decap_3
Xg_row\[1\].g_col\[1\].pe_hold1983 g_row\[1\].g_col\[1\].pe__2693_/Q VGND VGND VPWR
+ VPWR g_row\[1\].g_col\[1\].pe__2607_/B sky130_fd_sc_hd__clkbuf_2
Xg_row\[1\].g_col\[0\].pe__1431_ g_row\[1\].g_col\[0\].pe__1749_/A1 place1084/X place1085/X
+ g_row\[1\].g_col\[0\].pe__1641_/B2 VGND VGND VPWR VPWR g_row\[1\].g_col\[0\].pe__1432_/B
+ sky130_fd_sc_hd__a22o_2
XFILLER_76_751 VGND VGND VPWR VPWR sky130_fd_sc_hd__decap_3
Xg_row\[1\].g_col\[0\].pe__1362_ g_row\[1\].g_col\[0\].pe__2766_/Q g_row\[1\].g_col\[0\].pe__1361_/B
+ g_row\[1\].g_col\[0\].pe__2594_/B2 VGND VGND VPWR VPWR g_row\[1\].g_col\[0\].pe__1363_/B
+ sky130_fd_sc_hd__o21ai_2
XFILLER_35_103 VGND VGND VPWR VPWR sky130_fd_sc_hd__fill_1
XFILLER_36_648 VGND VGND VPWR VPWR sky130_fd_sc_hd__fill_1
XFILLER_91_732 VGND VGND VPWR VPWR sky130_fd_sc_hd__fill_2
XFILLER_91_776 VGND VGND VPWR VPWR sky130_fd_sc_hd__fill_1
Xg_row\[0\].g_col\[0\].pe__1440_ place1207/X g_row\[0\].g_col\[0\].pe__1732_/A2 g_row\[0\].g_col\[0\].pe__1732_/B1
+ place1209/X VGND VGND VPWR VPWR g_row\[0\].g_col\[0\].pe__1441_/B sky130_fd_sc_hd__a22o_2
XFILLER_31_320 VGND VGND VPWR VPWR sky130_fd_sc_hd__decap_3
Xg_row\[0\].g_col\[0\].pe__1371_ g_row\[0\].g_col\[0\].pe__2424_/A g_row\[0\].g_col\[0\].pe__1371_/B
+ VGND VGND VPWR VPWR output1360/A sky130_fd_sc_hd__xnor2_2
Xg_row\[1\].g_col\[1\].pe__2763_ clkbuf_leaf_75_clk/X g_row\[1\].g_col\[1\].pe__2763_/D
+ VGND VGND VPWR VPWR g_row\[1\].g_col\[1\].pe__2763_/Q sky130_fd_sc_hd__dfxtp_2
Xg_row\[1\].g_col\[1\].pe__1714_ g_row\[1\].g_col\[1\].pe__1714_/A g_row\[1\].g_col\[1\].pe__1714_/B
+ g_row\[1\].g_col\[1\].pe__1714_/C VGND VGND VPWR VPWR g_row\[1\].g_col\[1\].pe__1742_/B
+ sky130_fd_sc_hd__nand3_2
Xg_row\[1\].g_col\[0\].pe__2747_ clkbuf_leaf_57_clk/X g_row\[1\].g_col\[0\].pe__2747_/D
+ VGND VGND VPWR VPWR g_row\[1\].g_col\[0\].pe__2747_/Q sky130_fd_sc_hd__dfxtp_2
XFILLER_59_729 VGND VGND VPWR VPWR sky130_fd_sc_hd__fill_1
Xg_row\[1\].g_col\[1\].pe__2694_ clkbuf_leaf_70_clk/X g_row\[1\].g_col\[1\].pe__2694_/D
+ VGND VGND VPWR VPWR g_row\[1\].g_col\[1\].pe__2694_/Q sky130_fd_sc_hd__dfxtp_2
Xg_row\[1\].g_col\[0\].pe_hold3030 hold1898/X VGND VGND VPWR VPWR g_row\[1\].g_col\[0\].pe__2660_/A2
+ sky130_fd_sc_hd__clkbuf_2
Xg_row\[1\].g_col\[0\].pe__2678_ g_row\[1\].g_col\[0\].pe__2686_/B g_row\[1\].g_col\[0\].pe__2678_/B
+ VGND VGND VPWR VPWR g_row\[1\].g_col\[0\].pe__2678_/Y sky130_fd_sc_hd__nand2_2
Xg_row\[1\].g_col\[1\].pe__1645_ g_row\[1\].g_col\[1\].pe__1648_/A g_row\[1\].g_col\[1\].pe__1648_/B
+ VGND VGND VPWR VPWR g_row\[1\].g_col\[1\].pe__1688_/A sky130_fd_sc_hd__xor2_2
Xg_row\[1\].g_col\[0\].pe__1629_ g_row\[1\].g_col\[0\].pe__1629_/A g_row\[1\].g_col\[0\].pe__1629_/B
+ VGND VGND VPWR VPWR g_row\[1\].g_col\[0\].pe__1883_/A sky130_fd_sc_hd__xnor2_2
Xg_row\[1\].g_col\[1\].pe__1576_ g_row\[1\].g_col\[1\].pe__1626_/A g_row\[1\].g_col\[1\].pe__1626_/B
+ VGND VGND VPWR VPWR g_row\[1\].g_col\[1\].pe__1579_/A sky130_fd_sc_hd__xor2_2
XTAP_TAPCELL_ROW_1_224 VGND VPWR sky130_fd_sc_hd__tapvpwrvgnd_1
Xg_row\[0\].g_col\[0\].pe__2756_ _324_/CLK g_row\[0\].g_col\[0\].pe__2756_/D VGND
+ VGND VPWR VPWR g_row\[0\].g_col\[0\].pe__2775_/A sky130_fd_sc_hd__dfxtp_2
Xg_row\[1\].g_col\[0\].pe_hold1661 g_row\[1\].g_col\[0\].pe__2591_/X VGND VGND VPWR
+ VPWR g_row\[1\].g_col\[0\].pe__2592_/B sky130_fd_sc_hd__clkbuf_2
XTAP_TAPCELL_ROW_68_1224 VGND VPWR sky130_fd_sc_hd__tapvpwrvgnd_1
XTAP_TAPCELL_ROW_68_1235 VGND VPWR sky130_fd_sc_hd__tapvpwrvgnd_1
Xg_row\[0\].g_col\[0\].pe__1707_ g_row\[0\].g_col\[0\].pe__2686_/A g_row\[0\].g_col\[0\].pe__1707_/B
+ VGND VGND VPWR VPWR g_row\[0\].g_col\[0\].pe__1709_/B sky130_fd_sc_hd__xor2_2
Xg_row\[0\].g_col\[1\].pe__1723_ g_row\[0\].g_col\[1\].pe__1723_/A g_row\[0\].g_col\[1\].pe__1723_/B
+ VGND VGND VPWR VPWR g_row\[0\].g_col\[1\].pe__1745_/B sky130_fd_sc_hd__xor2_2
Xg_row\[1\].g_col\[0\].pe_hold1694 g_row\[1\].g_col\[0\].pe__2236_/X VGND VGND VPWR
+ VPWR g_row\[1\].g_col\[0\].pe__2237_/B sky130_fd_sc_hd__clkbuf_2
XFILLER_25_26 VGND VGND VPWR VPWR sky130_fd_sc_hd__decap_3
XFILLER_81_242 VGND VGND VPWR VPWR sky130_fd_sc_hd__fill_2
Xg_row\[0\].g_col\[0\].pe__2687_ g_row\[0\].g_col\[0\].pe__2687_/A1 g_row\[0\].g_col\[0\].pe__2680_/B
+ g_row\[0\].g_col\[0\].pe__2686_/X g_row\[0\].g_col\[0\].pe__2687_/C1 VGND VGND VPWR
+ VPWR g_row\[0\].g_col\[0\].pe__2687_/X sky130_fd_sc_hd__o211a_2
XTAP_TAPCELL_ROW_81_1424 VGND VPWR sky130_fd_sc_hd__tapvpwrvgnd_1
Xg_row\[0\].g_col\[0\].pe__1638_ g_row\[0\].g_col\[0\].pe__1844_/A g_row\[0\].g_col\[0\].pe__1844_/B
+ VGND VGND VPWR VPWR g_row\[0\].g_col\[0\].pe__1840_/B sky130_fd_sc_hd__xnor2_2
Xg_row\[0\].g_col\[1\].pe__1654_ g_row\[0\].g_col\[1\].pe__2692_/Q g_row\[0\].g_col\[1\].pe__1715_/B
+ g_row\[0\].g_col\[1\].pe__1863_/B1 g_row\[0\].g_col\[1\].pe__2691_/Q VGND VGND VPWR
+ VPWR g_row\[0\].g_col\[1\].pe__1655_/B sky130_fd_sc_hd__a22o_2
XTAP_TAPCELL_ROW_40_808 VGND VPWR sky130_fd_sc_hd__tapvpwrvgnd_1
Xg_row\[0\].g_col\[0\].pe__1569_ place1214/X g_row\[0\].g_col\[0\].pe__1657_/B g_row\[0\].g_col\[0\].pe__2247_/B1
+ g_row\[0\].g_col\[0\].pe__1957_/B2 VGND VGND VPWR VPWR g_row\[0\].g_col\[0\].pe__1570_/B
+ sky130_fd_sc_hd__a22o_2
Xg_row\[0\].g_col\[1\].pe__1585_ g_row\[0\].g_col\[1\].pe__1533_/A g_row\[0\].g_col\[1\].pe__1533_/B
+ g_row\[0\].g_col\[1\].pe__1584_/Y VGND VGND VPWR VPWR g_row\[0\].g_col\[1\].pe__1634_/B
+ sky130_fd_sc_hd__a21oi_2
Xg_row\[1\].g_col\[1\].pe__2128_ g_row\[1\].g_col\[1\].pe__2128_/A g_row\[1\].g_col\[1\].pe__2128_/B
+ g_row\[1\].g_col\[1\].pe__2128_/C VGND VGND VPWR VPWR g_row\[1\].g_col\[1\].pe__2129_/B
+ sky130_fd_sc_hd__and3_2
XFILLER_50_662 VGND VGND VPWR VPWR sky130_fd_sc_hd__fill_2
XTAP_TAPCELL_ROW_20_510 VGND VPWR sky130_fd_sc_hd__tapvpwrvgnd_1
Xg_row\[1\].g_col\[1\].pe__2059_ g_row\[1\].g_col\[1\].pe__2059_/A g_row\[1\].g_col\[1\].pe__2067_/A
+ VGND VGND VPWR VPWR g_row\[1\].g_col\[1\].pe__2153_/B sky130_fd_sc_hd__xnor2_2
Xg_row\[0\].g_col\[1\].pe__2206_ g_row\[0\].g_col\[1\].pe__2125_/A g_row\[0\].g_col\[1\].pe__2204_/Y
+ g_row\[0\].g_col\[1\].pe__1862_/A g_row\[0\].g_col\[1\].pe__1864_/A VGND VGND VPWR
+ VPWR g_row\[0\].g_col\[1\].pe__2207_/B sky130_fd_sc_hd__o211ai_2
XTAP_TAPCELL_ROW_79_1397 VGND VPWR sky130_fd_sc_hd__tapvpwrvgnd_1
Xg_row\[0\].g_col\[1\].pe__2137_ g_row\[0\].g_col\[1\].pe__2091_/B g_row\[0\].g_col\[1\].pe__2091_/C
+ g_row\[0\].g_col\[1\].pe__2091_/A VGND VGND VPWR VPWR g_row\[0\].g_col\[1\].pe__2142_/A
+ sky130_fd_sc_hd__a21boi_2
XTAP_TAPCELL_ROW_9_346 VGND VPWR sky130_fd_sc_hd__tapvpwrvgnd_1
Xg_row\[0\].g_col\[1\].pe__2068_ g_row\[0\].g_col\[1\].pe__2068_/A g_row\[0\].g_col\[1\].pe__2068_/B
+ VGND VGND VPWR VPWR g_row\[0\].g_col\[1\].pe__2068_/Y sky130_fd_sc_hd__nor2_2
XFILLER_1_235 VGND VGND VPWR VPWR sky130_fd_sc_hd__fill_1
XTAP_TAPCELL_ROW_92_1586 VGND VPWR sky130_fd_sc_hd__tapvpwrvgnd_1
XTAP_TAPCELL_ROW_92_1597 VGND VPWR sky130_fd_sc_hd__tapvpwrvgnd_1
Xplace1281 _267_/A VGND VGND VPWR VPWR _199_/A sky130_fd_sc_hd__buf_6
XFILLER_18_615 VGND VGND VPWR VPWR sky130_fd_sc_hd__decap_3
XFILLER_73_710 VGND VGND VPWR VPWR sky130_fd_sc_hd__decap_3
XFILLER_18_637 VGND VGND VPWR VPWR sky130_fd_sc_hd__decap_3
XFILLER_45_445 VGND VGND VPWR VPWR sky130_fd_sc_hd__decap_3
XFILLER_57_294 VGND VGND VPWR VPWR sky130_fd_sc_hd__fill_1
XTAP_TAPCELL_ROW_28_632 VGND VPWR sky130_fd_sc_hd__tapvpwrvgnd_1
XFILLER_17_169 VGND VGND VPWR VPWR sky130_fd_sc_hd__decap_3
XFILLER_45_456 VGND VGND VPWR VPWR sky130_fd_sc_hd__fill_2
Xg_row\[0\].g_col\[0\].pe_hold3128 _292_/Q VGND VGND VPWR VPWR g_row\[0\].g_col\[0\].pe_hold3128/X
+ sky130_fd_sc_hd__clkbuf_2
XFILLER_33_629 VGND VGND VPWR VPWR sky130_fd_sc_hd__fill_1
XFILLER_32_139 VGND VGND VPWR VPWR sky130_fd_sc_hd__fill_1
XFILLER_60_459 VGND VGND VPWR VPWR sky130_fd_sc_hd__fill_2
Xg_row\[0\].g_col\[0\].pe_hold1704 g_row\[0\].g_col\[0\].pe__2266_/Y VGND VGND VPWR
+ VPWR g_row\[0\].g_col\[0\].pe__2267_/B1 sky130_fd_sc_hd__clkbuf_2
XFILLER_13_364 VGND VGND VPWR VPWR sky130_fd_sc_hd__fill_1
XFILLER_41_673 VGND VGND VPWR VPWR sky130_fd_sc_hd__fill_2
Xg_row\[0\].g_col\[0\].pe_hold1748 g_row\[0\].g_col\[0\].pe__2749_/Q VGND VGND VPWR
+ VPWR g_row\[0\].g_col\[0\].pe__2269_/A sky130_fd_sc_hd__clkbuf_2
Xg_row\[1\].g_col\[0\].pe__1980_ g_row\[1\].g_col\[0\].pe__1980_/A g_row\[1\].g_col\[0\].pe__1980_/B
+ g_row\[1\].g_col\[0\].pe__1980_/C VGND VGND VPWR VPWR g_row\[1\].g_col\[0\].pe__1980_/X
+ sky130_fd_sc_hd__or3_4
Xg_row\[1\].g_col\[0\].pe__2532_ g_row\[1\].g_col\[0\].pe__2533_/A g_row\[1\].g_col\[0\].pe__2533_/B
+ VGND VGND VPWR VPWR g_row\[1\].g_col\[0\].pe__2534_/B sky130_fd_sc_hd__nor2_2
Xg_row\[1\].g_col\[1\].pe_hold1780 g_row\[1\].g_col\[1\].pe__1388_/X VGND VGND VPWR
+ VPWR g_row\[1\].g_col\[1\].pe__2730_/D sky130_fd_sc_hd__clkbuf_2
Xg_row\[1\].g_col\[0\].pe__2463_ g_row\[1\].g_col\[0\].pe__2519_/A g_row\[1\].g_col\[0\].pe__2519_/B
+ g_row\[1\].g_col\[0\].pe__2462_/Y VGND VGND VPWR VPWR g_row\[1\].g_col\[0\].pe__2526_/B
+ sky130_fd_sc_hd__o21ai_2
Xg_row\[1\].g_col\[0\].pe__1414_ g_row\[1\].g_col\[0\].pe__2725_/Q g_row\[1\].g_col\[0\].pe__2724_/Q
+ g_row\[1\].g_col\[0\].pe__1785_/A VGND VGND VPWR VPWR g_row\[1\].g_col\[0\].pe__1414_/X
+ sky130_fd_sc_hd__a21o_2
Xg_row\[0\].g_col\[0\].pe__2610_ g_row\[0\].g_col\[0\].pe__2623_/A place1214/X VGND
+ VGND VPWR VPWR g_row\[0\].g_col\[0\].pe__2610_/X sky130_fd_sc_hd__or2_2
Xg_row\[1\].g_col\[0\].pe__2394_ g_row\[1\].g_col\[0\].pe__2378_/X g_row\[1\].g_col\[0\].pe__2384_/Y
+ g_row\[1\].g_col\[0\].pe__2392_/Y g_row\[1\].g_col\[0\].pe__2010_/A VGND VGND VPWR
+ VPWR g_row\[1\].g_col\[0\].pe__2394_/X sky130_fd_sc_hd__a31o_2
Xg_row\[1\].g_col\[1\].pe__1361_ g_row\[1\].g_col\[1\].pe__2766_/Q g_row\[1\].g_col\[1\].pe__1361_/B
+ VGND VGND VPWR VPWR output1408/A sky130_fd_sc_hd__xor2_2
Xg_row\[1\].g_col\[0\].pe__1345_ g_row\[1\].g_col\[0\].pe__2758_/Q g_row\[1\].g_col\[0\].pe__2757_/Q
+ g_row\[1\].g_col\[0\].pe__2775_/A g_row\[1\].g_col\[0\].pe__2776_/A VGND VGND VPWR
+ VPWR g_row\[1\].g_col\[0\].pe__1346_/B sky130_fd_sc_hd__o31a_2
XFILLER_63_253 VGND VGND VPWR VPWR sky130_fd_sc_hd__fill_1
Xg_row\[0\].g_col\[0\].pe__2541_ g_row\[0\].g_col\[0\].pe__2541_/A1 g_row\[0\].g_col\[0\].pe__2554_/A2
+ g_row\[0\].g_col\[0\].pe__2517_/Y g_row\[0\].g_col\[0\].pe__2540_/X VGND VGND VPWR
+ VPWR g_row\[0\].g_col\[0\].pe__2542_/B sky130_fd_sc_hd__a22o_2
XFILLER_17_670 VGND VGND VPWR VPWR sky130_fd_sc_hd__fill_2
XFILLER_23_117 VGND VGND VPWR VPWR sky130_fd_sc_hd__fill_1
Xg_row\[0\].g_col\[0\].pe__2472_ g_row\[0\].g_col\[0\].pe__2765_/Q g_row\[0\].g_col\[0\].pe__2472_/B
+ VGND VGND VPWR VPWR g_row\[0\].g_col\[0\].pe__2491_/A sky130_fd_sc_hd__xnor2_2
XFILLER_23_139 VGND VGND VPWR VPWR sky130_fd_sc_hd__decap_3
XFILLER_32_640 VGND VGND VPWR VPWR sky130_fd_sc_hd__decap_3
Xg_row\[0\].g_col\[0\].pe__1423_ g_row\[0\].g_col\[0\].pe__2045_/A g_row\[0\].g_col\[0\].pe__2727_/Q
+ g_row\[0\].g_col\[0\].pe__2728_/Q VGND VGND VPWR VPWR g_row\[0\].g_col\[0\].pe__1424_/B
+ sky130_fd_sc_hd__or3b_4
XFILLER_20_813 VGND VGND VPWR VPWR sky130_fd_sc_hd__fill_2
XTAP_TAPCELL_ROW_63_1154 VGND VPWR sky130_fd_sc_hd__tapvpwrvgnd_1
Xg_row\[0\].g_col\[0\].pe_hold2950 g_row\[0\].g_col\[0\].pe_hold2950/A VGND VGND VPWR
+ VPWR g_row\[0\].g_col\[0\].pe__2624_/A2 sky130_fd_sc_hd__clkbuf_2
Xg_row\[0\].g_col\[0\].pe_hold2961 g_row\[0\].g_col\[0\].pe__2722_/Q VGND VGND VPWR
+ VPWR g_row\[0\].g_col\[0\].pe_hold2961/X sky130_fd_sc_hd__clkbuf_2
Xg_row\[0\].g_col\[1\].pe__1370_ g_row\[0\].g_col\[1\].pe__2769_/Q g_row\[0\].g_col\[1\].pe__2768_/Q
+ g_row\[0\].g_col\[1\].pe__1366_/B ANTENNA_146/DIODE VGND VGND VPWR VPWR g_row\[0\].g_col\[1\].pe__1371_/B
+ sky130_fd_sc_hd__o31a_2
XFILLER_31_194 VGND VGND VPWR VPWR sky130_fd_sc_hd__decap_3
Xg_row\[0\].g_col\[0\].pe__1354_ g_row\[0\].g_col\[0\].pe__2771_/Q g_row\[0\].g_col\[0\].pe__2762_/Q
+ g_row\[0\].g_col\[0\].pe__1353_/B VGND VGND VPWR VPWR g_row\[0\].g_col\[0\].pe__1355_/B
+ sky130_fd_sc_hd__a21o_2
Xg_row\[0\].g_col\[0\].pe_hold2983 g_row\[0\].g_col\[0\].pe__2664_/X VGND VGND VPWR
+ VPWR g_row\[0\].g_col\[0\].pe_hold2983/X sky130_fd_sc_hd__clkbuf_2
XTAP_TAPCELL_ROW_6_305 VGND VPWR sky130_fd_sc_hd__tapvpwrvgnd_1
Xg_row\[1\].g_col\[1\].pe__2746_ clkbuf_leaf_76_clk/X g_row\[1\].g_col\[1\].pe__2746_/D
+ VGND VGND VPWR VPWR g_row\[1\].g_col\[1\].pe__2746_/Q sky130_fd_sc_hd__dfxtp_2
Xg_row\[1\].g_col\[1\].pe__2677_ g_row\[1\].g_col\[1\].pe__2677_/A1 g_row\[1\].g_col\[1\].pe__2676_/A
+ g_row\[1\].g_col\[1\].pe__2683_/C1 g_row\[1\].g_col\[1\].pe__2676_/Y VGND VGND VPWR
+ VPWR g_row\[1\].g_col\[1\].pe__2677_/X sky130_fd_sc_hd__o211a_2
Xg_row\[1\].g_col\[1\].pe__1628_ g_row\[1\].g_col\[1\].pe__1879_/A g_row\[1\].g_col\[1\].pe__1879_/B
+ VGND VGND VPWR VPWR g_row\[1\].g_col\[1\].pe__1629_/B sky130_fd_sc_hd__xor2_2
XFILLER_55_721 VGND VGND VPWR VPWR sky130_fd_sc_hd__decap_3
Xg_row\[1\].g_col\[1\].pe__1559_ g_row\[1\].g_col\[1\].pe__1657_/A g_row\[1\].g_col\[1\].pe__1558_/B
+ g_row\[1\].g_col\[1\].pe__1558_/C VGND VGND VPWR VPWR g_row\[1\].g_col\[1\].pe__1560_/B
+ sky130_fd_sc_hd__a21o_2
XFILLER_54_253 VGND VGND VPWR VPWR sky130_fd_sc_hd__decap_3
Xg_row\[0\].g_col\[0\].pe__2739_ _323_/CLK g_row\[0\].g_col\[0\].pe__2739_/D VGND
+ VGND VPWR VPWR g_row\[0\].g_col\[0\].pe__2739_/Q sky130_fd_sc_hd__dfxtp_2
Xg_row\[0\].g_col\[1\].pe__2755_ clkbuf_leaf_4_clk/X g_row\[0\].g_col\[1\].pe__2755_/D
+ VGND VGND VPWR VPWR g_row\[0\].g_col\[1\].pe__2755_/Q sky130_fd_sc_hd__dfxtp_2
XFILLER_54_286 VGND VGND VPWR VPWR sky130_fd_sc_hd__decap_3
XFILLER_55_798 VGND VGND VPWR VPWR sky130_fd_sc_hd__decap_3
Xg_row\[0\].g_col\[1\].pe__1706_ g_row\[0\].g_col\[1\].pe__1761_/A2 g_row\[0\].g_col\[1\].pe__1729_/A2
+ g_row\[0\].g_col\[1\].pe__1729_/A3 g_row\[0\].g_col\[1\].pe__1729_/B1 g_row\[0\].g_col\[1\].pe__1749_/A2
+ VGND VGND VPWR VPWR g_row\[0\].g_col\[1\].pe__1707_/B sky130_fd_sc_hd__a32o_2
Xg_row\[0\].g_col\[1\].pe_hold1845 g_row\[0\].g_col\[1\].pe__2765_/Q VGND VGND VPWR
+ VPWR g_row\[0\].g_col\[1\].pe__2568_/A1 sky130_fd_sc_hd__clkbuf_2
Xg_row\[0\].g_col\[1\].pe__2686_ g_row\[0\].g_col\[1\].pe__2686_/A g_row\[0\].g_col\[1\].pe__2686_/B
+ VGND VGND VPWR VPWR g_row\[0\].g_col\[1\].pe__2686_/X sky130_fd_sc_hd__or2_2
XFILLER_14_139 VGND VGND VPWR VPWR sky130_fd_sc_hd__fill_1
XFILLER_23_640 VGND VGND VPWR VPWR sky130_fd_sc_hd__decap_3
XFILLER_70_757 VGND VGND VPWR VPWR sky130_fd_sc_hd__fill_1
Xg_row\[0\].g_col\[1\].pe__1637_ g_row\[0\].g_col\[1\].pe__1846_/A g_row\[0\].g_col\[1\].pe__1847_/B
+ VGND VGND VPWR VPWR g_row\[0\].g_col\[1\].pe__1844_/B sky130_fd_sc_hd__xnor2_2
XFILLER_23_673 VGND VGND VPWR VPWR sky130_fd_sc_hd__decap_3
XFILLER_50_470 VGND VGND VPWR VPWR sky130_fd_sc_hd__fill_2
XTAP_TAPCELL_ROW_53_999 VGND VPWR sky130_fd_sc_hd__tapvpwrvgnd_1
XFILLER_22_194 VGND VGND VPWR VPWR sky130_fd_sc_hd__fill_2
Xg_row\[0\].g_col\[1\].pe__1568_ g_row\[0\].g_col\[1\].pe__1596_/A g_row\[0\].g_col\[1\].pe__1596_/B
+ VGND VGND VPWR VPWR g_row\[0\].g_col\[1\].pe__1571_/A sky130_fd_sc_hd__xor2_2
XFILLER_6_316 VGND VGND VPWR VPWR sky130_fd_sc_hd__fill_1
Xg_row\[0\].g_col\[1\].pe__1499_ g_row\[0\].g_col\[1\].pe__1499_/A g_row\[0\].g_col\[1\].pe__1499_/B
+ VGND VGND VPWR VPWR g_row\[0\].g_col\[1\].pe__1500_/B sky130_fd_sc_hd__xor2_2
XFILLER_77_378 VGND VGND VPWR VPWR sky130_fd_sc_hd__fill_1
XFILLER_93_838 VGND VGND VPWR VPWR sky130_fd_sc_hd__fill_2
XFILLER_73_551 VGND VGND VPWR VPWR sky130_fd_sc_hd__decap_3
Xg_row\[0\].g_col\[0\].pe_hold2224 g_row\[0\].g_col\[0\].pe_hold2280/X VGND VGND VPWR
+ VPWR g_row\[0\].g_col\[0\].pe__2685_/A1 sky130_fd_sc_hd__clkbuf_2
XFILLER_13_150 VGND VGND VPWR VPWR sky130_fd_sc_hd__fill_1
XFILLER_60_289 VGND VGND VPWR VPWR sky130_fd_sc_hd__fill_2
Xg_row\[0\].g_col\[0\].pe_hold2268 _310_/Q VGND VGND VPWR VPWR g_row\[0\].g_col\[0\].pe_hold2268/X
+ sky130_fd_sc_hd__clkbuf_2
XFILLER_14_695 VGND VGND VPWR VPWR sky130_fd_sc_hd__decap_3
XTAP_TAPCELL_ROW_11_373 VGND VPWR sky130_fd_sc_hd__tapvpwrvgnd_1
X_299_ _301_/CLK _299_/D VGND VGND VPWR VPWR _299_/Q sky130_fd_sc_hd__dfxtp_2
Xg_row\[1\].g_col\[0\].pe__1963_ g_row\[1\].g_col\[0\].pe__1963_/A g_row\[1\].g_col\[0\].pe__1963_/B
+ VGND VGND VPWR VPWR g_row\[1\].g_col\[0\].pe__1964_/B sky130_fd_sc_hd__xor2_2
Xg_row\[1\].g_col\[0\].pe__1894_ g_row\[1\].g_col\[0\].pe__1894_/A g_row\[1\].g_col\[0\].pe__1894_/B
+ VGND VGND VPWR VPWR g_row\[1\].g_col\[0\].pe__1894_/Y sky130_fd_sc_hd__nand2_2
XFILLER_5_393 VGND VGND VPWR VPWR sky130_fd_sc_hd__fill_2
Xhold3409 hold3409/A VGND VGND VPWR VPWR hold3409/X sky130_fd_sc_hd__clkbuf_2
Xoutput1359 output1359/A VGND VGND VPWR VPWR results_flat[13] sky130_fd_sc_hd__buf_2
Xg_row\[1\].g_col\[1\].pe__2600_ g_row\[1\].g_col\[1\].pe__2633_/A1 g_row\[1\].g_col\[1\].pe__2600_/A2
+ g_row\[1\].g_col\[1\].pe__2679_/C1 g_row\[1\].g_col\[1\].pe__2599_/X VGND VGND VPWR
+ VPWR g_row\[1\].g_col\[1\].pe__2690_/D sky130_fd_sc_hd__o211a_2
Xg_row\[0\].g_col\[0\].pe__1972_ g_row\[0\].g_col\[0\].pe__2165_/A g_row\[0\].g_col\[0\].pe__1972_/B
+ g_row\[0\].g_col\[0\].pe__1972_/C VGND VGND VPWR VPWR g_row\[0\].g_col\[0\].pe__1974_/C
+ sky130_fd_sc_hd__nand3_2
Xhold2708 hold3410/X VGND VGND VPWR VPWR hold3411/A sky130_fd_sc_hd__clkbuf_2
Xhold2719 hold2719/A VGND VGND VPWR VPWR _292_/D sky130_fd_sc_hd__clkbuf_2
Xg_row\[1\].g_col\[1\].pe__2531_ g_row\[1\].g_col\[1\].pe__2526_/A g_row\[1\].g_col\[1\].pe__2526_/B
+ g_row\[1\].g_col\[1\].pe__2458_/A VGND VGND VPWR VPWR g_row\[1\].g_col\[1\].pe__2533_/A
+ sky130_fd_sc_hd__a21oi_2
XFILLER_3_84 VGND VGND VPWR VPWR sky130_fd_sc_hd__decap_3
Xg_row\[1\].g_col\[1\].pe__2462_ g_row\[1\].g_col\[1\].pe__2757_/Q g_row\[1\].g_col\[1\].pe__2462_/B
+ VGND VGND VPWR VPWR g_row\[1\].g_col\[1\].pe__2462_/Y sky130_fd_sc_hd__nand2_2
Xg_row\[1\].g_col\[0\].pe__2446_ g_row\[1\].g_col\[0\].pe__2761_/Q g_row\[1\].g_col\[0\].pe__2446_/B
+ VGND VGND VPWR VPWR g_row\[1\].g_col\[0\].pe__2497_/B sky130_fd_sc_hd__and2b_2
Xg_row\[1\].g_col\[1\].pe__2393_ g_row\[1\].g_col\[1\].pe__2378_/X g_row\[1\].g_col\[1\].pe__2384_/Y
+ g_row\[1\].g_col\[1\].pe__2392_/Y VGND VGND VPWR VPWR g_row\[1\].g_col\[1\].pe__2393_/Y
+ sky130_fd_sc_hd__a21oi_2
Xg_row\[1\].g_col\[1\].pe__1413_ g_row\[1\].g_col\[1\].pe__1728_/A g_row\[1\].g_col\[1\].pe__1413_/B
+ VGND VGND VPWR VPWR g_row\[1\].g_col\[1\].pe__1428_/A sky130_fd_sc_hd__xnor2_2
Xg_row\[1\].g_col\[0\].pe__2377_ g_row\[1\].g_col\[0\].pe__2377_/A g_row\[1\].g_col\[0\].pe__2377_/B
+ VGND VGND VPWR VPWR g_row\[1\].g_col\[0\].pe__2377_/Y sky130_fd_sc_hd__nand2_2
XFILLER_36_253 VGND VGND VPWR VPWR sky130_fd_sc_hd__fill_1
Xg_row\[1\].g_col\[1\].pe__1344_ g_row\[1\].g_col\[1\].pe__2758_/Q g_row\[1\].g_col\[1\].pe__1344_/B
+ VGND VGND VPWR VPWR output1400/A sky130_fd_sc_hd__xnor2_2
XFILLER_36_275 VGND VGND VPWR VPWR sky130_fd_sc_hd__fill_2
Xg_row\[0\].g_col\[1\].pe__2540_ g_row\[0\].g_col\[1\].pe__2544_/B g_row\[0\].g_col\[1\].pe__2539_/X
+ g_row\[0\].g_col\[1\].pe__2559_/A VGND VGND VPWR VPWR g_row\[0\].g_col\[1\].pe__2540_/X
+ sky130_fd_sc_hd__a21o_2
XFILLER_24_448 VGND VGND VPWR VPWR sky130_fd_sc_hd__fill_1
XTAP_TAPCELL_ROW_19_495 VGND VPWR sky130_fd_sc_hd__tapvpwrvgnd_1
Xg_row\[0\].g_col\[1\].pe__2471_ g_row\[0\].g_col\[1\].pe__2471_/A g_row\[0\].g_col\[1\].pe__2495_/A
+ g_row\[0\].g_col\[1\].pe__2471_/C VGND VGND VPWR VPWR g_row\[0\].g_col\[1\].pe__2505_/A
+ sky130_fd_sc_hd__and3_2
Xg_row\[0\].g_col\[0\].pe__2455_ g_row\[0\].g_col\[0\].pe__2455_/A g_row\[0\].g_col\[0\].pe__2455_/B
+ VGND VGND VPWR VPWR g_row\[0\].g_col\[0\].pe__2457_/B sky130_fd_sc_hd__xnor2_2
Xg_row\[0\].g_col\[1\].pe__1422_ g_row\[0\].g_col\[1\].pe__2125_/C g_row\[0\].g_col\[1\].pe__2727_/Q
+ g_row\[0\].g_col\[1\].pe__2045_/A VGND VGND VPWR VPWR g_row\[0\].g_col\[1\].pe__1424_/A
+ sky130_fd_sc_hd__nand3b_2
XTAP_TAPCELL_ROW_50_958 VGND VPWR sky130_fd_sc_hd__tapvpwrvgnd_1
Xg_row\[0\].g_col\[0\].pe__1406_ g_row\[0\].g_col\[0\].pe__1406_/A VGND VGND VPWR
+ VPWR g_row\[0\].g_col\[0\].pe__1406_/Y sky130_fd_sc_hd__inv_2
Xg_row\[0\].g_col\[0\].pe__2386_ g_row\[0\].g_col\[0\].pe__2386_/A g_row\[0\].g_col\[0\].pe__2372_/A
+ VGND VGND VPWR VPWR g_row\[0\].g_col\[0\].pe__2387_/B sky130_fd_sc_hd__or2b_2
Xg_row\[0\].g_col\[1\].pe__1353_ g_row\[0\].g_col\[1\].pe__2762_/Q g_row\[0\].g_col\[1\].pe__1353_/B
+ VGND VGND VPWR VPWR output1369/A sky130_fd_sc_hd__xor2_2
XFILLER_20_687 VGND VGND VPWR VPWR sky130_fd_sc_hd__fill_1
XTAP_TAPCELL_ROW_30_660 VGND VPWR sky130_fd_sc_hd__tapvpwrvgnd_1
XFILLER_4_809 VGND VGND VPWR VPWR sky130_fd_sc_hd__decap_3
XTAP_TAPCELL_ROW_76_1345 VGND VPWR sky130_fd_sc_hd__tapvpwrvgnd_1
XTAP_TAPCELL_ROW_76_1356 VGND VPWR sky130_fd_sc_hd__tapvpwrvgnd_1
Xg_row\[1\].g_col\[1\].pe__2729_ clkbuf_leaf_82_clk/X g_row\[1\].g_col\[1\].pe__2729_/D
+ VGND VGND VPWR VPWR g_row\[1\].g_col\[1\].pe__2729_/Q sky130_fd_sc_hd__dfxtp_2
XFILLER_87_643 VGND VGND VPWR VPWR sky130_fd_sc_hd__decap_3
XFILLER_47_529 VGND VGND VPWR VPWR sky130_fd_sc_hd__decap_3
XFILLER_87_698 VGND VGND VPWR VPWR sky130_fd_sc_hd__decap_3
XPHY_EDGE_ROW_29_Right_29 VGND VGND VPWR VPWR sky130_fd_sc_hd__decap_3
XFILLER_27_242 VGND VGND VPWR VPWR sky130_fd_sc_hd__decap_3
XFILLER_28_754 VGND VGND VPWR VPWR sky130_fd_sc_hd__fill_2
Xg_row\[0\].g_col\[1\].pe_hold2354 g_row\[0\].g_col\[1\].pe__2624_/X VGND VGND VPWR
+ VPWR g_row\[0\].g_col\[1\].pe__2700_/D sky130_fd_sc_hd__clkbuf_2
Xg_row\[0\].g_col\[1\].pe_hold2343 g_row\[0\].g_col\[1\].pe__2664_/A2 VGND VGND VPWR
+ VPWR g_row\[0\].g_col\[1\].pe__1396_/A sky130_fd_sc_hd__clkbuf_2
Xg_row\[0\].g_col\[1\].pe_hold2332 g_row\[0\].g_col\[1\].pe__2439_/A VGND VGND VPWR
+ VPWR g_row\[0\].g_col\[1\].pe__2198_/A2 sky130_fd_sc_hd__clkbuf_2
XTAP_TAPCELL_ROW_38_782 VGND VPWR sky130_fd_sc_hd__tapvpwrvgnd_1
Xg_row\[0\].g_col\[1\].pe_hold2387 g_row\[0\].g_col\[1\].pe__2114_/X VGND VGND VPWR
+ VPWR g_row\[0\].g_col\[1\].pe__2115_/B sky130_fd_sc_hd__clkbuf_2
Xg_row\[0\].g_col\[1\].pe_hold2376 g_row\[0\].g_col\[1\].pe__2436_/A VGND VGND VPWR
+ VPWR g_row\[0\].g_col\[1\].pe__2236_/B1 sky130_fd_sc_hd__clkbuf_2
Xg_row\[0\].g_col\[1\].pe_hold2365 g_row\[0\].g_col\[1\].pe__2692_/Q VGND VGND VPWR
+ VPWR g_row\[0\].g_col\[1\].pe_hold2365/X sky130_fd_sc_hd__clkbuf_2
Xg_row\[0\].g_col\[1\].pe__2738_ clkbuf_leaf_13_clk/X g_row\[0\].g_col\[1\].pe__2738_/D
+ VGND VGND VPWR VPWR g_row\[0\].g_col\[1\].pe__2738_/Q sky130_fd_sc_hd__dfxtp_2
XFILLER_42_234 VGND VGND VPWR VPWR sky130_fd_sc_hd__fill_2
Xg_row\[0\].g_col\[1\].pe_hold2398 g_row\[0\].g_col\[1\].pe__2397_/Y VGND VGND VPWR
+ VPWR g_row\[0\].g_col\[1\].pe__2401_/A2 sky130_fd_sc_hd__clkbuf_2
Xg_row\[0\].g_col\[1\].pe__2669_ g_row\[0\].g_col\[1\].pe__2669_/A hold2088/X VGND
+ VGND VPWR VPWR g_row\[0\].g_col\[1\].pe__2669_/X sky130_fd_sc_hd__or2_2
XFILLER_23_481 VGND VGND VPWR VPWR sky130_fd_sc_hd__decap_3
XFILLER_42_289 VGND VGND VPWR VPWR sky130_fd_sc_hd__decap_3
XFILLER_11_654 VGND VGND VPWR VPWR sky130_fd_sc_hd__fill_1
XPHY_EDGE_ROW_38_Right_38 VGND VGND VPWR VPWR sky130_fd_sc_hd__decap_3
X_153_ _173_/A _153_/B_N VGND VGND VPWR VPWR _153_/Y sky130_fd_sc_hd__nor2b_4
XFILLER_7_669 VGND VGND VPWR VPWR sky130_fd_sc_hd__decap_3
XFILLER_12_93 VGND VGND VPWR VPWR sky130_fd_sc_hd__fill_2
XFILLER_88_20 VGND VGND VPWR VPWR sky130_fd_sc_hd__fill_1
Xg_row\[1\].g_col\[0\].pe_hold2928 g_row\[1\].g_col\[0\].pe_hold2928/A VGND VGND VPWR
+ VPWR g_row\[1\].g_col\[0\].pe__2631_/A2 sky130_fd_sc_hd__clkbuf_2
Xg_row\[1\].g_col\[0\].pe_hold2917 g_row\[1\].g_col\[0\].pe__2624_/X VGND VGND VPWR
+ VPWR g_row\[1\].g_col\[0\].pe_hold2917/X sky130_fd_sc_hd__clkbuf_2
XPHY_EDGE_ROW_47_Right_47 VGND VGND VPWR VPWR sky130_fd_sc_hd__decap_3
Xg_row\[1\].g_col\[0\].pe__2300_ g_row\[1\].g_col\[0\].pe__2300_/A g_row\[1\].g_col\[0\].pe__2300_/B
+ VGND VGND VPWR VPWR g_row\[1\].g_col\[0\].pe__2304_/A sky130_fd_sc_hd__or2_2
XFILLER_93_657 VGND VGND VPWR VPWR sky130_fd_sc_hd__decap_3
Xg_row\[1\].g_col\[1\].pe__2689__1427 VGND VGND VPWR VPWR g_row\[1\].g_col\[1\].pe__2689__1427/HI
+ g_row\[1\].g_col\[1\].pe__2689_/CIN sky130_fd_sc_hd__conb_1
Xg_row\[1\].g_col\[0\].pe__2231_ g_row\[1\].g_col\[0\].pe__2231_/A g_row\[1\].g_col\[0\].pe__2231_/B
+ VGND VGND VPWR VPWR g_row\[1\].g_col\[0\].pe__2231_/Y sky130_fd_sc_hd__nand2_2
XFILLER_19_754 VGND VGND VPWR VPWR sky130_fd_sc_hd__decap_3
Xg_row\[1\].g_col\[0\].pe__2162_ g_row\[1\].g_col\[0\].pe__2148_/A g_row\[1\].g_col\[0\].pe__2162_/B
+ VGND VGND VPWR VPWR g_row\[1\].g_col\[0\].pe__2231_/A sky130_fd_sc_hd__and2b_2
Xg_row\[1\].g_col\[0\].pe__2093_ g_row\[1\].g_col\[0\].pe__2094_/B g_row\[1\].g_col\[0\].pe__2094_/C
+ g_row\[1\].g_col\[0\].pe__2125_/C VGND VGND VPWR VPWR g_row\[1\].g_col\[0\].pe__2184_/C
+ sky130_fd_sc_hd__a21o_2
XTAP_TAPCELL_ROW_16_443 VGND VPWR sky130_fd_sc_hd__tapvpwrvgnd_1
XTAP_TAPCELL_ROW_16_454 VGND VPWR sky130_fd_sc_hd__tapvpwrvgnd_1
Xg_row\[0\].g_col\[0\].pe_hold2010 g_row\[0\].g_col\[0\].pe__2668_/X VGND VGND VPWR
+ VPWR g_row\[0\].g_col\[0\].pe__2719_/D sky130_fd_sc_hd__clkbuf_2
Xg_row\[0\].g_col\[0\].pe_hold2021 g_row\[0\].g_col\[0\].pe__2662_/X VGND VGND VPWR
+ VPWR g_row\[0\].g_col\[0\].pe__2716_/D sky130_fd_sc_hd__clkbuf_2
XPHY_EDGE_ROW_56_Right_56 VGND VGND VPWR VPWR sky130_fd_sc_hd__decap_3
XTAP_TAPCELL_ROW_60_1113 VGND VPWR sky130_fd_sc_hd__tapvpwrvgnd_1
Xg_row\[0\].g_col\[0\].pe__2240_ g_row\[0\].g_col\[0\].pe__2207_/B g_row\[0\].g_col\[0\].pe__2210_/B
+ g_row\[0\].g_col\[0\].pe__2207_/A VGND VGND VPWR VPWR g_row\[0\].g_col\[0\].pe__2288_/A
+ sky130_fd_sc_hd__a21bo_2
Xg_row\[0\].g_col\[0\].pe__2171_ g_row\[0\].g_col\[0\].pe__2171_/A g_row\[0\].g_col\[0\].pe__2171_/B
+ VGND VGND VPWR VPWR g_row\[0\].g_col\[0\].pe__2172_/B sky130_fd_sc_hd__xnor2_2
Xg_row\[0\].g_col\[0\].pe_hold2087 g_row\[0\].g_col\[0\].pe__2560_/X VGND VGND VPWR
+ VPWR g_row\[0\].g_col\[0\].pe__2561_/B sky130_fd_sc_hd__clkbuf_2
Xg_row\[1\].g_col\[1\].pe__1962_ g_row\[1\].g_col\[1\].pe__2024_/A g_row\[1\].g_col\[1\].pe__1962_/B
+ VGND VGND VPWR VPWR g_row\[1\].g_col\[1\].pe__1963_/B sky130_fd_sc_hd__and2_2
Xg_row\[1\].g_col\[0\].pe__1946_ g_row\[1\].g_col\[0\].pe__1946_/A VGND VGND VPWR
+ VPWR g_row\[1\].g_col\[0\].pe__2455_/A sky130_fd_sc_hd__inv_2
Xg_row\[1\].g_col\[1\].pe__1893_ _195_/A g_row\[1\].g_col\[1\].pe__1893_/B VGND VGND
+ VPWR VPWR g_row\[1\].g_col\[1\].pe__2740_/D sky130_fd_sc_hd__nor2_2
XTAP_TAPCELL_ROW_58_1075 VGND VPWR sky130_fd_sc_hd__tapvpwrvgnd_1
XTAP_TAPCELL_ROW_58_1086 VGND VPWR sky130_fd_sc_hd__tapvpwrvgnd_1
Xhold3206 hold3206/A VGND VGND VPWR VPWR hold3206/X sky130_fd_sc_hd__clkbuf_2
Xg_row\[1\].g_col\[0\].pe__1877_ g_row\[1\].g_col\[0\].pe__1932_/B g_row\[1\].g_col\[0\].pe__1877_/B
+ VGND VGND VPWR VPWR g_row\[1\].g_col\[0\].pe__1878_/B sky130_fd_sc_hd__xnor2_2
XPHY_EDGE_ROW_65_Right_65 VGND VGND VPWR VPWR sky130_fd_sc_hd__decap_3
Xhold3217 hold3217/A VGND VGND VPWR VPWR hold3217/X sky130_fd_sc_hd__clkbuf_2
Xhold3228 b_inputs_flat[8] VGND VGND VPWR VPWR hold3228/X sky130_fd_sc_hd__clkbuf_2
Xhold3239 hold3239/A VGND VGND VPWR VPWR hold3239/X sky130_fd_sc_hd__clkbuf_2
Xhold2505 hold3251/X VGND VGND VPWR VPWR hold3252/A sky130_fd_sc_hd__clkbuf_2
Xhold2516 hold3221/X VGND VGND VPWR VPWR hold3222/A sky130_fd_sc_hd__clkbuf_2
Xhold2527 hold2527/A VGND VGND VPWR VPWR _339_/D sky130_fd_sc_hd__clkbuf_2
Xhold2538 _251_/Y VGND VGND VPWR VPWR hold2538/X sky130_fd_sc_hd__clkbuf_2
XTAP_TAPCELL_ROW_71_1275 VGND VPWR sky130_fd_sc_hd__tapvpwrvgnd_1
Xg_row\[0\].g_col\[0\].pe__1955_ g_row\[0\].g_col\[0\].pe__1955_/A g_row\[0\].g_col\[0\].pe__1955_/B
+ VGND VGND VPWR VPWR g_row\[0\].g_col\[0\].pe__1955_/X sky130_fd_sc_hd__and2_2
Xhold2549 hold3276/X VGND VGND VPWR VPWR _271_/B_N sky130_fd_sc_hd__clkbuf_2
Xg_row\[1\].g_col\[1\].pe__2514_ _195_/A g_row\[1\].g_col\[1\].pe__2514_/B VGND VGND
+ VPWR VPWR g_row\[1\].g_col\[1\].pe__2514_/Y sky130_fd_sc_hd__nor2_2
Xg_row\[0\].g_col\[1\].pe__1971_ g_row\[0\].g_col\[1\].pe__1461_/A g_row\[0\].g_col\[1\].pe__1461_/B
+ g_row\[0\].g_col\[1\].pe__2699_/Q VGND VGND VPWR VPWR g_row\[0\].g_col\[1\].pe__1972_/C
+ sky130_fd_sc_hd__a21bo_2
XFILLER_68_197 VGND VGND VPWR VPWR sky130_fd_sc_hd__fill_2
Xg_row\[0\].g_col\[0\].pe__1886_ g_row\[0\].g_col\[0\].pe__1886_/A g_row\[0\].g_col\[0\].pe__1897_/B
+ VGND VGND VPWR VPWR g_row\[0\].g_col\[0\].pe__1888_/C sky130_fd_sc_hd__xnor2_2
Xg_row\[1\].g_col\[1\].pe__2445_ g_row\[1\].g_col\[1\].pe__2445_/A g_row\[1\].g_col\[1\].pe__2445_/B
+ VGND VGND VPWR VPWR g_row\[1\].g_col\[1\].pe__2446_/B sky130_fd_sc_hd__xnor2_2
Xg_row\[1\].g_col\[0\].pe__2429_ g_row\[1\].g_col\[0\].pe__2751_/Q g_row\[1\].g_col\[0\].pe__2429_/B
+ VGND VGND VPWR VPWR g_row\[1\].g_col\[0\].pe__2478_/B sky130_fd_sc_hd__xnor2_2
XFILLER_83_167 VGND VGND VPWR VPWR sky130_fd_sc_hd__fill_1
Xg_row\[1\].g_col\[1\].pe__2376_ g_row\[1\].g_col\[1\].pe__2377_/A g_row\[1\].g_col\[1\].pe__2359_/B
+ g_row\[1\].g_col\[1\].pe__2377_/B g_row\[1\].g_col\[1\].pe__2356_/A VGND VGND VPWR
+ VPWR g_row\[1\].g_col\[1\].pe__2376_/X sky130_fd_sc_hd__a211o_2
XFILLER_52_521 VGND VGND VPWR VPWR sky130_fd_sc_hd__decap_3
XTAP_TAPCELL_ROW_35_730 VGND VPWR sky130_fd_sc_hd__tapvpwrvgnd_1
XTAP_TAPCELL_ROW_35_741 VGND VPWR sky130_fd_sc_hd__tapvpwrvgnd_1
XFILLER_52_587 VGND VGND VPWR VPWR sky130_fd_sc_hd__fill_1
XPHY_EDGE_ROW_74_Right_74 VGND VGND VPWR VPWR sky130_fd_sc_hd__decap_3
Xg_row\[0\].g_col\[0\].pe__2507_ g_row\[0\].g_col\[0\].pe__2575_/A g_row\[0\].g_col\[0\].pe__2507_/B
+ VGND VGND VPWR VPWR g_row\[0\].g_col\[0\].pe__2507_/Y sky130_fd_sc_hd__nor2_2
Xg_row\[0\].g_col\[0\].pe__2438_ g_row\[0\].g_col\[0\].pe__2764_/Q g_row\[0\].g_col\[0\].pe__2438_/B
+ VGND VGND VPWR VPWR g_row\[0\].g_col\[0\].pe__2471_/A sky130_fd_sc_hd__xnor2_2
Xg_row\[0\].g_col\[1\].pe__2454_ g_row\[0\].g_col\[1\].pe__2759_/Q g_row\[0\].g_col\[1\].pe__2464_/B
+ VGND VGND VPWR VPWR g_row\[0\].g_col\[1\].pe__2538_/B sky130_fd_sc_hd__or2_2
Xg_row\[0\].g_col\[1\].pe__1405_ g_row\[0\].g_col\[1\].pe__1838_/A place1233/X VGND
+ VGND VPWR VPWR g_row\[0\].g_col\[1\].pe__2157_/A sky130_fd_sc_hd__nor2_2
Xg_row\[0\].g_col\[1\].pe__2385_ g_row\[0\].g_col\[1\].pe__2385_/A g_row\[0\].g_col\[1\].pe__2385_/B
+ VGND VGND VPWR VPWR g_row\[0\].g_col\[1\].pe__2392_/A sky130_fd_sc_hd__nand2_2
Xg_row\[0\].g_col\[0\].pe__2369_ g_row\[0\].g_col\[0\].pe__2368_/A g_row\[0\].g_col\[0\].pe__2368_/B
+ g_row\[0\].g_col\[0\].pe__2367_/X VGND VGND VPWR VPWR g_row\[0\].g_col\[0\].pe__2370_/B
+ sky130_fd_sc_hd__o21bai_2
XPHY_EDGE_ROW_83_Right_83 VGND VGND VPWR VPWR sky130_fd_sc_hd__decap_3
XFILLER_0_801 VGND VGND VPWR VPWR sky130_fd_sc_hd__decap_3
XFILLER_75_613 VGND VGND VPWR VPWR sky130_fd_sc_hd__decap_3
XFILLER_47_337 VGND VGND VPWR VPWR sky130_fd_sc_hd__decap_3
XTAP_TAPCELL_ROW_89_1547 VGND VPWR sky130_fd_sc_hd__tapvpwrvgnd_1
XFILLER_74_178 VGND VGND VPWR VPWR sky130_fd_sc_hd__fill_2
XFILLER_74_44 VGND VGND VPWR VPWR sky130_fd_sc_hd__fill_1
XFILLER_15_223 VGND VGND VPWR VPWR sky130_fd_sc_hd__fill_1
XFILLER_16_757 VGND VGND VPWR VPWR sky130_fd_sc_hd__decap_3
XFILLER_71_841 VGND VGND VPWR VPWR sky130_fd_sc_hd__fill_1
XPHY_EDGE_ROW_92_Right_92 VGND VGND VPWR VPWR sky130_fd_sc_hd__decap_3
Xg_row\[0\].g_col\[1\].pe_hold2184 g_row\[0\].g_col\[1\].pe_hold2995/X VGND VGND VPWR
+ VPWR g_row\[0\].g_col\[1\].pe__2720_/D sky130_fd_sc_hd__clkbuf_2
Xg_row\[0\].g_col\[1\].pe_hold2173 _333_/Q VGND VGND VPWR VPWR g_row\[0\].g_col\[1\].pe_hold2173/X
+ sky130_fd_sc_hd__clkbuf_2
XFILLER_31_727 VGND VGND VPWR VPWR sky130_fd_sc_hd__fill_1
XFILLER_70_373 VGND VGND VPWR VPWR sky130_fd_sc_hd__fill_1
XTAP_TAPCELL_ROW_13_402 VGND VPWR sky130_fd_sc_hd__tapvpwrvgnd_1
X_205_ _205_/A _205_/B_N VGND VGND VPWR VPWR _205_/Y sky130_fd_sc_hd__nor2b_4
X_136_ _274_/Q VGND VGND VPWR VPWR _136_/Y sky130_fd_sc_hd__inv_2
Xg_row\[1\].g_col\[0\].pe__1800_ g_row\[1\].g_col\[0\].pe__1808_/A g_row\[1\].g_col\[0\].pe__1800_/B
+ VGND VGND VPWR VPWR g_row\[1\].g_col\[0\].pe__1801_/C sky130_fd_sc_hd__xnor2_2
XFILLER_7_477 VGND VGND VPWR VPWR sky130_fd_sc_hd__fill_1
Xg_row\[1\].g_col\[0\].pe__1731_ g_row\[1\].g_col\[0\].pe__1734_/A g_row\[1\].g_col\[0\].pe__1734_/B
+ VGND VGND VPWR VPWR g_row\[1\].g_col\[0\].pe__1758_/A sky130_fd_sc_hd__xor2_2
Xg_row\[1\].g_col\[0\].pe__1662_ g_row\[1\].g_col\[0\].pe__1662_/A g_row\[1\].g_col\[0\].pe__1662_/B
+ VGND VGND VPWR VPWR g_row\[1\].g_col\[0\].pe__1663_/B sky130_fd_sc_hd__xor2_2
XFILLER_2_171 VGND VGND VPWR VPWR sky130_fd_sc_hd__fill_1
Xg_row\[1\].g_col\[0\].pe__1593_ g_row\[1\].g_col\[0\].pe__1594_/A g_row\[1\].g_col\[0\].pe__1594_/B
+ VGND VGND VPWR VPWR g_row\[1\].g_col\[0\].pe__1593_/Y sky130_fd_sc_hd__nor2_2
XFILLER_39_838 VGND VGND VPWR VPWR sky130_fd_sc_hd__fill_2
Xg_row\[0\].g_col\[0\].pe__1740_ g_row\[0\].g_col\[0\].pe__1740_/A g_row\[0\].g_col\[0\].pe__1740_/B
+ VGND VGND VPWR VPWR g_row\[0\].g_col\[0\].pe__1740_/Y sky130_fd_sc_hd__nor2_2
XFILLER_19_540 VGND VGND VPWR VPWR sky130_fd_sc_hd__decap_3
XFILLER_38_359 VGND VGND VPWR VPWR sky130_fd_sc_hd__decap_3
Xg_row\[1\].g_col\[1\].pe__2230_ g_row\[1\].g_col\[1\].pe__2238_/A g_row\[1\].g_col\[1\].pe__2238_/B
+ VGND VGND VPWR VPWR g_row\[1\].g_col\[1\].pe__2298_/A sky130_fd_sc_hd__xnor2_2
Xg_row\[0\].g_col\[0\].pe__1671_ g_row\[0\].g_col\[0\].pe__1816_/A g_row\[0\].g_col\[0\].pe__1671_/B
+ VGND VGND VPWR VPWR g_row\[0\].g_col\[0\].pe__1690_/A sky130_fd_sc_hd__xor2_2
Xg_row\[1\].g_col\[0\].pe__2214_ g_row\[1\].g_col\[0\].pe__2169_/B g_row\[1\].g_col\[0\].pe__2172_/B
+ g_row\[1\].g_col\[0\].pe__2167_/X VGND VGND VPWR VPWR g_row\[1\].g_col\[0\].pe__2219_/A
+ sky130_fd_sc_hd__a21o_2
Xg_row\[1\].g_col\[1\].pe__2161_ g_row\[1\].g_col\[1\].pe__2161_/A g_row\[1\].g_col\[1\].pe__2161_/B
+ VGND VGND VPWR VPWR g_row\[1\].g_col\[1\].pe__2161_/Y sky130_fd_sc_hd__nand2_2
Xg_row\[1\].g_col\[0\].pe__2145_ g_row\[1\].g_col\[0\].pe__2145_/A g_row\[1\].g_col\[0\].pe__2104_/A
+ VGND VGND VPWR VPWR g_row\[1\].g_col\[0\].pe__2192_/B sky130_fd_sc_hd__nor2b_4
Xg_row\[1\].g_col\[1\].pe__2092_ g_row\[1\].g_col\[1\].pe__2091_/A g_row\[1\].g_col\[1\].pe__2091_/B
+ g_row\[1\].g_col\[1\].pe__2091_/C VGND VGND VPWR VPWR g_row\[1\].g_col\[1\].pe__2097_/C
+ sky130_fd_sc_hd__a21oi_2
XFILLER_34_587 VGND VGND VPWR VPWR sky130_fd_sc_hd__fill_1
XFILLER_34_598 VGND VGND VPWR VPWR sky130_fd_sc_hd__decap_3
Xg_row\[1\].g_col\[0\].pe__2076_ g_row\[1\].g_col\[0\].pe__2136_/A g_row\[1\].g_col\[0\].pe__2136_/B
+ VGND VGND VPWR VPWR g_row\[1\].g_col\[0\].pe__2119_/B sky130_fd_sc_hd__xor2_2
Xg_row\[0\].g_col\[0\].pe__2223_ g_row\[0\].g_col\[0\].pe__2183_/A g_row\[0\].g_col\[0\].pe__2183_/B
+ g_row\[0\].g_col\[0\].pe__2222_/X VGND VGND VPWR VPWR g_row\[0\].g_col\[0\].pe__2258_/B
+ sky130_fd_sc_hd__o21ai_2
XFILLER_9_94 VGND VGND VPWR VPWR sky130_fd_sc_hd__decap_3
Xg_row\[0\].g_col\[0\].pe__2154_ g_row\[0\].g_col\[0\].pe__2062_/C g_row\[0\].g_col\[0\].pe__2150_/X
+ g_row\[0\].g_col\[0\].pe__2153_/X g_row\[0\].g_col\[0\].pe__2111_/A VGND VGND VPWR
+ VPWR g_row\[0\].g_col\[0\].pe__2300_/A sky130_fd_sc_hd__a211oi_2
Xg_row\[0\].g_col\[1\].pe__2170_ g_row\[0\].g_col\[1\].pe__1965_/A g_row\[0\].g_col\[1\].pe__1471_/X
+ g_row\[0\].g_col\[1\].pe__1474_/Y g_row\[0\].g_col\[1\].pe__2625_/B VGND VGND VPWR
+ VPWR g_row\[0\].g_col\[1\].pe__2171_/B sky130_fd_sc_hd__a22o_2
Xg_row\[0\].g_col\[0\].pe__2085_ g_row\[0\].g_col\[0\].pe__2165_/A g_row\[0\].g_col\[0\].pe__2085_/B
+ g_row\[0\].g_col\[0\].pe__2085_/C VGND VGND VPWR VPWR g_row\[0\].g_col\[0\].pe__2087_/C
+ sky130_fd_sc_hd__nand3_2
Xg_row\[1\].g_col\[1\].pe__1945_ g_row\[1\].g_col\[1\].pe__1894_/Y g_row\[1\].g_col\[1\].pe__1895_/X
+ g_row\[1\].g_col\[1\].pe__2151_/A VGND VGND VPWR VPWR g_row\[1\].g_col\[1\].pe__2008_/A
+ sky130_fd_sc_hd__a21o_2
XTAP_TAPCELL_ROW_73_1304 VGND VPWR sky130_fd_sc_hd__tapvpwrvgnd_1
Xg_row\[1\].g_col\[0\].pe__1929_ g_row\[1\].g_col\[0\].pe__1874_/A g_row\[1\].g_col\[0\].pe__1874_/B
+ g_row\[1\].g_col\[0\].pe__1928_/X VGND VGND VPWR VPWR g_row\[1\].g_col\[0\].pe__1994_/B
+ sky130_fd_sc_hd__a21oi_2
Xhold3003 hold3003/A VGND VGND VPWR VPWR hold3003/X sky130_fd_sc_hd__clkbuf_2
Xg_row\[1\].g_col\[1\].pe__1876_ g_row\[1\].g_col\[1\].pe__1625_/A g_row\[1\].g_col\[1\].pe__1625_/B
+ g_row\[1\].g_col\[1\].pe__1875_/X VGND VGND VPWR VPWR g_row\[1\].g_col\[1\].pe__1877_/B
+ sky130_fd_sc_hd__a21oi_2
Xhold1601 hold3540/X VGND VGND VPWR VPWR hold2765/A sky130_fd_sc_hd__clkbuf_2
XFILLER_57_646 VGND VGND VPWR VPWR sky130_fd_sc_hd__fill_1
XFILLER_84_421 VGND VGND VPWR VPWR sky130_fd_sc_hd__decap_3
Xhold1612 hold3554/X VGND VGND VPWR VPWR hold3555/A sky130_fd_sc_hd__clkbuf_2
Xhold1623 hold2802/X VGND VGND VPWR VPWR hold2803/A sky130_fd_sc_hd__clkbuf_2
Xhold1634 hold1639/X VGND VGND VPWR VPWR hold1640/A sky130_fd_sc_hd__clkbuf_2
Xg_row\[0\].g_col\[1\].pe__1954_ g_row\[0\].g_col\[1\].pe__1857_/A g_row\[0\].g_col\[1\].pe__1857_/B
+ g_row\[0\].g_col\[1\].pe__1908_/B g_row\[0\].g_col\[1\].pe__1907_/B g_row\[0\].g_col\[1\].pe__1907_/A
+ VGND VGND VPWR VPWR g_row\[0\].g_col\[1\].pe__2002_/A sky130_fd_sc_hd__a32o_2
Xg_row\[0\].g_col\[0\].pe__1938_ g_row\[0\].g_col\[0\].pe__1938_/A g_row\[0\].g_col\[0\].pe__1952_/A
+ VGND VGND VPWR VPWR g_row\[0\].g_col\[0\].pe__1939_/B sky130_fd_sc_hd__xnor2_2
Xhold1656 reset VGND VGND VPWR VPWR hold1656/X sky130_fd_sc_hd__clkbuf_2
Xg_row\[0\].g_col\[0\].pe__1869_ place1195/X g_row\[0\].g_col\[0\].pe__1414_/X g_row\[0\].g_col\[0\].pe__1415_/Y
+ g_row\[0\].g_col\[0\].pe__1416_/X g_row\[0\].g_col\[1\].pe__2635_/C VGND VGND VPWR
+ VPWR g_row\[0\].g_col\[0\].pe__1870_/B sky130_fd_sc_hd__a32o_2
Xg_row\[1\].g_col\[1\].pe__2428_ g_row\[1\].g_col\[1\].pe__2427_/B g_row\[1\].g_col\[1\].pe__2769_/Q
+ VGND VGND VPWR VPWR g_row\[1\].g_col\[1\].pe__2494_/B sky130_fd_sc_hd__and2b_2
Xg_row\[0\].g_col\[1\].pe__1885_ g_row\[0\].g_col\[1\].pe__1885_/A g_row\[0\].g_col\[1\].pe__1896_/A
+ VGND VGND VPWR VPWR g_row\[0\].g_col\[1\].pe__1897_/B sky130_fd_sc_hd__xnor2_2
XFILLER_53_841 VGND VGND VPWR VPWR sky130_fd_sc_hd__fill_1
Xg_row\[1\].g_col\[1\].pe__2359_ g_row\[1\].g_col\[1\].pe__2377_/A g_row\[1\].g_col\[1\].pe__2359_/B
+ VGND VGND VPWR VPWR g_row\[1\].g_col\[1\].pe__2359_/Y sky130_fd_sc_hd__xnor2_2
XTAP_TAPCELL_ROW_84_1466 VGND VPWR sky130_fd_sc_hd__tapvpwrvgnd_1
XTAP_TAPCELL_ROW_84_1477 VGND VPWR sky130_fd_sc_hd__tapvpwrvgnd_1
XFILLER_13_727 VGND VGND VPWR VPWR sky130_fd_sc_hd__fill_1
XFILLER_13_749 VGND VGND VPWR VPWR sky130_fd_sc_hd__decap_3
Xg_row\[0\].g_col\[1\].pe__2506_ g_row\[0\].g_col\[1\].pe__2571_/A g_row\[0\].g_col\[1\].pe__2567_/A
+ g_row\[0\].g_col\[1\].pe__2506_/C g_row\[0\].g_col\[1\].pe__2505_/X VGND VGND VPWR
+ VPWR g_row\[0\].g_col\[1\].pe__2507_/B sky130_fd_sc_hd__or4b_4
Xg_row\[0\].g_col\[1\].pe__2437_ g_row\[0\].g_col\[1\].pe__2438_/B g_row\[0\].g_col\[1\].pe__2764_/Q
+ VGND VGND VPWR VPWR g_row\[0\].g_col\[1\].pe__2491_/B sky130_fd_sc_hd__and2b_2
XFILLER_60_46 VGND VGND VPWR VPWR sky130_fd_sc_hd__fill_2
Xg_row\[0\].g_col\[0\].pe_place1215 hold3118/A VGND VGND VPWR VPWR g_row\[0\].g_col\[0\].pe__1957_/B2
+ sky130_fd_sc_hd__buf_6
Xg_row\[0\].g_col\[0\].pe_place1226 g_row\[0\].g_col\[0\].pe__2633_/B1 VGND VGND VPWR
+ VPWR g_row\[0\].g_col\[0\].pe__2685_/C1 sky130_fd_sc_hd__buf_6
Xg_row\[0\].g_col\[1\].pe__2368_ g_row\[0\].g_col\[1\].pe__2368_/A g_row\[0\].g_col\[1\].pe__2368_/B
+ g_row\[0\].g_col\[1\].pe__2367_/X VGND VGND VPWR VPWR g_row\[0\].g_col\[1\].pe__2387_/A
+ sky130_fd_sc_hd__or3b_2
Xg_row\[0\].g_col\[1\].pe__2299_ g_row\[0\].g_col\[1\].pe__2299_/A g_row\[0\].g_col\[1\].pe__2299_/B
+ VGND VGND VPWR VPWR g_row\[0\].g_col\[1\].pe__2300_/B sky130_fd_sc_hd__or2_4
Xg_row\[1\].g_col\[1\].pe_hold2822 g_row\[1\].g_col\[1\].pe__2710_/Q VGND VGND VPWR
+ VPWR g_row\[1\].g_col\[1\].pe__2649_/B sky130_fd_sc_hd__clkbuf_2
XFILLER_69_55 VGND VGND VPWR VPWR sky130_fd_sc_hd__fill_1
Xg_row\[1\].g_col\[1\].pe_hold2844 g_row\[1\].g_col\[1\].pe__2654_/X VGND VGND VPWR
+ VPWR g_row\[1\].g_col\[1\].pe_hold2844/X sky130_fd_sc_hd__clkbuf_2
Xg_row\[1\].g_col\[1\].pe_hold2866 g_row\[1\].g_col\[1\].pe__2661_/X VGND VGND VPWR
+ VPWR g_row\[1\].g_col\[1\].pe__2662_/C1 sky130_fd_sc_hd__clkbuf_2
XFILLER_0_642 VGND VGND VPWR VPWR sky130_fd_sc_hd__fill_2
XFILLER_88_760 VGND VGND VPWR VPWR sky130_fd_sc_hd__fill_2
Xhold3570 hold3570/A VGND VGND VPWR VPWR hold3570/X sky130_fd_sc_hd__clkbuf_2
XFILLER_85_21 VGND VGND VPWR VPWR sky130_fd_sc_hd__fill_1
XFILLER_85_43 VGND VGND VPWR VPWR sky130_fd_sc_hd__fill_1
XFILLER_88_793 VGND VGND VPWR VPWR sky130_fd_sc_hd__fill_1
Xhold3592 hold3592/A VGND VGND VPWR VPWR hold3592/X sky130_fd_sc_hd__clkbuf_2
Xhold3581 hold3581/A VGND VGND VPWR VPWR hold3581/X sky130_fd_sc_hd__clkbuf_2
XFILLER_47_134 VGND VGND VPWR VPWR sky130_fd_sc_hd__fill_2
XFILLER_18_70 VGND VGND VPWR VPWR sky130_fd_sc_hd__decap_3
XFILLER_63_627 VGND VGND VPWR VPWR sky130_fd_sc_hd__decap_3
XFILLER_62_137 VGND VGND VPWR VPWR sky130_fd_sc_hd__decap_3
XFILLER_16_554 VGND VGND VPWR VPWR sky130_fd_sc_hd__decap_3
XFILLER_70_170 VGND VGND VPWR VPWR sky130_fd_sc_hd__fill_2
XTAP_TAPCELL_ROW_26_593 VGND VPWR sky130_fd_sc_hd__tapvpwrvgnd_1
XFILLER_12_760 VGND VGND VPWR VPWR sky130_fd_sc_hd__fill_1
Xg_row\[0\].g_col\[1\].pe_place1160 g_row\[0\].g_col\[1\].pe__2692_/Q VGND VGND VPWR
+ VPWR g_row\[0\].g_col\[1\].pe__1799_/A2 sky130_fd_sc_hd__buf_6
Xg_row\[0\].g_col\[1\].pe_place1171 g_row\[0\].g_col\[1\].pe__2656_/B1 VGND VGND VPWR
+ VPWR g_row\[0\].g_col\[1\].pe__2670_/B1 sky130_fd_sc_hd__buf_6
Xg_row\[1\].g_col\[0\].pe__2763_ clkbuf_leaf_57_clk/X g_row\[1\].g_col\[0\].pe__2763_/D
+ VGND VGND VPWR VPWR g_row\[1\].g_col\[0\].pe__2763_/Q sky130_fd_sc_hd__dfxtp_2
XTAP_TAPCELL_ROW_55_1034 VGND VPWR sky130_fd_sc_hd__tapvpwrvgnd_1
Xg_row\[1\].g_col\[1\].pe__1730_ g_row\[1\].g_col\[1\].pe__1730_/A g_row\[1\].g_col\[1\].pe__1730_/B
+ VGND VGND VPWR VPWR g_row\[1\].g_col\[1\].pe__1734_/B sky130_fd_sc_hd__xor2_2
Xg_row\[1\].g_col\[0\].pe__2694_ clkbuf_leaf_67_clk/X g_row\[1\].g_col\[0\].pe__2694_/D
+ VGND VGND VPWR VPWR place1098/A sky130_fd_sc_hd__dfxtp_2
Xg_row\[1\].g_col\[0\].pe__1714_ g_row\[1\].g_col\[0\].pe__1714_/A g_row\[1\].g_col\[0\].pe__1714_/B
+ g_row\[1\].g_col\[0\].pe__1714_/C VGND VGND VPWR VPWR g_row\[1\].g_col\[0\].pe__1742_/B
+ sky130_fd_sc_hd__nand3_2
Xg_row\[1\].g_col\[1\].pe__1661_ g_row\[1\].g_col\[1\].pe__1693_/A g_row\[1\].g_col\[1\].pe__1693_/B
+ g_row\[1\].g_col\[1\].pe__1660_/Y VGND VGND VPWR VPWR g_row\[1\].g_col\[1\].pe__1663_/A
+ sky130_fd_sc_hd__a21o_2
Xg_row\[1\].g_col\[0\].pe__1645_ g_row\[1\].g_col\[0\].pe__1648_/A g_row\[1\].g_col\[0\].pe__1648_/B
+ VGND VGND VPWR VPWR g_row\[1\].g_col\[0\].pe__1688_/A sky130_fd_sc_hd__xor2_2
XFILLER_39_602 VGND VGND VPWR VPWR sky130_fd_sc_hd__decap_3
Xg_row\[1\].g_col\[1\].pe__1592_ g_row\[1\].g_col\[1\].pe__1830_/A g_row\[1\].g_col\[1\].pe__1830_/B
+ g_row\[1\].g_col\[1\].pe__1830_/C VGND VGND VPWR VPWR g_row\[1\].g_col\[1\].pe__1840_/A
+ sky130_fd_sc_hd__o21ai_2
Xg_row\[1\].g_col\[0\].pe_hold1821 g_row\[1\].g_col\[0\].pe__2560_/X VGND VGND VPWR
+ VPWR g_row\[1\].g_col\[0\].pe__2561_/B sky130_fd_sc_hd__clkbuf_2
Xg_row\[1\].g_col\[0\].pe__1576_ g_row\[1\].g_col\[0\].pe__1626_/A g_row\[1\].g_col\[0\].pe__1626_/B
+ VGND VGND VPWR VPWR g_row\[1\].g_col\[0\].pe__1579_/A sky130_fd_sc_hd__xor2_2
Xg_row\[1\].g_col\[0\].pe_hold1843 g_row\[1\].g_col\[0\].pe__2011_/Y VGND VGND VPWR
+ VPWR g_row\[1\].g_col\[0\].pe__2742_/D sky130_fd_sc_hd__clkbuf_2
Xg_row\[1\].g_col\[0\].pe_hold1832 g_row\[1\].g_col\[0\].pe__1835_/X VGND VGND VPWR
+ VPWR g_row\[1\].g_col\[0\].pe__1836_/B sky130_fd_sc_hd__clkbuf_2
Xg_row\[0\].g_col\[1\].pe_hold2909 g_row\[0\].g_col\[1\].pe_hold2909/A VGND VGND VPWR
+ VPWR g_row\[0\].g_col\[1\].pe__2721_/D sky130_fd_sc_hd__clkbuf_2
XFILLER_54_638 VGND VGND VPWR VPWR sky130_fd_sc_hd__decap_3
Xg_row\[0\].g_col\[0\].pe__1723_ g_row\[0\].g_col\[0\].pe__1723_/A g_row\[0\].g_col\[0\].pe__1723_/B
+ VGND VGND VPWR VPWR g_row\[0\].g_col\[0\].pe__1745_/B sky130_fd_sc_hd__xor2_2
Xg_row\[1\].g_col\[0\].pe_hold1865 g_row\[1\].g_col\[0\].pe_hold2901/X VGND VGND VPWR
+ VPWR g_row\[1\].g_col\[0\].pe__2696_/D sky130_fd_sc_hd__clkbuf_2
XFILLER_35_841 VGND VGND VPWR VPWR sky130_fd_sc_hd__fill_1
XFILLER_53_148 VGND VGND VPWR VPWR sky130_fd_sc_hd__decap_3
Xg_row\[0\].g_col\[0\].pe__1654_ place1218/X g_row\[0\].g_col\[0\].pe__1715_/B g_row\[0\].g_col\[0\].pe__1863_/B1
+ g_row\[0\].g_col\[0\].pe__1672_/A1 VGND VGND VPWR VPWR g_row\[0\].g_col\[0\].pe__1655_/B
+ sky130_fd_sc_hd__a22o_2
Xg_row\[0\].g_col\[1\].pe__1670_ g_row\[0\].g_col\[1\].pe__1782_/A2 g_row\[0\].g_col\[1\].pe__1748_/B
+ g_row\[0\].g_col\[1\].pe__1738_/B1 g_row\[0\].g_col\[1\].pe__1799_/A2 VGND VGND
+ VPWR VPWR g_row\[0\].g_col\[1\].pe__1671_/B sky130_fd_sc_hd__a22o_2
Xg_row\[1\].g_col\[1\].pe__2213_ g_row\[1\].g_col\[1\].pe__2213_/A g_row\[1\].g_col\[1\].pe__2213_/B
+ VGND VGND VPWR VPWR g_row\[1\].g_col\[1\].pe__2220_/A sky130_fd_sc_hd__nand2_2
Xg_row\[1\].g_col\[1\].pe__2144_ g_row\[1\].g_col\[1\].pe__2144_/A g_row\[1\].g_col\[1\].pe__2144_/B
+ VGND VGND VPWR VPWR g_row\[1\].g_col\[1\].pe__2192_/A sky130_fd_sc_hd__xnor2_2
XTAP_TAPCELL_ROW_45_880 VGND VPWR sky130_fd_sc_hd__tapvpwrvgnd_1
XTAP_TAPCELL_ROW_45_891 VGND VPWR sky130_fd_sc_hd__tapvpwrvgnd_1
XTAP_TAPCELL_ROW_66_1196 VGND VPWR sky130_fd_sc_hd__tapvpwrvgnd_1
Xg_row\[0\].g_col\[0\].pe__1585_ g_row\[0\].g_col\[0\].pe__1533_/A g_row\[0\].g_col\[0\].pe__1533_/B
+ g_row\[0\].g_col\[0\].pe__1584_/Y VGND VGND VPWR VPWR g_row\[0\].g_col\[0\].pe__1634_/B
+ sky130_fd_sc_hd__a21oi_2
Xg_row\[1\].g_col\[0\].pe__2128_ g_row\[1\].g_col\[0\].pe__2128_/A g_row\[1\].g_col\[0\].pe__2128_/B
+ g_row\[1\].g_col\[0\].pe__2128_/C VGND VGND VPWR VPWR g_row\[1\].g_col\[0\].pe__2129_/B
+ sky130_fd_sc_hd__and3_2
XFILLER_22_546 VGND VGND VPWR VPWR sky130_fd_sc_hd__decap_3
Xg_row\[1\].g_col\[1\].pe__2075_ g_row\[1\].g_col\[1\].pe__2075_/A g_row\[1\].g_col\[1\].pe__2075_/B
+ VGND VGND VPWR VPWR g_row\[1\].g_col\[1\].pe__2136_/B sky130_fd_sc_hd__xnor2_2
Xg_row\[1\].g_col\[0\].pe__2059_ g_row\[1\].g_col\[0\].pe__2059_/A g_row\[1\].g_col\[0\].pe__2067_/A
+ VGND VGND VPWR VPWR g_row\[1\].g_col\[0\].pe__2153_/B sky130_fd_sc_hd__xnor2_2
Xg_row\[0\].g_col\[0\].pe__2206_ g_row\[0\].g_col\[0\].pe__2125_/A g_row\[0\].g_col\[0\].pe__2204_/Y
+ g_row\[0\].g_col\[0\].pe__1460_/B g_row\[0\].g_col\[0\].pe__1912_/A VGND VGND VPWR
+ VPWR g_row\[0\].g_col\[0\].pe__2207_/B sky130_fd_sc_hd__o211ai_2
Xg_row\[0\].g_col\[1\].pe__2222_ g_row\[0\].g_col\[1\].pe__2222_/A g_row\[0\].g_col\[1\].pe__2253_/A
+ VGND VGND VPWR VPWR g_row\[0\].g_col\[1\].pe__2222_/X sky130_fd_sc_hd__or2_2
Xg_row\[0\].g_col\[0\].pe__2137_ g_row\[0\].g_col\[0\].pe__2091_/B g_row\[0\].g_col\[0\].pe__2091_/C
+ g_row\[0\].g_col\[0\].pe__2091_/A VGND VGND VPWR VPWR g_row\[0\].g_col\[0\].pe__2142_/A
+ sky130_fd_sc_hd__a21boi_2
Xg_row\[0\].g_col\[1\].pe__2153_ g_row\[0\].g_col\[1\].pe__2153_/A g_row\[0\].g_col\[1\].pe__2153_/B
+ g_row\[0\].g_col\[1\].pe__2153_/C VGND VGND VPWR VPWR g_row\[0\].g_col\[1\].pe__2153_/X
+ sky130_fd_sc_hd__and3_2
XFILLER_89_502 VGND VGND VPWR VPWR sky130_fd_sc_hd__fill_2
XFILLER_89_513 VGND VGND VPWR VPWR sky130_fd_sc_hd__fill_1
Xg_row\[0\].g_col\[0\].pe__2068_ g_row\[0\].g_col\[0\].pe__2068_/A g_row\[0\].g_col\[0\].pe__2068_/B
+ VGND VGND VPWR VPWR g_row\[0\].g_col\[0\].pe__2068_/Y sky130_fd_sc_hd__nor2_2
Xg_row\[1\].g_col\[1\].pe__1928_ g_row\[1\].g_col\[1\].pe__1928_/A g_row\[1\].g_col\[1\].pe__1928_/B
+ VGND VGND VPWR VPWR g_row\[1\].g_col\[1\].pe__1928_/X sky130_fd_sc_hd__and2_2
Xg_row\[0\].g_col\[1\].pe__2084_ g_row\[0\].g_col\[1\].pe__1461_/A g_row\[0\].g_col\[1\].pe__1461_/B
+ g_row\[0\].g_col\[1\].pe__1966_/Y VGND VGND VPWR VPWR g_row\[0\].g_col\[1\].pe__2085_/C
+ sky130_fd_sc_hd__a21o_2
XPHY_EDGE_ROW_55_Left_149 VGND VGND VPWR VPWR sky130_fd_sc_hd__decap_3
Xg_row\[1\].g_col\[1\].pe__1859_ g_row\[1\].g_col\[1\].pe__1859_/A g_row\[1\].g_col\[1\].pe__1859_/B
+ VGND VGND VPWR VPWR g_row\[1\].g_col\[1\].pe__1860_/B sky130_fd_sc_hd__xor2_2
XFILLER_69_281 VGND VGND VPWR VPWR sky130_fd_sc_hd__decap_3
XFILLER_85_763 VGND VGND VPWR VPWR sky130_fd_sc_hd__fill_1
XTAP_TAPCELL_ROW_4_266 VGND VPWR sky130_fd_sc_hd__tapvpwrvgnd_1
Xhold1431 hold2412/X VGND VGND VPWR VPWR hold2413/A sky130_fd_sc_hd__clkbuf_2
Xhold1442 hold3170/X VGND VGND VPWR VPWR hold3171/A sky130_fd_sc_hd__clkbuf_2
Xhold2176 hold2176/A VGND VGND VPWR VPWR hold2176/X sky130_fd_sc_hd__clkbuf_2
XFILLER_44_104 VGND VGND VPWR VPWR sky130_fd_sc_hd__decap_3
XTAP_TAPCELL_ROW_4_277 VGND VPWR sky130_fd_sc_hd__tapvpwrvgnd_1
XTAP_TAPCELL_ROW_86_1506 VGND VPWR sky130_fd_sc_hd__tapvpwrvgnd_1
Xhold1453 hold3187/X VGND VGND VPWR VPWR hold3188/A sky130_fd_sc_hd__clkbuf_2
Xhold1464 hold2466/X VGND VGND VPWR VPWR hold2467/A sky130_fd_sc_hd__clkbuf_2
Xhold1475 hold3198/X VGND VGND VPWR VPWR hold3199/A sky130_fd_sc_hd__clkbuf_2
Xhold1486 hold3278/X VGND VGND VPWR VPWR hold3279/A sky130_fd_sc_hd__clkbuf_2
Xhold2198 hold2198/A VGND VGND VPWR VPWR hold2198/X sky130_fd_sc_hd__clkbuf_2
Xg_row\[0\].g_col\[1\].pe__1937_ g_row\[0\].g_col\[1\].pe__1882_/A g_row\[0\].g_col\[1\].pe__1882_/B
+ g_row\[0\].g_col\[1\].pe__1936_/X VGND VGND VPWR VPWR g_row\[0\].g_col\[1\].pe__1952_/A
+ sky130_fd_sc_hd__o21a_2
XFILLER_45_638 VGND VGND VPWR VPWR sky130_fd_sc_hd__decap_3
XFILLER_55_57 VGND VGND VPWR VPWR sky130_fd_sc_hd__decap_3
Xhold1497 hold2544/X VGND VGND VPWR VPWR hold2545/A sky130_fd_sc_hd__clkbuf_2
Xg_row\[0\].g_col\[1\].pe__1868_ g_row\[0\].g_col\[1\].pe__1868_/A g_row\[0\].g_col\[1\].pe__1868_/B
+ VGND VGND VPWR VPWR g_row\[0\].g_col\[1\].pe__1878_/A sky130_fd_sc_hd__xor2_2
Xg_row\[1\].g_col\[0\].pe_place847 g_row\[1\].g_col\[0\].pe__1474_/Y VGND VGND VPWR
+ VPWR g_row\[1\].g_col\[0\].pe__2036_/B1 sky130_fd_sc_hd__buf_6
XFILLER_52_170 VGND VGND VPWR VPWR sky130_fd_sc_hd__fill_2
XPHY_EDGE_ROW_64_Left_158 VGND VGND VPWR VPWR sky130_fd_sc_hd__decap_3
Xg_row\[0\].g_col\[1\].pe__1799_ g_row\[0\].g_col\[1\].pe__1804_/A g_row\[0\].g_col\[1\].pe__1799_/A2
+ g_row\[0\].g_col\[1\].pe__1805_/A2 g_row\[0\].g_col\[1\].pe__1804_/B VGND VGND VPWR
+ VPWR g_row\[0\].g_col\[1\].pe__1800_/B sky130_fd_sc_hd__a22o_2
XFILLER_13_557 VGND VGND VPWR VPWR sky130_fd_sc_hd__decap_3
Xg_row\[0\].g_col\[0\].pe_hold1908 g_row\[0\].g_col\[0\].pe__1406_/Y VGND VGND VPWR
+ VPWR g_row\[0\].g_col\[0\].pe__2404_/B1 sky130_fd_sc_hd__clkbuf_2
XTAP_TAPCELL_ROW_23_552 VGND VPWR sky130_fd_sc_hd__tapvpwrvgnd_1
Xinput1330 hold3210/X VGND VGND VPWR VPWR hold3211/A sky130_fd_sc_hd__buf_2
Xinput1352 hold3273/X VGND VGND VPWR VPWR hold3274/A sky130_fd_sc_hd__buf_2
Xinput1341 hold3294/X VGND VGND VPWR VPWR hold3295/A sky130_fd_sc_hd__buf_2
XPHY_EDGE_ROW_73_Left_167 VGND VGND VPWR VPWR sky130_fd_sc_hd__decap_3
XFILLER_20_93 VGND VGND VPWR VPWR sky130_fd_sc_hd__fill_2
Xg_row\[1\].g_col\[1\].pe_hold1940 g_row\[1\].g_col\[1\].pe__2694_/Q VGND VGND VPWR
+ VPWR g_row\[1\].g_col\[1\].pe__2610_/B sky130_fd_sc_hd__clkbuf_2
Xg_row\[1\].g_col\[1\].pe_hold1962 g_row\[1\].g_col\[1\].pe_hold3065/X VGND VGND VPWR
+ VPWR g_row\[1\].g_col\[1\].pe__1403_/A1 sky130_fd_sc_hd__clkbuf_2
Xg_row\[1\].g_col\[1\].pe_hold1951 g_row\[1\].g_col\[1\].pe__2613_/X VGND VGND VPWR
+ VPWR g_row\[1\].g_col\[1\].pe__2695_/D sky130_fd_sc_hd__clkbuf_2
Xg_row\[1\].g_col\[1\].pe_hold1984 g_row\[1\].g_col\[1\].pe__2607_/X VGND VGND VPWR
+ VPWR g_row\[1\].g_col\[1\].pe__2608_/C1 sky130_fd_sc_hd__clkbuf_2
XFILLER_48_454 VGND VGND VPWR VPWR sky130_fd_sc_hd__decap_3
Xg_row\[1\].g_col\[0\].pe__1361_ g_row\[1\].g_col\[0\].pe__2766_/Q g_row\[1\].g_col\[0\].pe__1361_/B
+ VGND VGND VPWR VPWR output1391/A sky130_fd_sc_hd__xor2_2
XFILLER_36_605 VGND VGND VPWR VPWR sky130_fd_sc_hd__fill_1
XFILLER_17_841 VGND VGND VPWR VPWR sky130_fd_sc_hd__fill_1
XFILLER_48_498 VGND VGND VPWR VPWR sky130_fd_sc_hd__fill_1
XPHY_EDGE_ROW_82_Left_176 VGND VGND VPWR VPWR sky130_fd_sc_hd__decap_3
XFILLER_63_479 VGND VGND VPWR VPWR sky130_fd_sc_hd__fill_1
XFILLER_32_811 VGND VGND VPWR VPWR sky130_fd_sc_hd__fill_1
Xclkbuf_leaf_70_clk clkbuf_4_12_0_clk/X VGND VGND VPWR VPWR clkbuf_leaf_70_clk/X sky130_fd_sc_hd__clkbuf_16
Xg_row\[0\].g_col\[0\].pe__1370_ g_row\[0\].g_col\[0\].pe__2769_/Q g_row\[0\].g_col\[0\].pe__2768_/Q
+ g_row\[0\].g_col\[0\].pe__1366_/B g_row\[0\].g_col\[0\].pe__2776_/A VGND VGND VPWR
+ VPWR g_row\[0\].g_col\[0\].pe__1371_/B sky130_fd_sc_hd__o31a_2
XPHY_EDGE_ROW_91_Left_185 VGND VGND VPWR VPWR sky130_fd_sc_hd__decap_3
Xg_row\[1\].g_col\[1\].pe__2762_ clkbuf_leaf_76_clk/X g_row\[1\].g_col\[1\].pe__2762_/D
+ VGND VGND VPWR VPWR g_row\[1\].g_col\[1\].pe__2762_/Q sky130_fd_sc_hd__dfxtp_2
Xg_row\[1\].g_col\[1\].pe__1713_ g_row\[1\].g_col\[1\].pe__1713_/A g_row\[1\].g_col\[1\].pe__1713_/B
+ VGND VGND VPWR VPWR g_row\[1\].g_col\[1\].pe__1714_/C sky130_fd_sc_hd__xnor2_2
Xg_row\[1\].g_col\[0\].pe__2746_ clkbuf_leaf_60_clk/X g_row\[1\].g_col\[0\].pe__2746_/D
+ VGND VGND VPWR VPWR g_row\[1\].g_col\[0\].pe__2746_/Q sky130_fd_sc_hd__dfxtp_2
Xg_row\[1\].g_col\[1\].pe__2693_ clkload15/A g_row\[1\].g_col\[1\].pe__2693_/D VGND
+ VGND VPWR VPWR g_row\[1\].g_col\[1\].pe__2693_/Q sky130_fd_sc_hd__dfxtp_2
Xg_row\[1\].g_col\[0\].pe_hold3031 g_row\[1\].g_col\[0\].pe__2660_/X VGND VGND VPWR
+ VPWR g_row\[1\].g_col\[0\].pe_hold3031/X sky130_fd_sc_hd__clkbuf_2
Xg_row\[1\].g_col\[0\].pe__2677_ g_row\[1\].g_col\[0\].pe__2677_/A1 g_row\[1\].g_col\[0\].pe__2676_/A
+ g_row\[1\].g_col\[0\].pe__2677_/B1 g_row\[1\].g_col\[0\].pe__2676_/Y VGND VGND VPWR
+ VPWR g_row\[1\].g_col\[0\].pe__2677_/X sky130_fd_sc_hd__o211a_2
Xg_row\[1\].g_col\[1\].pe_place900 g_row\[1\].g_col\[1\].pe__1838_/A VGND VGND VPWR
+ VPWR g_row\[1\].g_col\[1\].pe__1950_/A sky130_fd_sc_hd__buf_6
Xg_row\[1\].g_col\[1\].pe__1644_ g_row\[1\].g_col\[1\].pe__1730_/A g_row\[1\].g_col\[1\].pe__1644_/B
+ VGND VGND VPWR VPWR g_row\[1\].g_col\[1\].pe__1648_/B sky130_fd_sc_hd__xor2_2
Xg_row\[1\].g_col\[0\].pe__1628_ g_row\[1\].g_col\[0\].pe__1879_/A g_row\[1\].g_col\[0\].pe__1879_/B
+ VGND VGND VPWR VPWR g_row\[1\].g_col\[0\].pe__1629_/B sky130_fd_sc_hd__xor2_2
XFILLER_39_421 VGND VGND VPWR VPWR sky130_fd_sc_hd__fill_2
Xg_row\[1\].g_col\[1\].pe__1575_ g_row\[1\].g_col\[1\].pe__2686_/A g_row\[1\].g_col\[1\].pe__1575_/B
+ VGND VGND VPWR VPWR g_row\[1\].g_col\[1\].pe__1626_/B sky130_fd_sc_hd__xor2_2
Xg_row\[1\].g_col\[0\].pe_hold3086 g_row\[1\].g_col\[0\].pe__1386_/X VGND VGND VPWR
+ VPWR g_row\[1\].g_col\[0\].pe_hold3086/X sky130_fd_sc_hd__clkbuf_2
XFILLER_27_627 VGND VGND VPWR VPWR sky130_fd_sc_hd__decap_3
XTAP_TAPCELL_ROW_1_225 VGND VPWR sky130_fd_sc_hd__tapvpwrvgnd_1
Xg_row\[0\].g_col\[0\].pe__2755_ clkbuf_leaf_32_clk/X g_row\[0\].g_col\[0\].pe__2755_/D
+ VGND VGND VPWR VPWR g_row\[0\].g_col\[0\].pe__2755_/Q sky130_fd_sc_hd__dfxtp_2
Xg_row\[1\].g_col\[0\].pe_hold1662 g_row\[1\].g_col\[0\].pe__2592_/X VGND VGND VPWR
+ VPWR g_row\[1\].g_col\[0\].pe__2770_/D sky130_fd_sc_hd__clkbuf_2
Xg_row\[1\].g_col\[0\].pe__1559_ g_row\[1\].g_col\[0\].pe__2599_/B g_row\[1\].g_col\[0\].pe__1558_/B
+ g_row\[1\].g_col\[0\].pe__1558_/C VGND VGND VPWR VPWR g_row\[1\].g_col\[0\].pe__1560_/B
+ sky130_fd_sc_hd__a21o_2
Xg_row\[0\].g_col\[1\].pe__2771_ _274_/CLK g_row\[0\].g_col\[1\].pe__2771_/D VGND
+ VGND VPWR VPWR g_row\[0\].g_col\[1\].pe__2771_/Q sky130_fd_sc_hd__dfxtp_2
XTAP_TAPCELL_ROW_68_1225 VGND VPWR sky130_fd_sc_hd__tapvpwrvgnd_1
XTAP_TAPCELL_ROW_68_1236 VGND VPWR sky130_fd_sc_hd__tapvpwrvgnd_1
Xg_row\[0\].g_col\[0\].pe__1706_ place1214/A g_row\[0\].g_col\[0\].pe__1784_/A2 g_row\[0\].g_col\[0\].pe__1784_/A3
+ g_row\[0\].g_col\[0\].pe__1801_/B place1212/X VGND VGND VPWR VPWR g_row\[0\].g_col\[0\].pe__1707_/B
+ sky130_fd_sc_hd__a32o_2
Xg_row\[0\].g_col\[1\].pe__1722_ g_row\[0\].g_col\[1\].pe__1722_/A g_row\[0\].g_col\[1\].pe__1722_/B
+ VGND VGND VPWR VPWR g_row\[0\].g_col\[1\].pe__1723_/B sky130_fd_sc_hd__xnor2_2
XFILLER_26_159 VGND VGND VPWR VPWR sky130_fd_sc_hd__decap_3
Xg_row\[0\].g_col\[0\].pe__2686_ g_row\[0\].g_col\[0\].pe__2686_/A g_row\[0\].g_col\[0\].pe__2686_/B
+ VGND VGND VPWR VPWR g_row\[0\].g_col\[0\].pe__2686_/X sky130_fd_sc_hd__or2_2
Xg_row\[0\].g_col\[1\].pe__1653_ g_row\[0\].g_col\[1\].pe__1816_/A g_row\[0\].g_col\[1\].pe__1653_/B
+ VGND VGND VPWR VPWR g_row\[0\].g_col\[1\].pe__1656_/A sky130_fd_sc_hd__xor2_2
XTAP_TAPCELL_ROW_81_1425 VGND VPWR sky130_fd_sc_hd__tapvpwrvgnd_1
Xg_row\[0\].g_col\[0\].pe__1637_ g_row\[0\].g_col\[0\].pe__1846_/A g_row\[0\].g_col\[0\].pe__1847_/B
+ VGND VGND VPWR VPWR g_row\[0\].g_col\[0\].pe__1844_/B sky130_fd_sc_hd__xnor2_2
XTAP_TAPCELL_ROW_40_809 VGND VPWR sky130_fd_sc_hd__tapvpwrvgnd_1
Xg_row\[0\].g_col\[0\].pe__1568_ g_row\[0\].g_col\[0\].pe__1596_/A g_row\[0\].g_col\[0\].pe__1596_/B
+ VGND VGND VPWR VPWR g_row\[0\].g_col\[0\].pe__1571_/A sky130_fd_sc_hd__xor2_2
Xg_row\[0\].g_col\[1\].pe__1584_ g_row\[0\].g_col\[1\].pe__1584_/A g_row\[0\].g_col\[1\].pe__1584_/B
+ VGND VGND VPWR VPWR g_row\[0\].g_col\[1\].pe__1584_/Y sky130_fd_sc_hd__nor2_2
Xg_row\[1\].g_col\[1\].pe__2127_ g_row\[1\].g_col\[1\].pe__2128_/B g_row\[1\].g_col\[1\].pe__2128_/C
+ g_row\[1\].g_col\[1\].pe__2128_/A VGND VGND VPWR VPWR g_row\[1\].g_col\[1\].pe__2129_/A
+ sky130_fd_sc_hd__a21oi_2
XFILLER_10_505 VGND VGND VPWR VPWR sky130_fd_sc_hd__fill_2
Xg_row\[1\].g_col\[1\].pe__2058_ g_row\[1\].g_col\[1\].pe__2058_/A g_row\[1\].g_col\[1\].pe__2058_/B
+ VGND VGND VPWR VPWR g_row\[1\].g_col\[1\].pe__2067_/A sky130_fd_sc_hd__xnor2_2
XFILLER_41_15 VGND VGND VPWR VPWR sky130_fd_sc_hd__fill_2
XTAP_TAPCELL_ROW_20_511 VGND VPWR sky130_fd_sc_hd__tapvpwrvgnd_1
Xg_row\[0\].g_col\[0\].pe__1499_ g_row\[0\].g_col\[0\].pe__1499_/A g_row\[0\].g_col\[0\].pe__1499_/B
+ VGND VGND VPWR VPWR g_row\[0\].g_col\[0\].pe__1500_/B sky130_fd_sc_hd__xor2_2
Xg_row\[0\].g_col\[1\].pe__2205_ g_row\[0\].g_col\[1\].pe__2163_/A g_row\[0\].g_col\[1\].pe__2204_/Y
+ g_row\[0\].g_col\[1\].pe__1862_/A g_row\[0\].g_col\[1\].pe__1864_/A VGND VGND VPWR
+ VPWR g_row\[0\].g_col\[1\].pe__2207_/A sky130_fd_sc_hd__a211o_2
XFILLER_2_704 VGND VGND VPWR VPWR sky130_fd_sc_hd__decap_3
XTAP_TAPCELL_ROW_79_1398 VGND VPWR sky130_fd_sc_hd__tapvpwrvgnd_1
Xg_row\[0\].g_col\[1\].pe__2136_ g_row\[0\].g_col\[1\].pe__2136_/A g_row\[0\].g_col\[1\].pe__2136_/B
+ VGND VGND VPWR VPWR g_row\[0\].g_col\[1\].pe__2143_/A sky130_fd_sc_hd__and2_2
XTAP_TAPCELL_ROW_9_347 VGND VPWR sky130_fd_sc_hd__tapvpwrvgnd_1
Xg_row\[0\].g_col\[1\].pe__2067_ g_row\[0\].g_col\[1\].pe__2067_/A g_row\[0\].g_col\[1\].pe__2059_/A
+ VGND VGND VPWR VPWR g_row\[0\].g_col\[1\].pe__2110_/A sky130_fd_sc_hd__nor2b_2
XTAP_TAPCELL_ROW_92_1587 VGND VPWR sky130_fd_sc_hd__tapvpwrvgnd_1
Xplace1271 _165_/A VGND VGND VPWR VPWR place1271/X sky130_fd_sc_hd__buf_6
Xplace1282 _267_/A VGND VGND VPWR VPWR _269_/A sky130_fd_sc_hd__buf_6
XFILLER_45_402 VGND VGND VPWR VPWR sky130_fd_sc_hd__decap_3
XFILLER_66_56 VGND VGND VPWR VPWR sky130_fd_sc_hd__fill_1
XFILLER_66_78 VGND VGND VPWR VPWR sky130_fd_sc_hd__fill_1
XTAP_TAPCELL_ROW_28_633 VGND VPWR sky130_fd_sc_hd__tapvpwrvgnd_1
XFILLER_26_671 VGND VGND VPWR VPWR sky130_fd_sc_hd__fill_2
XFILLER_32_129 VGND VGND VPWR VPWR sky130_fd_sc_hd__decap_3
XFILLER_82_44 VGND VGND VPWR VPWR sky130_fd_sc_hd__fill_1
XFILLER_82_66 VGND VGND VPWR VPWR sky130_fd_sc_hd__fill_1
XFILLER_53_490 VGND VGND VPWR VPWR sky130_fd_sc_hd__decap_3
Xclkbuf_leaf_52_clk clkload8/A VGND VGND VPWR VPWR clkbuf_leaf_52_clk/X sky130_fd_sc_hd__clkbuf_16
XFILLER_15_71 VGND VGND VPWR VPWR sky130_fd_sc_hd__decap_3
Xg_row\[0\].g_col\[0\].pe_hold1716 ANTENNA_180/DIODE VGND VGND VPWR VPWR g_row\[0\].g_col\[0\].pe__2160_/A
+ sky130_fd_sc_hd__clkbuf_2
Xg_row\[0\].g_col\[0\].pe_hold1749 ANTENNA_179/DIODE VGND VGND VPWR VPWR g_row\[0\].g_col\[0\].pe__2306_/A2
+ sky130_fd_sc_hd__clkbuf_2
Xg_row\[1\].g_col\[0\].pe__2600_ g_row\[1\].g_col\[0\].pe__2640_/A1 g_row\[1\].g_col\[0\].pe__2600_/A2
+ g_row\[1\].g_col\[0\].pe__2640_/C1 g_row\[1\].g_col\[0\].pe__2599_/X VGND VGND VPWR
+ VPWR g_row\[1\].g_col\[0\].pe__2600_/X sky130_fd_sc_hd__o211a_2
XFILLER_5_575 VGND VGND VPWR VPWR sky130_fd_sc_hd__fill_1
Xg_row\[1\].g_col\[0\].pe__2531_ g_row\[1\].g_col\[0\].pe__2526_/A g_row\[1\].g_col\[0\].pe__2526_/B
+ g_row\[1\].g_col\[0\].pe__2458_/A VGND VGND VPWR VPWR g_row\[1\].g_col\[0\].pe__2533_/A
+ sky130_fd_sc_hd__a21oi_2
Xg_row\[1\].g_col\[0\].pe__2462_ g_row\[1\].g_col\[0\].pe__2757_/Q g_row\[1\].g_col\[0\].pe__2462_/B
+ VGND VGND VPWR VPWR g_row\[1\].g_col\[0\].pe__2462_/Y sky130_fd_sc_hd__nand2_2
XFILLER_68_549 VGND VGND VPWR VPWR sky130_fd_sc_hd__decap_3
Xg_row\[1\].g_col\[0\].pe__1413_ g_row\[1\].g_col\[0\].pe__1642_/A g_row\[1\].g_col\[0\].pe__1413_/B
+ VGND VGND VPWR VPWR g_row\[1\].g_col\[0\].pe__1428_/A sky130_fd_sc_hd__xnor2_2
XFILLER_48_251 VGND VGND VPWR VPWR sky130_fd_sc_hd__fill_1
XFILLER_49_785 VGND VGND VPWR VPWR sky130_fd_sc_hd__fill_1
XFILLER_64_711 VGND VGND VPWR VPWR sky130_fd_sc_hd__decap_3
XFILLER_76_560 VGND VGND VPWR VPWR sky130_fd_sc_hd__fill_1
Xg_row\[1\].g_col\[1\].pe__1360_ g_row\[1\].g_col\[1\].pe__2765_/Q g_row\[1\].g_col\[1\].pe__1359_/B
+ g_row\[1\].g_col\[1\].pe__2776_/A VGND VGND VPWR VPWR g_row\[1\].g_col\[1\].pe__1361_/B
+ sky130_fd_sc_hd__o21a_2
Xg_row\[1\].g_col\[0\].pe__2393_ g_row\[1\].g_col\[0\].pe__2378_/X g_row\[1\].g_col\[0\].pe__2384_/Y
+ g_row\[1\].g_col\[0\].pe__2392_/Y VGND VGND VPWR VPWR g_row\[1\].g_col\[0\].pe__2393_/Y
+ sky130_fd_sc_hd__a21oi_2
XFILLER_36_424 VGND VGND VPWR VPWR sky130_fd_sc_hd__decap_3
XFILLER_48_295 VGND VGND VPWR VPWR sky130_fd_sc_hd__decap_3
XFILLER_76_593 VGND VGND VPWR VPWR sky130_fd_sc_hd__decap_3
XTAP_TAPCELL_ROW_47_920 VGND VPWR sky130_fd_sc_hd__tapvpwrvgnd_1
Xg_row\[1\].g_col\[0\].pe__1344_ g_row\[1\].g_col\[0\].pe__2758_/Q g_row\[1\].g_col\[0\].pe__1344_/B
+ VGND VGND VPWR VPWR output1382/A sky130_fd_sc_hd__xnor2_2
Xg_row\[0\].g_col\[0\].pe__2540_ g_row\[0\].g_col\[0\].pe__2544_/B g_row\[0\].g_col\[0\].pe__2539_/X
+ g_row\[0\].g_col\[0\].pe__2559_/A VGND VGND VPWR VPWR g_row\[0\].g_col\[0\].pe__2540_/X
+ sky130_fd_sc_hd__a21o_2
XFILLER_91_574 VGND VGND VPWR VPWR sky130_fd_sc_hd__decap_3
Xg_row\[0\].g_col\[0\].pe__2471_ g_row\[0\].g_col\[0\].pe__2471_/A g_row\[0\].g_col\[0\].pe__2495_/A
+ g_row\[0\].g_col\[0\].pe__2471_/C VGND VGND VPWR VPWR g_row\[0\].g_col\[0\].pe__2505_/A
+ sky130_fd_sc_hd__and3_2
Xclkbuf_leaf_43_clk clkbuf_4_12_0_clk/X VGND VGND VPWR VPWR clkbuf_leaf_43_clk/X sky130_fd_sc_hd__clkbuf_16
Xg_row\[0\].g_col\[0\].pe__1422_ g_row\[0\].g_col\[0\].pe__2728_/Q g_row\[0\].g_col\[0\].pe__2727_/Q
+ g_row\[0\].g_col\[0\].pe__2045_/A VGND VGND VPWR VPWR g_row\[0\].g_col\[0\].pe__1424_/A
+ sky130_fd_sc_hd__nand3b_2
XTAP_TAPCELL_ROW_63_1155 VGND VPWR sky130_fd_sc_hd__tapvpwrvgnd_1
Xg_row\[0\].g_col\[0\].pe__1353_ g_row\[0\].g_col\[0\].pe__2762_/Q g_row\[0\].g_col\[0\].pe__1353_/B
+ VGND VGND VPWR VPWR output1415/A sky130_fd_sc_hd__xor2_2
Xg_row\[0\].g_col\[0\].pe_hold2951 g_row\[0\].g_col\[0\].pe__2624_/X VGND VGND VPWR
+ VPWR g_row\[0\].g_col\[0\].pe_hold2951/X sky130_fd_sc_hd__clkbuf_2
Xg_row\[0\].g_col\[0\].pe_hold2962 g_row\[0\].g_col\[0\].pe__2398_/A VGND VGND VPWR
+ VPWR g_row\[0\].g_col\[0\].pe__2679_/A1 sky130_fd_sc_hd__clkbuf_2
XTAP_TAPCELL_ROW_6_306 VGND VPWR sky130_fd_sc_hd__tapvpwrvgnd_1
Xg_row\[1\].g_col\[1\].pe__2745_ clkbuf_leaf_77_clk/X g_row\[1\].g_col\[1\].pe__2745_/D
+ VGND VGND VPWR VPWR g_row\[1\].g_col\[1\].pe__2745_/Q sky130_fd_sc_hd__dfxtp_2
Xg_row\[1\].g_col\[0\].pe__2729_ clkbuf_leaf_45_clk/X g_row\[1\].g_col\[0\].pe__2729_/D
+ VGND VGND VPWR VPWR g_row\[1\].g_col\[0\].pe__2729_/Q sky130_fd_sc_hd__dfxtp_2
Xg_row\[1\].g_col\[1\].pe__2676_ g_row\[1\].g_col\[1\].pe__2676_/A g_row\[1\].g_col\[1\].pe__2678_/B
+ VGND VGND VPWR VPWR g_row\[1\].g_col\[1\].pe__2676_/Y sky130_fd_sc_hd__nand2_2
Xg_row\[1\].g_col\[1\].pe__1627_ g_row\[1\].g_col\[1\].pe__1579_/A g_row\[1\].g_col\[1\].pe__1579_/B
+ g_row\[1\].g_col\[1\].pe__1626_/X VGND VGND VPWR VPWR g_row\[1\].g_col\[1\].pe__1879_/B
+ sky130_fd_sc_hd__a21oi_2
Xg_row\[1\].g_col\[1\].pe__1558_ g_row\[1\].g_col\[1\].pe__1657_/A g_row\[1\].g_col\[1\].pe__1558_/B
+ g_row\[1\].g_col\[1\].pe__1558_/C VGND VGND VPWR VPWR g_row\[1\].g_col\[1\].pe__1607_/A
+ sky130_fd_sc_hd__nand3_2
Xg_row\[0\].g_col\[1\].pe__2754_ _307_/CLK g_row\[0\].g_col\[1\].pe__2754_/D VGND
+ VGND VPWR VPWR g_row\[0\].g_col\[1\].pe__2754_/Q sky130_fd_sc_hd__dfxtp_2
Xg_row\[0\].g_col\[0\].pe__2738_ _319_/CLK g_row\[0\].g_col\[0\].pe__2738_/D VGND
+ VGND VPWR VPWR g_row\[0\].g_col\[0\].pe__2738_/Q sky130_fd_sc_hd__dfxtp_2
Xg_row\[1\].g_col\[1\].pe__1489_ g_row\[1\].g_col\[1\].pe__1733_/A g_row\[1\].g_col\[1\].pe__1489_/B
+ VGND VGND VPWR VPWR g_row\[1\].g_col\[1\].pe__1490_/B sky130_fd_sc_hd__xor2_2
XFILLER_82_585 VGND VGND VPWR VPWR sky130_fd_sc_hd__decap_3
Xg_row\[0\].g_col\[0\].pe__2669_ g_row\[0\].g_col\[0\].pe__2669_/A hold2082/X VGND
+ VGND VPWR VPWR g_row\[0\].g_col\[0\].pe__2669_/X sky130_fd_sc_hd__or2_2
Xg_row\[0\].g_col\[1\].pe__1705_ g_row\[0\].g_col\[1\].pe__1728_/A g_row\[0\].g_col\[1\].pe__1705_/B
+ VGND VGND VPWR VPWR g_row\[0\].g_col\[1\].pe__1709_/A sky130_fd_sc_hd__xnor2_2
Xg_row\[0\].g_col\[1\].pe_hold1846 g_row\[0\].g_col\[1\].pe__2568_/X VGND VGND VPWR
+ VPWR g_row\[0\].g_col\[1\].pe__2569_/B sky130_fd_sc_hd__clkbuf_2
Xg_row\[0\].g_col\[1\].pe__2685_ g_row\[0\].g_col\[1\].pe__2685_/A1 g_row\[0\].g_col\[1\].pe__2680_/B
+ g_row\[0\].g_col\[1\].pe__2684_/X g_row\[0\].g_col\[1\].pe__2687_/C1 VGND VGND VPWR
+ VPWR g_row\[0\].g_col\[1\].pe__2685_/X sky130_fd_sc_hd__o211a_2
Xclkbuf_leaf_34_clk clkbuf_4_6_0_clk/X VGND VGND VPWR VPWR _322_/CLK sky130_fd_sc_hd__clkbuf_16
Xg_row\[0\].g_col\[1\].pe__1636_ g_row\[0\].g_col\[1\].pe__1845_/B g_row\[0\].g_col\[1\].pe__1636_/B
+ VGND VGND VPWR VPWR g_row\[0\].g_col\[1\].pe__1847_/B sky130_fd_sc_hd__xor2_2
Xg_row\[0\].g_col\[1\].pe_hold1879 g_row\[0\].g_col\[1\].pe__2763_/Q VGND VGND VPWR
+ VPWR g_row\[0\].g_col\[1\].pe__2560_/A1 sky130_fd_sc_hd__clkbuf_2
Xg_row\[0\].g_col\[1\].pe__1567_ g_row\[0\].g_col\[1\].pe__1673_/A g_row\[0\].g_col\[1\].pe__1567_/B
+ VGND VGND VPWR VPWR g_row\[0\].g_col\[1\].pe__1596_/B sky130_fd_sc_hd__xnor2_2
XFILLER_22_173 VGND VGND VPWR VPWR sky130_fd_sc_hd__decap_3
Xg_row\[0\].g_col\[1\].pe__1498_ g_row\[0\].g_col\[1\].pe__1676_/A g_row\[0\].g_col\[1\].pe__1498_/B
+ VGND VGND VPWR VPWR g_row\[0\].g_col\[1\].pe__1499_/B sky130_fd_sc_hd__xnor2_2
XFILLER_10_379 VGND VGND VPWR VPWR sky130_fd_sc_hd__fill_2
Xg_row\[0\].g_col\[1\].pe__2119_ g_row\[0\].g_col\[1\].pe__2077_/A g_row\[0\].g_col\[1\].pe__2119_/B
+ VGND VGND VPWR VPWR g_row\[0\].g_col\[1\].pe__2119_/X sky130_fd_sc_hd__and2b_2
XFILLER_89_140 VGND VGND VPWR VPWR sky130_fd_sc_hd__fill_2
XFILLER_2_578 VGND VGND VPWR VPWR sky130_fd_sc_hd__decap_3
XFILLER_77_33 VGND VGND VPWR VPWR sky130_fd_sc_hd__fill_2
Xplace1090 place1090/A VGND VGND VPWR VPWR place1090/X sky130_fd_sc_hd__buf_6
XFILLER_77_335 VGND VGND VPWR VPWR sky130_fd_sc_hd__fill_1
XFILLER_65_508 VGND VGND VPWR VPWR sky130_fd_sc_hd__decap_3
XFILLER_77_357 VGND VGND VPWR VPWR sky130_fd_sc_hd__fill_1
XFILLER_58_582 VGND VGND VPWR VPWR sky130_fd_sc_hd__fill_1
XFILLER_45_243 VGND VGND VPWR VPWR sky130_fd_sc_hd__fill_2
XFILLER_46_799 VGND VGND VPWR VPWR sky130_fd_sc_hd__fill_1
XFILLER_73_585 VGND VGND VPWR VPWR sky130_fd_sc_hd__decap_3
XFILLER_33_449 VGND VGND VPWR VPWR sky130_fd_sc_hd__fill_1
XFILLER_45_298 VGND VGND VPWR VPWR sky130_fd_sc_hd__decap_3
Xclkbuf_leaf_25_clk clkload2/A VGND VGND VPWR VPWR clkbuf_leaf_25_clk/X sky130_fd_sc_hd__clkbuf_16
Xg_row\[0\].g_col\[0\].pe_hold2225 g_row\[0\].g_col\[0\].pe__2685_/X VGND VGND VPWR
+ VPWR g_row\[0\].g_col\[0\].pe__2725_/D sky130_fd_sc_hd__clkbuf_2
XFILLER_13_140 VGND VGND VPWR VPWR sky130_fd_sc_hd__fill_1
XFILLER_9_100 VGND VGND VPWR VPWR sky130_fd_sc_hd__decap_3
Xg_row\[0\].g_col\[0\].pe_hold2236 g_row\[0\].g_col\[0\].pe_hold2268/X VGND VGND VPWR
+ VPWR g_row\[0\].g_col\[0\].pe__2683_/A1 sky130_fd_sc_hd__clkbuf_2
XFILLER_41_493 VGND VGND VPWR VPWR sky130_fd_sc_hd__decap_3
Xg_row\[0\].g_col\[0\].pe_hold2269 g_row\[0\].g_col\[0\].pe__2683_/A1 VGND VGND VPWR
+ VPWR g_row\[0\].g_col\[0\].pe__2644_/A2 sky130_fd_sc_hd__clkbuf_2
XFILLER_9_177 VGND VGND VPWR VPWR sky130_fd_sc_hd__fill_2
XTAP_TAPCELL_ROW_11_374 VGND VPWR sky130_fd_sc_hd__tapvpwrvgnd_1
X_298_ _308_/CLK _298_/D VGND VGND VPWR VPWR _298_/Q sky130_fd_sc_hd__dfxtp_2
Xg_row\[1\].g_col\[0\].pe__1962_ g_row\[1\].g_col\[0\].pe__2024_/A g_row\[1\].g_col\[0\].pe__1962_/B
+ VGND VGND VPWR VPWR g_row\[1\].g_col\[0\].pe__1963_/B sky130_fd_sc_hd__and2_2
Xg_row\[1\].g_col\[0\].pe__1893_ g_row\[1\].g_col\[0\].pe__2514_/A g_row\[1\].g_col\[0\].pe__1893_/B
+ VGND VGND VPWR VPWR g_row\[1\].g_col\[0\].pe__1893_/Y sky130_fd_sc_hd__nor2_2
XFILLER_5_372 VGND VGND VPWR VPWR sky130_fd_sc_hd__decap_3
XFILLER_5_383 VGND VGND VPWR VPWR sky130_fd_sc_hd__fill_1
Xg_row\[0\].g_col\[0\].pe__1971_ g_row\[0\].g_col\[0\].pe__1461_/A g_row\[0\].g_col\[0\].pe__1461_/B
+ hold2339/A VGND VGND VPWR VPWR g_row\[0\].g_col\[0\].pe__1972_/C sky130_fd_sc_hd__a21bo_2
Xhold2709 hold3412/X VGND VGND VPWR VPWR hold3413/A sky130_fd_sc_hd__clkbuf_2
Xg_row\[1\].g_col\[0\].pe__2514_ g_row\[1\].g_col\[0\].pe__2514_/A g_row\[1\].g_col\[0\].pe__2514_/B
+ VGND VGND VPWR VPWR g_row\[1\].g_col\[0\].pe__2514_/Y sky130_fd_sc_hd__nor2_2
Xg_row\[1\].g_col\[1\].pe__2461_ g_row\[1\].g_col\[1\].pe__2757_/Q g_row\[1\].g_col\[1\].pe__2462_/B
+ VGND VGND VPWR VPWR g_row\[1\].g_col\[1\].pe__2519_/B sky130_fd_sc_hd__xnor2_2
Xg_row\[1\].g_col\[1\].pe__1412_ g_row\[1\].g_col\[1\].pe__1727_/A1 g_row\[1\].g_col\[1\].pe__2700_/Q
+ g_row\[1\].g_col\[1\].pe__1608_/A1 g_row\[1\].g_col\[1\].pe__1727_/B2 VGND VGND
+ VPWR VPWR g_row\[1\].g_col\[1\].pe__1413_/B sky130_fd_sc_hd__a22o_2
Xg_row\[1\].g_col\[0\].pe__2445_ g_row\[1\].g_col\[0\].pe__2445_/A g_row\[1\].g_col\[0\].pe__2445_/B
+ VGND VGND VPWR VPWR g_row\[1\].g_col\[0\].pe__2446_/B sky130_fd_sc_hd__xnor2_2
Xg_row\[1\].g_col\[1\].pe__2392_ g_row\[1\].g_col\[1\].pe__2392_/A g_row\[1\].g_col\[1\].pe__2392_/B
+ VGND VGND VPWR VPWR g_row\[1\].g_col\[1\].pe__2392_/Y sky130_fd_sc_hd__xnor2_2
Xg_row\[1\].g_col\[0\].pe__2376_ g_row\[1\].g_col\[0\].pe__2377_/A g_row\[1\].g_col\[0\].pe__2359_/B
+ g_row\[1\].g_col\[0\].pe__2377_/B g_row\[1\].g_col\[0\].pe__2356_/A VGND VGND VPWR
+ VPWR g_row\[1\].g_col\[0\].pe__2376_/X sky130_fd_sc_hd__a211o_2
Xg_row\[1\].g_col\[1\].pe__1343_ g_row\[1\].g_col\[1\].pe__2757_/Q g_row\[1\].g_col\[1\].pe__2775_/A
+ g_row\[1\].g_col\[1\].pe__1348_/A VGND VGND VPWR VPWR g_row\[1\].g_col\[1\].pe__1344_/B
+ sky130_fd_sc_hd__o21ai_2
XFILLER_64_585 VGND VGND VPWR VPWR sky130_fd_sc_hd__decap_3
XFILLER_91_393 VGND VGND VPWR VPWR sky130_fd_sc_hd__decap_3
XTAP_TAPCELL_ROW_19_496 VGND VPWR sky130_fd_sc_hd__tapvpwrvgnd_1
Xclkbuf_leaf_16_clk clkbuf_4_4_0_clk/X VGND VGND VPWR VPWR _279_/CLK sky130_fd_sc_hd__clkbuf_16
Xg_row\[0\].g_col\[1\].pe__2470_ g_row\[0\].g_col\[1\].pe__2551_/A g_row\[0\].g_col\[1\].pe__2551_/B
+ g_row\[0\].g_col\[1\].pe__2551_/C g_row\[0\].g_col\[1\].pe__2444_/A g_row\[0\].g_col\[1\].pe__2496_/B
+ VGND VGND VPWR VPWR g_row\[0\].g_col\[1\].pe__2471_/C sky130_fd_sc_hd__a311o_2
XFILLER_20_600 VGND VGND VPWR VPWR sky130_fd_sc_hd__decap_3
Xg_row\[0\].g_col\[0\].pe__2454_ g_row\[0\].g_col\[0\].pe__2759_/Q g_row\[0\].g_col\[0\].pe__2464_/B
+ VGND VGND VPWR VPWR g_row\[0\].g_col\[0\].pe__2538_/B sky130_fd_sc_hd__or2_2
Xg_row\[0\].g_col\[1\].pe__1421_ g_row\[0\].g_col\[1\].pe__2726_/Q g_row\[0\].g_col\[1\].pe__2727_/Q
+ VGND VGND VPWR VPWR g_row\[0\].g_col\[1\].pe__1982_/B sky130_fd_sc_hd__xor2_2
XTAP_TAPCELL_ROW_50_959 VGND VPWR sky130_fd_sc_hd__tapvpwrvgnd_1
Xg_row\[0\].g_col\[0\].pe__1405_ g_row\[0\].g_col\[0\].pe__1838_/A _275_/Q VGND VGND
+ VPWR VPWR g_row\[0\].g_col\[0\].pe__2157_/A sky130_fd_sc_hd__nor2_2
Xg_row\[0\].g_col\[0\].pe__2385_ g_row\[0\].g_col\[0\].pe__2385_/A g_row\[0\].g_col\[0\].pe__2385_/B
+ VGND VGND VPWR VPWR g_row\[0\].g_col\[0\].pe__2392_/A sky130_fd_sc_hd__nand2_2
Xg_row\[0\].g_col\[1\].pe__1352_ g_row\[0\].g_col\[1\].pe__2761_/Q g_row\[0\].g_col\[1\].pe__2760_/Q
+ g_row\[0\].g_col\[1\].pe__1348_/B g_row\[0\].g_col\[1\].pe__2771_/Q VGND VGND VPWR
+ VPWR g_row\[0\].g_col\[1\].pe__1353_/B sky130_fd_sc_hd__o31a_2
XTAP_TAPCELL_ROW_30_661 VGND VPWR sky130_fd_sc_hd__tapvpwrvgnd_1
XTAP_TAPCELL_ROW_76_1346 VGND VPWR sky130_fd_sc_hd__tapvpwrvgnd_1
XTAP_TAPCELL_ROW_76_1357 VGND VPWR sky130_fd_sc_hd__tapvpwrvgnd_1
XFILLER_87_600 VGND VGND VPWR VPWR sky130_fd_sc_hd__decap_3
Xg_row\[1\].g_col\[1\].pe__2728_ clkbuf_leaf_82_clk/X g_row\[1\].g_col\[1\].pe__2728_/D
+ VGND VGND VPWR VPWR g_row\[1\].g_col\[1\].pe__2728_/Q sky130_fd_sc_hd__dfxtp_2
XFILLER_86_110 VGND VGND VPWR VPWR sky130_fd_sc_hd__decap_3
Xg_row\[1\].g_col\[1\].pe__2659_ g_row\[1\].g_col\[1\].pe__2669_/A g_row\[1\].g_col\[1\].pe__2659_/B
+ VGND VGND VPWR VPWR g_row\[1\].g_col\[1\].pe__2659_/X sky130_fd_sc_hd__or2_2
XFILLER_75_839 VGND VGND VPWR VPWR sky130_fd_sc_hd__fill_1
Xg_row\[0\].g_col\[1\].pe_hold2344 g_row\[0\].g_col\[1\].pe__1397_/X VGND VGND VPWR
+ VPWR g_row\[0\].g_col\[1\].pe__2734_/D sky130_fd_sc_hd__clkbuf_2
Xg_row\[0\].g_col\[1\].pe_hold2333 g_row\[0\].g_col\[1\].pe__2198_/X VGND VGND VPWR
+ VPWR g_row\[0\].g_col\[1\].pe__2199_/B sky130_fd_sc_hd__clkbuf_2
XTAP_TAPCELL_ROW_38_783 VGND VPWR sky130_fd_sc_hd__tapvpwrvgnd_1
Xg_row\[0\].g_col\[1\].pe_hold2377 g_row\[0\].g_col\[1\].pe__2236_/X VGND VGND VPWR
+ VPWR g_row\[0\].g_col\[1\].pe__2237_/B sky130_fd_sc_hd__clkbuf_2
Xg_row\[0\].g_col\[1\].pe_hold2355 g_row\[0\].g_col\[1\].pe__2635_/C VGND VGND VPWR
+ VPWR g_row\[0\].g_col\[1\].pe__2633_/A2 sky130_fd_sc_hd__clkbuf_2
Xg_row\[0\].g_col\[1\].pe__2737_ clkbuf_leaf_91_clk/X g_row\[0\].g_col\[1\].pe__2737_/D
+ VGND VGND VPWR VPWR g_row\[0\].g_col\[1\].pe__2737_/Q sky130_fd_sc_hd__dfxtp_2
XFILLER_70_533 VGND VGND VPWR VPWR sky130_fd_sc_hd__decap_3
XFILLER_70_555 VGND VGND VPWR VPWR sky130_fd_sc_hd__decap_3
Xg_row\[0\].g_col\[1\].pe_hold2399 g_row\[0\].g_col\[1\].pe__2401_/X VGND VGND VPWR
+ VPWR g_row\[0\].g_col\[1\].pe__2402_/B sky130_fd_sc_hd__clkbuf_2
Xg_row\[0\].g_col\[1\].pe_hold2388 g_row\[0\].g_col\[1\].pe_hold3111/X VGND VGND VPWR
+ VPWR g_row\[0\].g_col\[1\].pe__1950_/B sky130_fd_sc_hd__clkbuf_2
Xg_row\[0\].g_col\[1\].pe__2668_ g_row\[0\].g_col\[1\].pe__2668_/A1 g_row\[0\].g_col\[1\].pe__1400_/A
+ g_row\[0\].g_col\[1\].pe__2677_/B1 g_row\[0\].g_col\[1\].pe__2667_/X VGND VGND VPWR
+ VPWR g_row\[0\].g_col\[1\].pe__2668_/X sky130_fd_sc_hd__o211a_2
XFILLER_70_599 VGND VGND VPWR VPWR sky130_fd_sc_hd__decap_3
X_221_ _235_/A _221_/B_N VGND VGND VPWR VPWR _221_/Y sky130_fd_sc_hd__nor2b_4
Xg_row\[0\].g_col\[1\].pe__1619_ g_row\[0\].g_col\[1\].pe__1875_/A g_row\[0\].g_col\[1\].pe__1875_/B
+ VGND VGND VPWR VPWR g_row\[0\].g_col\[1\].pe__1622_/A sky130_fd_sc_hd__nand2_2
Xg_row\[0\].g_col\[1\].pe__2599_ g_row\[0\].g_col\[1\].pe__2669_/A g_row\[0\].g_col\[1\].pe__2599_/B
+ VGND VGND VPWR VPWR g_row\[0\].g_col\[1\].pe__2599_/X sky130_fd_sc_hd__or2_2
XFILLER_7_626 VGND VGND VPWR VPWR sky130_fd_sc_hd__decap_3
XFILLER_7_637 VGND VGND VPWR VPWR sky130_fd_sc_hd__decap_3
XFILLER_78_622 VGND VGND VPWR VPWR sky130_fd_sc_hd__decap_3
Xg_row\[1\].g_col\[0\].pe_hold2929 g_row\[1\].g_col\[0\].pe__2631_/X VGND VGND VPWR
+ VPWR g_row\[1\].g_col\[0\].pe_hold2929/X sky130_fd_sc_hd__clkbuf_2
Xg_row\[1\].g_col\[0\].pe_hold2918 _294_/Q VGND VGND VPWR VPWR g_row\[1\].g_col\[0\].pe_hold2918/X
+ sky130_fd_sc_hd__clkbuf_2
XFILLER_78_699 VGND VGND VPWR VPWR sky130_fd_sc_hd__fill_1
Xg_row\[1\].g_col\[0\].pe__2230_ g_row\[1\].g_col\[0\].pe__2238_/A g_row\[1\].g_col\[0\].pe__2238_/B
+ VGND VGND VPWR VPWR g_row\[1\].g_col\[0\].pe__2298_/A sky130_fd_sc_hd__xnor2_2
XFILLER_18_243 VGND VGND VPWR VPWR sky130_fd_sc_hd__fill_1
XFILLER_46_552 VGND VGND VPWR VPWR sky130_fd_sc_hd__decap_3
Xg_row\[1\].g_col\[0\].pe__2161_ g_row\[1\].g_col\[0\].pe__2161_/A g_row\[1\].g_col\[0\].pe__2161_/B
+ VGND VGND VPWR VPWR g_row\[1\].g_col\[0\].pe__2161_/Y sky130_fd_sc_hd__nand2_2
XFILLER_46_585 VGND VGND VPWR VPWR sky130_fd_sc_hd__decap_3
XFILLER_73_393 VGND VGND VPWR VPWR sky130_fd_sc_hd__fill_1
Xg_row\[0\].g_col\[0\].pe_hold2000 g_row\[0\].g_col\[0\].pe__1835_/X VGND VGND VPWR
+ VPWR g_row\[0\].g_col\[0\].pe__1836_/B sky130_fd_sc_hd__clkbuf_2
Xg_row\[1\].g_col\[0\].pe__2092_ g_row\[1\].g_col\[0\].pe__2091_/A g_row\[1\].g_col\[0\].pe__2091_/B
+ g_row\[1\].g_col\[0\].pe__2091_/C VGND VGND VPWR VPWR g_row\[1\].g_col\[0\].pe__2097_/C
+ sky130_fd_sc_hd__a21oi_2
XTAP_TAPCELL_ROW_16_444 VGND VPWR sky130_fd_sc_hd__tapvpwrvgnd_1
XTAP_TAPCELL_ROW_16_455 VGND VPWR sky130_fd_sc_hd__tapvpwrvgnd_1
Xg_row\[0\].g_col\[0\].pe_hold2011 g_row\[0\].g_col\[0\].pe_hold2975/X VGND VGND VPWR
+ VPWR g_row\[0\].g_col\[0\].pe__2672_/C sky130_fd_sc_hd__clkbuf_2
Xg_row\[0\].g_col\[0\].pe_hold2022 g_row\[0\].g_col\[0\].pe__2731_/Q VGND VGND VPWR
+ VPWR g_row\[0\].g_col\[0\].pe__1391_/A1 sky130_fd_sc_hd__clkbuf_2
XFILLER_42_791 VGND VGND VPWR VPWR sky130_fd_sc_hd__fill_2
XFILLER_61_599 VGND VGND VPWR VPWR sky130_fd_sc_hd__decap_3
XTAP_TAPCELL_ROW_60_1103 VGND VPWR sky130_fd_sc_hd__tapvpwrvgnd_1
XTAP_TAPCELL_ROW_60_1114 VGND VPWR sky130_fd_sc_hd__tapvpwrvgnd_1
Xg_row\[0\].g_col\[0\].pe__2170_ g_row\[0\].g_col\[0\].pe__2083_/A g_row\[0\].g_col\[0\].pe__1471_/X
+ g_row\[0\].g_col\[0\].pe__1474_/Y g_row\[0\].g_col\[0\].pe__2030_/A VGND VGND VPWR
+ VPWR g_row\[0\].g_col\[0\].pe__2171_/B sky130_fd_sc_hd__a22o_2
Xg_row\[1\].g_col\[1\].pe__1961_ g_row\[1\].g_col\[1\].pe__1961_/A g_row\[1\].g_col\[1\].pe__1961_/B
+ VGND VGND VPWR VPWR g_row\[1\].g_col\[1\].pe__1962_/B sky130_fd_sc_hd__or2_2
Xg_row\[1\].g_col\[0\].pe__1945_ g_row\[1\].g_col\[0\].pe__1894_/Y g_row\[1\].g_col\[0\].pe__1895_/X
+ g_row\[1\].g_col\[0\].pe__2151_/A VGND VGND VPWR VPWR g_row\[1\].g_col\[0\].pe__2008_/A
+ sky130_fd_sc_hd__a21o_2
Xg_row\[1\].g_col\[1\].pe__1892_ g_row\[1\].g_col\[1\].pe__1838_/A g_row\[1\].g_col\[1\].pe_hold1684/X
+ g_row\[1\].g_col\[1\].pe__2394_/B1 g_row\[1\].g_col\[1\].pe__1891_/Y VGND VGND VPWR
+ VPWR g_row\[1\].g_col\[1\].pe__1892_/X sky130_fd_sc_hd__o2bb2a_2
XTAP_TAPCELL_ROW_58_1076 VGND VPWR sky130_fd_sc_hd__tapvpwrvgnd_1
Xg_row\[1\].g_col\[0\].pe__1876_ g_row\[1\].g_col\[0\].pe__1625_/A g_row\[1\].g_col\[0\].pe__1625_/B
+ g_row\[1\].g_col\[0\].pe__1875_/X VGND VGND VPWR VPWR g_row\[1\].g_col\[0\].pe__1877_/B
+ sky130_fd_sc_hd__a21oi_2
XTAP_TAPCELL_ROW_58_1087 VGND VPWR sky130_fd_sc_hd__tapvpwrvgnd_1
Xclkbuf_leaf_5_clk clkbuf_4_0_0_clk/X VGND VGND VPWR VPWR clkload9/A sky130_fd_sc_hd__clkbuf_16
Xhold3207 b_inputs_flat[20] VGND VGND VPWR VPWR hold3207/X sky130_fd_sc_hd__clkbuf_2
Xhold3218 hold3218/A VGND VGND VPWR VPWR hold3218/X sky130_fd_sc_hd__clkbuf_2
Xhold3229 hold3229/A VGND VGND VPWR VPWR hold3229/X sky130_fd_sc_hd__clkbuf_2
XFILLER_69_633 VGND VGND VPWR VPWR sky130_fd_sc_hd__decap_3
Xhold2506 hold3253/X VGND VGND VPWR VPWR hold3254/A sky130_fd_sc_hd__clkbuf_2
Xhold2517 hold3223/X VGND VGND VPWR VPWR hold3224/A sky130_fd_sc_hd__clkbuf_2
Xhold2528 hold3277/X VGND VGND VPWR VPWR hold3278/A sky130_fd_sc_hd__clkbuf_2
Xg_row\[1\].g_col\[1\].pe__2513_ g_row\[1\].g_col\[1\].pe__2513_/A1 g_row\[1\].g_col\[1\].pe__2406_/Y
+ g_row\[1\].g_col\[1\].pe__2512_/X VGND VGND VPWR VPWR g_row\[1\].g_col\[1\].pe__2513_/Y
+ sky130_fd_sc_hd__a21oi_2
Xg_row\[0\].g_col\[1\].pe__1970_ g_row\[0\].g_col\[1\].pe__1970_/A g_row\[0\].g_col\[1\].pe__2163_/B
+ VGND VGND VPWR VPWR g_row\[0\].g_col\[1\].pe__1972_/B sky130_fd_sc_hd__nand2_2
XFILLER_29_508 VGND VGND VPWR VPWR sky130_fd_sc_hd__fill_1
XTAP_TAPCELL_ROW_71_1276 VGND VPWR sky130_fd_sc_hd__tapvpwrvgnd_1
Xg_row\[0\].g_col\[0\].pe__1954_ g_row\[0\].g_col\[0\].pe__1857_/A g_row\[0\].g_col\[0\].pe__1857_/B
+ g_row\[0\].g_col\[0\].pe__1908_/B g_row\[0\].g_col\[0\].pe__1907_/B g_row\[0\].g_col\[0\].pe__1907_/A
+ VGND VGND VPWR VPWR g_row\[0\].g_col\[0\].pe__2002_/A sky130_fd_sc_hd__a32o_2
Xhold2539 hold2539/A VGND VGND VPWR VPWR _331_/D sky130_fd_sc_hd__clkbuf_2
XFILLER_83_113 VGND VGND VPWR VPWR sky130_fd_sc_hd__fill_1
Xg_row\[0\].g_col\[0\].pe__1885_ g_row\[0\].g_col\[0\].pe__1885_/A g_row\[0\].g_col\[0\].pe__1896_/A
+ VGND VGND VPWR VPWR g_row\[0\].g_col\[0\].pe__1897_/B sky130_fd_sc_hd__xnor2_2
Xg_row\[1\].g_col\[1\].pe__2444_ g_row\[1\].g_col\[1\].pe__2444_/A g_row\[1\].g_col\[1\].pe__2444_/B
+ VGND VGND VPWR VPWR g_row\[1\].g_col\[1\].pe__2551_/A sky130_fd_sc_hd__nor2_2
Xg_row\[1\].g_col\[0\].pe__2428_ g_row\[1\].g_col\[0\].pe__2427_/B g_row\[1\].g_col\[0\].pe__2769_/Q
+ VGND VGND VPWR VPWR g_row\[1\].g_col\[0\].pe__2494_/B sky130_fd_sc_hd__and2b_2
XFILLER_37_541 VGND VGND VPWR VPWR sky130_fd_sc_hd__decap_3
XFILLER_49_390 VGND VGND VPWR VPWR sky130_fd_sc_hd__fill_2
XFILLER_56_349 VGND VGND VPWR VPWR sky130_fd_sc_hd__decap_3
Xg_row\[1\].g_col\[1\].pe__2375_ g_row\[1\].g_col\[1\].pe__2375_/A g_row\[1\].g_col\[1\].pe__2375_/B
+ VGND VGND VPWR VPWR g_row\[1\].g_col\[1\].pe__2377_/B sky130_fd_sc_hd__xor2_2
Xg_row\[1\].g_col\[0\].pe__2359_ g_row\[1\].g_col\[0\].pe__2377_/A g_row\[1\].g_col\[0\].pe__2359_/B
+ VGND VGND VPWR VPWR g_row\[1\].g_col\[0\].pe__2359_/Y sky130_fd_sc_hd__xnor2_2
XFILLER_25_758 VGND VGND VPWR VPWR sky130_fd_sc_hd__fill_1
XFILLER_92_691 VGND VGND VPWR VPWR sky130_fd_sc_hd__decap_3
XTAP_TAPCELL_ROW_35_731 VGND VPWR sky130_fd_sc_hd__tapvpwrvgnd_1
Xg_row\[0\].g_col\[1\].pe__2522_ g_row\[0\].g_col\[1\].pe__2595_/A g_row\[0\].g_col\[1\].pe__2522_/B
+ VGND VGND VPWR VPWR g_row\[0\].g_col\[1\].pe__2757_/D sky130_fd_sc_hd__and2_2
XFILLER_52_566 VGND VGND VPWR VPWR sky130_fd_sc_hd__decap_3
XTAP_TAPCELL_ROW_35_742 VGND VPWR sky130_fd_sc_hd__tapvpwrvgnd_1
Xg_row\[0\].g_col\[0\].pe__2506_ g_row\[0\].g_col\[0\].pe__2571_/A g_row\[0\].g_col\[0\].pe__2567_/A
+ g_row\[0\].g_col\[0\].pe__2506_/C g_row\[0\].g_col\[0\].pe__2505_/X VGND VGND VPWR
+ VPWR g_row\[0\].g_col\[0\].pe__2507_/B sky130_fd_sc_hd__or4b_4
Xg_row\[0\].g_col\[0\].pe__2437_ g_row\[0\].g_col\[0\].pe__2438_/B g_row\[0\].g_col\[0\].pe__2764_/Q
+ VGND VGND VPWR VPWR g_row\[0\].g_col\[0\].pe__2491_/B sky130_fd_sc_hd__and2b_2
Xg_row\[0\].g_col\[1\].pe__2453_ g_row\[0\].g_col\[1\].pe__2742_/Q g_row\[0\].g_col\[1\].pe__2453_/B
+ VGND VGND VPWR VPWR g_row\[0\].g_col\[1\].pe__2464_/B sky130_fd_sc_hd__xnor2_2
Xg_row\[0\].g_col\[1\].pe__1404_ place1249/X VGND VGND VPWR VPWR g_row\[0\].g_col\[1\].pe__1838_/A
+ sky130_fd_sc_hd__inv_2
Xg_row\[0\].g_col\[1\].pe__2384_ g_row\[0\].g_col\[1\].pe__2375_/A g_row\[0\].g_col\[1\].pe__2356_/A
+ g_row\[0\].g_col\[1\].pe__2375_/B VGND VGND VPWR VPWR g_row\[0\].g_col\[1\].pe__2384_/Y
+ sky130_fd_sc_hd__o21ai_2
XFILLER_20_452 VGND VGND VPWR VPWR sky130_fd_sc_hd__decap_3
Xg_row\[0\].g_col\[0\].pe__2368_ g_row\[0\].g_col\[0\].pe__2368_/A g_row\[0\].g_col\[0\].pe__2368_/B
+ g_row\[0\].g_col\[0\].pe__2367_/X VGND VGND VPWR VPWR g_row\[0\].g_col\[0\].pe__2387_/A
+ sky130_fd_sc_hd__or3b_2
Xg_row\[0\].g_col\[0\].pe__2299_ g_row\[0\].g_col\[0\].pe__2299_/A g_row\[0\].g_col\[0\].pe__2299_/B
+ VGND VGND VPWR VPWR g_row\[0\].g_col\[0\].pe__2300_/B sky130_fd_sc_hd__or2_4
XFILLER_3_106 VGND VGND VPWR VPWR sky130_fd_sc_hd__fill_2
XFILLER_4_618 VGND VGND VPWR VPWR sky130_fd_sc_hd__decap_3
XTAP_TAPCELL_ROW_89_1548 VGND VPWR sky130_fd_sc_hd__tapvpwrvgnd_1
XFILLER_28_530 VGND VGND VPWR VPWR sky130_fd_sc_hd__fill_2
XFILLER_74_168 VGND VGND VPWR VPWR sky130_fd_sc_hd__fill_1
Xg_row\[0\].g_col\[1\].pe_hold2130 g_row\[0\].g_col\[1\].pe_hold2146/X VGND VGND VPWR
+ VPWR g_row\[0\].g_col\[1\].pe__2674_/A sky130_fd_sc_hd__clkbuf_2
XFILLER_43_522 VGND VGND VPWR VPWR sky130_fd_sc_hd__fill_1
Xg_row\[0\].g_col\[1\].pe_hold2196 g_row\[0\].g_col\[1\].pe_hold2998/X VGND VGND VPWR
+ VPWR g_row\[0\].g_col\[1\].pe__1394_/A sky130_fd_sc_hd__clkbuf_2
Xg_row\[0\].g_col\[1\].pe_hold2174 g_row\[0\].g_col\[1\].pe__1389_/A VGND VGND VPWR
+ VPWR g_row\[0\].g_col\[1\].pe__2658_/A2 sky130_fd_sc_hd__clkbuf_2
Xg_row\[0\].g_col\[1\].pe_hold2163 g_row\[0\].g_col\[1\].pe__2643_/X VGND VGND VPWR
+ VPWR g_row\[0\].g_col\[1\].pe__2644_/C1 sky130_fd_sc_hd__clkbuf_2
XFILLER_31_706 VGND VGND VPWR VPWR sky130_fd_sc_hd__fill_1
XFILLER_15_279 VGND VGND VPWR VPWR sky130_fd_sc_hd__fill_1
XFILLER_30_216 VGND VGND VPWR VPWR sky130_fd_sc_hd__decap_3
XTAP_TAPCELL_ROW_13_403 VGND VPWR sky130_fd_sc_hd__tapvpwrvgnd_1
Xg_row\[1\].g_col\[0\].pe__1730_ g_row\[1\].g_col\[0\].pe__1730_/A g_row\[1\].g_col\[0\].pe__1730_/B
+ VGND VGND VPWR VPWR g_row\[1\].g_col\[0\].pe__1734_/B sky130_fd_sc_hd__xor2_2
Xg_row\[0\].g_col\[0\].pe_place870 g_row\[0\].g_col\[0\].pe__1471_/X VGND VGND VPWR
+ VPWR g_row\[0\].g_col\[0\].pe__1657_/B sky130_fd_sc_hd__buf_6
XFILLER_3_673 VGND VGND VPWR VPWR sky130_fd_sc_hd__decap_3
Xg_row\[1\].g_col\[0\].pe__1661_ g_row\[1\].g_col\[0\].pe__1693_/A g_row\[1\].g_col\[0\].pe__1693_/B
+ g_row\[1\].g_col\[0\].pe__1660_/Y VGND VGND VPWR VPWR g_row\[1\].g_col\[0\].pe__1663_/A
+ sky130_fd_sc_hd__a21o_2
Xg_row\[1\].g_col\[0\].pe__1592_ g_row\[1\].g_col\[0\].pe__1830_/A g_row\[1\].g_col\[0\].pe__1830_/B
+ g_row\[1\].g_col\[0\].pe__1830_/C VGND VGND VPWR VPWR g_row\[1\].g_col\[0\].pe__1840_/A
+ sky130_fd_sc_hd__o21ai_2
XFILLER_66_625 VGND VGND VPWR VPWR sky130_fd_sc_hd__decap_3
XFILLER_0_42 VGND VGND VPWR VPWR sky130_fd_sc_hd__fill_1
XFILLER_34_500 VGND VGND VPWR VPWR sky130_fd_sc_hd__decap_3
XFILLER_81_617 VGND VGND VPWR VPWR sky130_fd_sc_hd__decap_3
XFILLER_93_477 VGND VGND VPWR VPWR sky130_fd_sc_hd__fill_2
Xg_row\[0\].g_col\[0\].pe__1670_ place1216/X g_row\[0\].g_col\[0\].pe__1748_/B g_row\[0\].g_col\[0\].pe__1738_/B1
+ place1217/X VGND VGND VPWR VPWR g_row\[0\].g_col\[0\].pe__1671_/B sky130_fd_sc_hd__a22o_2
Xg_row\[1\].g_col\[0\].pe__2213_ g_row\[1\].g_col\[0\].pe__2213_/A g_row\[1\].g_col\[0\].pe__2213_/B
+ VGND VGND VPWR VPWR g_row\[1\].g_col\[0\].pe__2220_/A sky130_fd_sc_hd__nand2_2
XFILLER_74_680 VGND VGND VPWR VPWR sky130_fd_sc_hd__decap_3
Xg_row\[1\].g_col\[1\].pe__2160_ g_row\[1\].g_col\[1\].pe__2160_/A VGND VGND VPWR
+ VPWR g_row\[1\].g_col\[1\].pe__2439_/A sky130_fd_sc_hd__inv_2
Xg_row\[1\].g_col\[0\].pe__2144_ g_row\[1\].g_col\[0\].pe__2144_/A g_row\[1\].g_col\[0\].pe__2144_/B
+ VGND VGND VPWR VPWR g_row\[1\].g_col\[0\].pe__2192_/A sky130_fd_sc_hd__xnor2_2
XFILLER_61_363 VGND VGND VPWR VPWR sky130_fd_sc_hd__fill_2
Xg_row\[1\].g_col\[1\].pe__2091_ g_row\[1\].g_col\[1\].pe__2091_/A g_row\[1\].g_col\[1\].pe__2091_/B
+ g_row\[1\].g_col\[1\].pe__2091_/C VGND VGND VPWR VPWR g_row\[1\].g_col\[1\].pe__2097_/B
+ sky130_fd_sc_hd__and3_4
Xg_row\[1\].g_col\[0\].pe__2075_ g_row\[1\].g_col\[0\].pe__2075_/A g_row\[1\].g_col\[0\].pe__2075_/B
+ VGND VGND VPWR VPWR g_row\[1\].g_col\[0\].pe__2136_/B sky130_fd_sc_hd__xnor2_2
XFILLER_61_374 VGND VGND VPWR VPWR sky130_fd_sc_hd__decap_3
Xg_row\[0\].g_col\[0\].pe__2222_ g_row\[0\].g_col\[0\].pe__2222_/A g_row\[0\].g_col\[0\].pe__2253_/A
+ VGND VGND VPWR VPWR g_row\[0\].g_col\[0\].pe__2222_/X sky130_fd_sc_hd__or2_2
Xg_row\[0\].g_col\[0\].pe__2153_ g_row\[0\].g_col\[0\].pe__2153_/A g_row\[0\].g_col\[0\].pe__2153_/B
+ g_row\[0\].g_col\[0\].pe__2153_/C VGND VGND VPWR VPWR g_row\[0\].g_col\[0\].pe__2153_/X
+ sky130_fd_sc_hd__and3_2
Xg_row\[0\].g_col\[0\].pe__2084_ g_row\[0\].g_col\[0\].pe__1461_/A g_row\[0\].g_col\[0\].pe__1461_/B
+ g_row\[0\].g_col\[0\].pe__1966_/Y VGND VGND VPWR VPWR g_row\[0\].g_col\[0\].pe__2085_/C
+ sky130_fd_sc_hd__a21o_2
Xg_row\[1\].g_col\[1\].pe__1944_ g_row\[1\].g_col\[1\].pe__1894_/Y g_row\[1\].g_col\[1\].pe__1895_/X
+ g_row\[1\].g_col\[1\].pe__2151_/A g_row\[1\].g_col\[1\].pe__2394_/B1 VGND VGND VPWR
+ VPWR g_row\[1\].g_col\[1\].pe__1944_/Y sky130_fd_sc_hd__a31oi_2
XTAP_TAPCELL_ROW_73_1305 VGND VPWR sky130_fd_sc_hd__tapvpwrvgnd_1
Xg_row\[1\].g_col\[0\].pe__1928_ g_row\[1\].g_col\[0\].pe__2682_/A g_row\[1\].g_col\[0\].pe__1928_/B
+ VGND VGND VPWR VPWR g_row\[1\].g_col\[0\].pe__1928_/X sky130_fd_sc_hd__and2_2
Xg_row\[1\].g_col\[1\].pe__1875_ g_row\[1\].g_col\[1\].pe__1875_/A g_row\[1\].g_col\[1\].pe__1875_/B
+ g_row\[1\].g_col\[1\].pe__1875_/C VGND VGND VPWR VPWR g_row\[1\].g_col\[1\].pe__1875_/X
+ sky130_fd_sc_hd__and3_2
Xg_row\[1\].g_col\[0\].pe__1859_ g_row\[1\].g_col\[0\].pe__1859_/A g_row\[1\].g_col\[0\].pe__1859_/B
+ VGND VGND VPWR VPWR g_row\[1\].g_col\[0\].pe__1860_/B sky130_fd_sc_hd__xor2_2
Xhold3026 hold3026/A VGND VGND VPWR VPWR hold3026/X sky130_fd_sc_hd__clkbuf_2
XFILLER_69_430 VGND VGND VPWR VPWR sky130_fd_sc_hd__decap_3
Xclkbuf_4_15_0_clk clkbuf_0_clk/X VGND VGND VPWR VPWR clkload8/A sky130_fd_sc_hd__clkbuf_16
XFILLER_28_27 VGND VGND VPWR VPWR sky130_fd_sc_hd__fill_1
XFILLER_56_102 VGND VGND VPWR VPWR sky130_fd_sc_hd__decap_3
XFILLER_57_614 VGND VGND VPWR VPWR sky130_fd_sc_hd__fill_2
Xg_row\[0\].g_col\[0\].pe__1937_ g_row\[0\].g_col\[0\].pe__1882_/A g_row\[0\].g_col\[0\].pe__1882_/B
+ g_row\[0\].g_col\[0\].pe__1936_/X VGND VGND VPWR VPWR g_row\[0\].g_col\[0\].pe__1952_/A
+ sky130_fd_sc_hd__o21a_2
Xhold1602 hold2766/X VGND VGND VPWR VPWR hold2767/A sky130_fd_sc_hd__clkbuf_2
Xhold1613 hold3558/X VGND VGND VPWR VPWR hold2777/A sky130_fd_sc_hd__clkbuf_2
Xhold1624 hold3578/X VGND VGND VPWR VPWR hold3579/A sky130_fd_sc_hd__clkbuf_2
Xhold1635 hold1635/A VGND VGND VPWR VPWR _165_/A sky130_fd_sc_hd__clkbuf_2
Xg_row\[0\].g_col\[1\].pe__1953_ g_row\[0\].g_col\[1\].pe__1939_/A g_row\[0\].g_col\[1\].pe__1939_/B
+ g_row\[0\].g_col\[1\].pe__1952_/X VGND VGND VPWR VPWR g_row\[0\].g_col\[1\].pe__2013_/A
+ sky130_fd_sc_hd__a21boi_2
XFILLER_57_669 VGND VGND VPWR VPWR sky130_fd_sc_hd__decap_3
Xhold1657 hold1657/A VGND VGND VPWR VPWR hold1657/X sky130_fd_sc_hd__clkbuf_2
XFILLER_72_617 VGND VGND VPWR VPWR sky130_fd_sc_hd__fill_1
Xg_row\[0\].g_col\[0\].pe__1868_ g_row\[0\].g_col\[0\].pe__1868_/A g_row\[0\].g_col\[0\].pe__1868_/B
+ VGND VGND VPWR VPWR g_row\[0\].g_col\[0\].pe__1878_/A sky130_fd_sc_hd__xor2_2
Xg_row\[1\].g_col\[1\].pe__2427_ g_row\[1\].g_col\[1\].pe__2769_/Q g_row\[1\].g_col\[1\].pe__2427_/B
+ VGND VGND VPWR VPWR g_row\[1\].g_col\[1\].pe__2494_/A sky130_fd_sc_hd__and2b_2
Xg_row\[0\].g_col\[1\].pe__1884_ g_row\[0\].g_col\[1\].pe__1633_/A g_row\[0\].g_col\[1\].pe__1633_/B
+ g_row\[0\].g_col\[1\].pe__1883_/X VGND VGND VPWR VPWR g_row\[0\].g_col\[1\].pe__1896_/A
+ sky130_fd_sc_hd__o21a_2
XFILLER_37_371 VGND VGND VPWR VPWR sky130_fd_sc_hd__decap_3
XFILLER_37_382 VGND VGND VPWR VPWR sky130_fd_sc_hd__decap_3
Xg_row\[0\].g_col\[0\].pe__1799_ g_row\[0\].g_col\[0\].pe__1804_/A place1218/X place1220/X
+ g_row\[0\].g_col\[0\].pe__1804_/B VGND VGND VPWR VPWR g_row\[0\].g_col\[0\].pe__1800_/B
+ sky130_fd_sc_hd__a22o_2
Xg_row\[1\].g_col\[1\].pe__2358_ g_row\[1\].g_col\[1\].pe__2358_/A g_row\[1\].g_col\[1\].pe__2358_/B
+ VGND VGND VPWR VPWR g_row\[1\].g_col\[1\].pe__2359_/B sky130_fd_sc_hd__nand2_2
XFILLER_25_555 VGND VGND VPWR VPWR sky130_fd_sc_hd__decap_3
XFILLER_80_650 VGND VGND VPWR VPWR sky130_fd_sc_hd__decap_3
XTAP_TAPCELL_ROW_84_1467 VGND VPWR sky130_fd_sc_hd__tapvpwrvgnd_1
Xg_row\[1\].g_col\[1\].pe__2289_ g_row\[1\].g_col\[1\].pe__2246_/A g_row\[1\].g_col\[1\].pe__2246_/B
+ g_row\[1\].g_col\[1\].pe__2288_/Y VGND VGND VPWR VPWR g_row\[1\].g_col\[1\].pe__2291_/B
+ sky130_fd_sc_hd__o21ai_2
Xg_row\[0\].g_col\[1\].pe__2505_ g_row\[0\].g_col\[1\].pe__2505_/A g_row\[0\].g_col\[1\].pe__2504_/X
+ VGND VGND VPWR VPWR g_row\[0\].g_col\[1\].pe__2505_/X sky130_fd_sc_hd__or2b_2
Xg_row\[0\].g_col\[1\].pe__2436_ g_row\[0\].g_col\[1\].pe__2436_/A g_row\[0\].g_col\[1\].pe__2436_/B
+ VGND VGND VPWR VPWR g_row\[0\].g_col\[1\].pe__2438_/B sky130_fd_sc_hd__xnor2_2
Xg_row\[0\].g_col\[0\].pe_place1227 g_row\[0\].g_col\[0\].pe__2633_/B1 VGND VGND VPWR
+ VPWR g_row\[0\].g_col\[0\].pe__2640_/C1 sky130_fd_sc_hd__buf_6
Xg_row\[0\].g_col\[1\].pe__2367_ g_row\[0\].g_col\[1\].pe__2343_/A g_row\[0\].g_col\[1\].pe__2365_/X
+ g_row\[0\].g_col\[1\].pe__2366_/X VGND VGND VPWR VPWR g_row\[0\].g_col\[1\].pe__2367_/X
+ sky130_fd_sc_hd__a21bo_2
Xg_row\[0\].g_col\[1\].pe__2298_ g_row\[0\].g_col\[1\].pe__2298_/A g_row\[0\].g_col\[1\].pe__2263_/X
+ VGND VGND VPWR VPWR g_row\[0\].g_col\[1\].pe__2299_/B sky130_fd_sc_hd__or2b_2
Xg_row\[1\].g_col\[1\].pe_hold2823 g_row\[1\].g_col\[1\].pe__2649_/X VGND VGND VPWR
+ VPWR g_row\[1\].g_col\[1\].pe__2650_/C1 sky130_fd_sc_hd__clkbuf_2
Xg_row\[1\].g_col\[1\].pe_hold2845 g_row\[1\].g_col\[1\].pe_hold2845/A VGND VGND VPWR
+ VPWR g_row\[1\].g_col\[1\].pe__2712_/D sky130_fd_sc_hd__clkbuf_2
Xg_row\[1\].g_col\[1\].pe_hold2867 g_row\[1\].g_col\[1\].pe__2662_/X VGND VGND VPWR
+ VPWR g_row\[1\].g_col\[1\].pe_hold2867/X sky130_fd_sc_hd__clkbuf_2
Xhold3560 hold3560/A VGND VGND VPWR VPWR hold3560/X sky130_fd_sc_hd__clkbuf_2
XFILLER_0_676 VGND VGND VPWR VPWR sky130_fd_sc_hd__decap_3
XFILLER_0_698 VGND VGND VPWR VPWR sky130_fd_sc_hd__fill_2
XFILLER_48_636 VGND VGND VPWR VPWR sky130_fd_sc_hd__decap_3
XFILLER_75_411 VGND VGND VPWR VPWR sky130_fd_sc_hd__decap_3
Xhold3593 hold3593/A VGND VGND VPWR VPWR hold3593/X sky130_fd_sc_hd__clkbuf_2
Xhold3582 hold3582/A VGND VGND VPWR VPWR hold3582/X sky130_fd_sc_hd__clkbuf_2
Xhold3571 a_inputs_flat[30] VGND VGND VPWR VPWR hold3571/X sky130_fd_sc_hd__clkbuf_2
XFILLER_48_669 VGND VGND VPWR VPWR sky130_fd_sc_hd__decap_3
XFILLER_63_617 VGND VGND VPWR VPWR sky130_fd_sc_hd__fill_2
XFILLER_16_533 VGND VGND VPWR VPWR sky130_fd_sc_hd__decap_3
XFILLER_90_425 VGND VGND VPWR VPWR sky130_fd_sc_hd__fill_2
XFILLER_31_569 VGND VGND VPWR VPWR sky130_fd_sc_hd__fill_2
XTAP_TAPCELL_ROW_26_594 VGND VPWR sky130_fd_sc_hd__tapvpwrvgnd_1
Xg_row\[0\].g_col\[1\].pe_place1150 g_row\[0\].g_col\[1\].pe__2697_/Q VGND VGND VPWR
+ VPWR g_row\[0\].g_col\[1\].pe__1704_/A2 sky130_fd_sc_hd__buf_6
XFILLER_11_271 VGND VGND VPWR VPWR sky130_fd_sc_hd__decap_3
XFILLER_11_293 VGND VGND VPWR VPWR sky130_fd_sc_hd__fill_2
Xg_row\[0\].g_col\[1\].pe_place1172 g_row\[0\].g_col\[1\].pe__2656_/B1 VGND VGND VPWR
+ VPWR g_row\[0\].g_col\[1\].pe__2677_/B1 sky130_fd_sc_hd__buf_6
Xg_row\[0\].g_col\[1\].pe_place1161 g_row\[0\].g_col\[1\].pe__2691_/Q VGND VGND VPWR
+ VPWR g_row\[0\].g_col\[1\].pe__2603_/B sky130_fd_sc_hd__buf_6
Xg_row\[1\].g_col\[0\].pe__2762_ clkbuf_leaf_57_clk/X g_row\[1\].g_col\[0\].pe__2762_/D
+ VGND VGND VPWR VPWR g_row\[1\].g_col\[0\].pe__2762_/Q sky130_fd_sc_hd__dfxtp_2
Xg_row\[1\].g_col\[0\].pe__2693_ clkbuf_leaf_67_clk/X g_row\[1\].g_col\[0\].pe__2693_/D
+ VGND VGND VPWR VPWR place1100/A sky130_fd_sc_hd__dfxtp_2
Xg_row\[1\].g_col\[0\].pe__1713_ g_row\[1\].g_col\[0\].pe__1713_/A g_row\[1\].g_col\[0\].pe__1713_/B
+ VGND VGND VPWR VPWR g_row\[1\].g_col\[0\].pe__1714_/C sky130_fd_sc_hd__xnor2_2
XTAP_TAPCELL_ROW_55_1035 VGND VPWR sky130_fd_sc_hd__tapvpwrvgnd_1
Xg_row\[1\].g_col\[1\].pe__1660_ g_row\[1\].g_col\[1\].pe__1660_/A g_row\[1\].g_col\[1\].pe__1660_/B
+ VGND VGND VPWR VPWR g_row\[1\].g_col\[1\].pe__1660_/Y sky130_fd_sc_hd__nor2_2
Xg_row\[1\].g_col\[0\].pe__1644_ g_row\[1\].g_col\[0\].pe__1730_/A g_row\[1\].g_col\[0\].pe__1644_/B
+ VGND VGND VPWR VPWR g_row\[1\].g_col\[0\].pe__1648_/B sky130_fd_sc_hd__xor2_2
Xg_row\[1\].g_col\[1\].pe__1591_ g_row\[1\].g_col\[1\].pe__1591_/A g_row\[1\].g_col\[1\].pe__1591_/B
+ VGND VGND VPWR VPWR g_row\[1\].g_col\[1\].pe__1830_/C sky130_fd_sc_hd__xnor2_2
XFILLER_22_3 VGND VGND VPWR VPWR sky130_fd_sc_hd__decap_3
XFILLER_79_783 VGND VGND VPWR VPWR sky130_fd_sc_hd__fill_1
Xg_row\[1\].g_col\[0\].pe__1575_ g_row\[1\].g_col\[0\].pe__1870_/A g_row\[1\].g_col\[0\].pe__1575_/B
+ VGND VGND VPWR VPWR g_row\[1\].g_col\[0\].pe__1626_/B sky130_fd_sc_hd__xor2_2
Xg_row\[0\].g_col\[0\].pe__2771_ _323_/CLK g_row\[0\].g_col\[0\].pe__2771_/D VGND
+ VGND VPWR VPWR g_row\[0\].g_col\[0\].pe__2771_/Q sky130_fd_sc_hd__dfxtp_2
Xg_row\[1\].g_col\[0\].pe_hold1833 g_row\[1\].g_col\[0\].pe__1836_/X VGND VGND VPWR
+ VPWR g_row\[1\].g_col\[0\].pe__2739_/D sky130_fd_sc_hd__clkbuf_2
Xg_row\[1\].g_col\[0\].pe_hold1822 g_row\[1\].g_col\[0\].pe__2759_/Q VGND VGND VPWR
+ VPWR g_row\[1\].g_col\[0\].pe__2535_/A1 sky130_fd_sc_hd__clkbuf_2
XFILLER_66_466 VGND VGND VPWR VPWR sky130_fd_sc_hd__fill_1
Xg_row\[0\].g_col\[0\].pe__1722_ g_row\[0\].g_col\[0\].pe__1722_/A g_row\[0\].g_col\[0\].pe__1722_/B
+ VGND VGND VPWR VPWR g_row\[0\].g_col\[0\].pe__1723_/B sky130_fd_sc_hd__xnor2_2
Xg_row\[1\].g_col\[0\].pe_hold1888 g_row\[1\].g_col\[0\].pe_hold2852/X VGND VGND VPWR
+ VPWR g_row\[1\].g_col\[0\].pe_hold2853/A sky130_fd_sc_hd__clkbuf_2
Xg_row\[1\].g_col\[0\].pe_hold1877 g_row\[1\].g_col\[0\].pe__1389_/X VGND VGND VPWR
+ VPWR g_row\[1\].g_col\[0\].pe__1391_/B1 sky130_fd_sc_hd__clkbuf_2
Xg_row\[1\].g_col\[0\].pe_hold1866 g_row\[1\].g_col\[0\].pe_hold2959/X VGND VGND VPWR
+ VPWR g_row\[1\].g_col\[0\].pe_hold2960/A sky130_fd_sc_hd__clkbuf_2
XFILLER_19_393 VGND VGND VPWR VPWR sky130_fd_sc_hd__decap_3
Xg_row\[0\].g_col\[0\].pe__1653_ g_row\[0\].g_col\[0\].pe__1816_/A g_row\[0\].g_col\[0\].pe__1653_/B
+ VGND VGND VPWR VPWR g_row\[0\].g_col\[0\].pe__1656_/A sky130_fd_sc_hd__xor2_2
Xg_row\[1\].g_col\[1\].pe__2212_ g_row\[1\].g_col\[1\].pe__2253_/A g_row\[1\].g_col\[1\].pe__2253_/B
+ VGND VGND VPWR VPWR g_row\[1\].g_col\[1\].pe__2221_/A sky130_fd_sc_hd__xnor2_2
Xg_row\[1\].g_col\[0\].pe_hold1899 g_row\[1\].g_col\[0\].pe__1392_/X VGND VGND VPWR
+ VPWR g_row\[1\].g_col\[0\].pe__1393_/B1 sky130_fd_sc_hd__clkbuf_2
Xg_row\[1\].g_col\[1\].pe__2143_ g_row\[1\].g_col\[1\].pe__2143_/A g_row\[1\].g_col\[1\].pe__2143_/B
+ VGND VGND VPWR VPWR g_row\[1\].g_col\[1\].pe__2144_/B sky130_fd_sc_hd__xnor2_2
XFILLER_61_160 VGND VGND VPWR VPWR sky130_fd_sc_hd__fill_1
XTAP_TAPCELL_ROW_45_881 VGND VPWR sky130_fd_sc_hd__tapvpwrvgnd_1
Xg_row\[0\].g_col\[0\].pe__1584_ g_row\[0\].g_col\[0\].pe__1584_/A g_row\[0\].g_col\[0\].pe__1584_/B
+ VGND VGND VPWR VPWR g_row\[0\].g_col\[0\].pe__1584_/Y sky130_fd_sc_hd__nor2_2
Xg_row\[1\].g_col\[0\].pe__2127_ g_row\[1\].g_col\[0\].pe__2128_/B g_row\[1\].g_col\[0\].pe__2128_/C
+ g_row\[1\].g_col\[0\].pe__2128_/A VGND VGND VPWR VPWR g_row\[1\].g_col\[0\].pe__2129_/A
+ sky130_fd_sc_hd__a21oi_2
XFILLER_14_29 VGND VGND VPWR VPWR sky130_fd_sc_hd__decap_3
XFILLER_22_558 VGND VGND VPWR VPWR sky130_fd_sc_hd__decap_3
XTAP_TAPCELL_ROW_45_892 VGND VPWR sky130_fd_sc_hd__tapvpwrvgnd_1
XTAP_TAPCELL_ROW_66_1197 VGND VPWR sky130_fd_sc_hd__tapvpwrvgnd_1
Xg_row\[1\].g_col\[1\].pe__2074_ g_row\[1\].g_col\[1\].pe__2215_/B2 g_row\[1\].g_col\[1\].pe__2313_/A2
+ g_row\[1\].g_col\[1\].pe__2313_/B1 g_row\[1\].g_col\[1\].pe__2177_/B2 VGND VGND
+ VPWR VPWR g_row\[1\].g_col\[1\].pe__2075_/B sky130_fd_sc_hd__a22o_2
Xg_row\[1\].g_col\[0\].pe__2058_ g_row\[1\].g_col\[0\].pe__2058_/A g_row\[1\].g_col\[0\].pe__2058_/B
+ VGND VGND VPWR VPWR g_row\[1\].g_col\[0\].pe__2067_/A sky130_fd_sc_hd__xnor2_2
Xg_row\[0\].g_col\[1\].pe__2221_ g_row\[0\].g_col\[1\].pe__2221_/A g_row\[0\].g_col\[1\].pe__2221_/B
+ VGND VGND VPWR VPWR g_row\[0\].g_col\[1\].pe__2258_/A sky130_fd_sc_hd__xor2_2
Xg_row\[0\].g_col\[0\].pe__2205_ g_row\[0\].g_col\[0\].pe__2388_/A g_row\[0\].g_col\[0\].pe__2204_/Y
+ g_row\[0\].g_col\[0\].pe__1460_/B g_row\[0\].g_col\[0\].pe__1912_/A VGND VGND VPWR
+ VPWR g_row\[0\].g_col\[0\].pe__2207_/A sky130_fd_sc_hd__a211o_2
Xg_row\[0\].g_col\[0\].pe__2136_ g_row\[0\].g_col\[0\].pe__2136_/A g_row\[0\].g_col\[0\].pe__2136_/B
+ VGND VGND VPWR VPWR g_row\[0\].g_col\[0\].pe__2143_/A sky130_fd_sc_hd__and2_2
Xg_row\[0\].g_col\[1\].pe__2152_ g_row\[0\].g_col\[1\].pe__1894_/Y g_row\[0\].g_col\[1\].pe__1895_/X
+ g_row\[0\].g_col\[1\].pe__2151_/X VGND VGND VPWR VPWR g_row\[0\].g_col\[1\].pe__2155_/B
+ sky130_fd_sc_hd__a21o_2
Xg_row\[0\].g_col\[1\].pe__2083_ g_row\[0\].g_col\[1\].pe__2702_/Q g_row\[0\].g_col\[1\].pe__2163_/B
+ VGND VGND VPWR VPWR g_row\[0\].g_col\[1\].pe__2085_/B sky130_fd_sc_hd__nand2_2
Xg_row\[0\].g_col\[0\].pe__2067_ g_row\[0\].g_col\[0\].pe__2067_/A g_row\[0\].g_col\[0\].pe__2059_/A
+ VGND VGND VPWR VPWR g_row\[0\].g_col\[0\].pe__2110_/A sky130_fd_sc_hd__nor2b_2
Xg_row\[1\].g_col\[1\].pe__1927_ g_row\[1\].g_col\[1\].pe__1980_/A g_row\[1\].g_col\[1\].pe__1927_/B
+ VGND VGND VPWR VPWR g_row\[1\].g_col\[1\].pe__1994_/A sky130_fd_sc_hd__xnor2_2
Xg_row\[1\].g_col\[1\].pe__1858_ g_row\[1\].g_col\[1\].pe__1908_/A g_row\[1\].g_col\[1\].pe__1858_/B
+ VGND VGND VPWR VPWR g_row\[1\].g_col\[1\].pe__1859_/B sky130_fd_sc_hd__and2_2
XFILLER_77_709 VGND VGND VPWR VPWR sky130_fd_sc_hd__decap_3
XFILLER_89_558 VGND VGND VPWR VPWR sky130_fd_sc_hd__fill_2
Xg_row\[1\].g_col\[1\].pe__1789_ g_row\[1\].g_col\[1\].pe__2728_/Q g_row\[1\].g_col\[1\].pe__1789_/B
+ VGND VGND VPWR VPWR g_row\[1\].g_col\[1\].pe__1790_/B sky130_fd_sc_hd__or2_2
Xhold1432 hold3138/X VGND VGND VPWR VPWR hold3139/A sky130_fd_sc_hd__clkbuf_2
Xhold1443 hold2436/X VGND VGND VPWR VPWR hold2437/A sky130_fd_sc_hd__clkbuf_2
XFILLER_29_179 VGND VGND VPWR VPWR sky130_fd_sc_hd__decap_3
XFILLER_57_488 VGND VGND VPWR VPWR sky130_fd_sc_hd__decap_3
XFILLER_85_775 VGND VGND VPWR VPWR sky130_fd_sc_hd__decap_3
XTAP_TAPCELL_ROW_4_267 VGND VPWR sky130_fd_sc_hd__tapvpwrvgnd_1
XTAP_TAPCELL_ROW_86_1507 VGND VPWR sky130_fd_sc_hd__tapvpwrvgnd_1
Xhold1454 hold3191/X VGND VGND VPWR VPWR hold3192/A sky130_fd_sc_hd__clkbuf_2
Xhold1465 hold3215/X VGND VGND VPWR VPWR hold3216/A sky130_fd_sc_hd__clkbuf_2
Xhold1476 hold2490/X VGND VGND VPWR VPWR hold2491/A sky130_fd_sc_hd__clkbuf_2
Xg_row\[0\].g_col\[1\].pe__1936_ g_row\[0\].g_col\[1\].pe__1936_/A g_row\[0\].g_col\[1\].pe__1936_/B
+ VGND VGND VPWR VPWR g_row\[0\].g_col\[1\].pe__1936_/X sky130_fd_sc_hd__or2_4
Xhold1487 hold3282/X VGND VGND VPWR VPWR hold3283/A sky130_fd_sc_hd__clkbuf_2
Xhold1498 hold3271/X VGND VGND VPWR VPWR hold3272/A sky130_fd_sc_hd__clkbuf_2
Xg_row\[0\].g_col\[1\].pe__1867_ g_row\[0\].g_col\[1\].pe__2348_/A g_row\[0\].g_col\[1\].pe__1867_/B
+ VGND VGND VPWR VPWR g_row\[0\].g_col\[1\].pe__1868_/B sky130_fd_sc_hd__xnor2_2
Xg_row\[1\].g_col\[0\].pe_place848 g_row\[1\].g_col\[0\].pe__1471_/X VGND VGND VPWR
+ VPWR g_row\[1\].g_col\[0\].pe__1657_/B sky130_fd_sc_hd__buf_6
Xg_row\[0\].g_col\[1\].pe__1798_ g_row\[0\].g_col\[1\].pe__1801_/A g_row\[0\].g_col\[1\].pe__1801_/B
+ VGND VGND VPWR VPWR g_row\[0\].g_col\[1\].pe__1806_/B sky130_fd_sc_hd__nand2_2
Xg_row\[0\].g_col\[0\].pe_hold1909 g_row\[0\].g_col\[0\].pe__1407_/X VGND VGND VPWR
+ VPWR g_row\[0\].g_col\[0\].pe__1408_/B sky130_fd_sc_hd__clkbuf_2
XFILLER_71_57 VGND VGND VPWR VPWR sky130_fd_sc_hd__fill_1
XTAP_TAPCELL_ROW_23_553 VGND VPWR sky130_fd_sc_hd__tapvpwrvgnd_1
Xinput1320 hold3399/X VGND VGND VPWR VPWR hold3400/A sky130_fd_sc_hd__buf_2
Xg_row\[0\].g_col\[1\].pe__2419_ g_row\[0\].g_col\[1\].pe__2421_/A1 g_row\[0\].g_col\[1\].pe__2750_/Q
+ g_row\[0\].g_col\[1\].pe__2430_/B VGND VGND VPWR VPWR g_row\[0\].g_col\[1\].pe__2429_/B
+ sky130_fd_sc_hd__a21oi_2
Xinput1353 hold3568/X VGND VGND VPWR VPWR hold3569/A sky130_fd_sc_hd__buf_2
Xinput1342 hold3203/X VGND VGND VPWR VPWR hold3204/A sky130_fd_sc_hd__buf_2
Xinput1331 hold3168/X VGND VGND VPWR VPWR hold3169/A sky130_fd_sc_hd__buf_2
XFILLER_5_757 VGND VGND VPWR VPWR sky130_fd_sc_hd__fill_2
XFILLER_20_83 VGND VGND VPWR VPWR sky130_fd_sc_hd__fill_1
XFILLER_4_278 VGND VGND VPWR VPWR sky130_fd_sc_hd__decap_3
Xg_row\[1\].g_col\[1\].pe_hold1963 g_row\[1\].g_col\[1\].pe__1403_/X VGND VGND VPWR
+ VPWR g_row\[1\].g_col\[1\].pe__2737_/D sky130_fd_sc_hd__clkbuf_2
Xg_row\[1\].g_col\[1\].pe_hold1952 g_row\[1\].g_col\[1\].pe_hold3088/X VGND VGND VPWR
+ VPWR g_row\[1\].g_col\[1\].pe__1380_/A1 sky130_fd_sc_hd__clkbuf_2
Xg_row\[1\].g_col\[1\].pe_hold1941 g_row\[1\].g_col\[1\].pe__2610_/X VGND VGND VPWR
+ VPWR g_row\[1\].g_col\[1\].pe__2611_/C1 sky130_fd_sc_hd__clkbuf_2
Xg_row\[1\].g_col\[1\].pe_hold1985 g_row\[1\].g_col\[1\].pe__2608_/X VGND VGND VPWR
+ VPWR g_row\[1\].g_col\[1\].pe__2693_/D sky130_fd_sc_hd__clkbuf_2
XFILLER_76_742 VGND VGND VPWR VPWR sky130_fd_sc_hd__decap_3
Xhold3390 hold3390/A VGND VGND VPWR VPWR hold3390/X sky130_fd_sc_hd__clkbuf_2
Xg_row\[1\].g_col\[0\].pe__1360_ g_row\[1\].g_col\[0\].pe__2765_/Q g_row\[1\].g_col\[0\].pe__1359_/B
+ g_row\[1\].g_col\[0\].pe__2594_/B2 VGND VGND VPWR VPWR g_row\[1\].g_col\[0\].pe__1361_/B
+ sky130_fd_sc_hd__o21a_2
XFILLER_48_477 VGND VGND VPWR VPWR sky130_fd_sc_hd__decap_3
XFILLER_76_764 VGND VGND VPWR VPWR sky130_fd_sc_hd__decap_3
XFILLER_63_447 VGND VGND VPWR VPWR sky130_fd_sc_hd__fill_1
XFILLER_91_723 VGND VGND VPWR VPWR sky130_fd_sc_hd__decap_3
XFILLER_16_330 VGND VGND VPWR VPWR sky130_fd_sc_hd__decap_3
XFILLER_28_190 VGND VGND VPWR VPWR sky130_fd_sc_hd__decap_3
XFILLER_16_363 VGND VGND VPWR VPWR sky130_fd_sc_hd__fill_1
XFILLER_44_672 VGND VGND VPWR VPWR sky130_fd_sc_hd__decap_3
XTAP_TAPCELL_ROW_42_840 VGND VPWR sky130_fd_sc_hd__tapvpwrvgnd_1
XFILLER_84_5 VGND VGND VPWR VPWR sky130_fd_sc_hd__decap_3
XANTENNA_1 a_inputs_flat[16] VGND VGND VPWR VPWR sky130_fd_sc_hd__diode_2
Xg_row\[1\].g_col\[1\].pe__2761_ clkbuf_leaf_75_clk/X g_row\[1\].g_col\[1\].pe__2761_/D
+ VGND VGND VPWR VPWR g_row\[1\].g_col\[1\].pe__2761_/Q sky130_fd_sc_hd__dfxtp_2
Xg_row\[1\].g_col\[0\].pe__2745_ clkbuf_leaf_60_clk/X g_row\[1\].g_col\[0\].pe__2745_/D
+ VGND VGND VPWR VPWR g_row\[1\].g_col\[0\].pe__2745_/Q sky130_fd_sc_hd__dfxtp_2
Xg_row\[1\].g_col\[1\].pe__1712_ g_row\[1\].g_col\[1\].pe__1736_/A g_row\[1\].g_col\[1\].pe__1736_/B
+ VGND VGND VPWR VPWR g_row\[1\].g_col\[1\].pe__1714_/B sky130_fd_sc_hd__nand2_2
Xg_row\[1\].g_col\[1\].pe__2692_ clkbuf_leaf_87_clk/X g_row\[1\].g_col\[1\].pe__2692_/D
+ VGND VGND VPWR VPWR g_row\[1\].g_col\[1\].pe__2692_/Q sky130_fd_sc_hd__dfxtp_2
Xg_row\[1\].g_col\[0\].pe_hold3010 g_row\[1\].g_col\[0\].pe__2662_/X VGND VGND VPWR
+ VPWR g_row\[1\].g_col\[0\].pe_hold3010/X sky130_fd_sc_hd__clkbuf_2
Xg_row\[1\].g_col\[0\].pe__2676_ g_row\[1\].g_col\[0\].pe__2676_/A g_row\[1\].g_col\[0\].pe__2678_/B
+ VGND VGND VPWR VPWR g_row\[1\].g_col\[0\].pe__2676_/Y sky130_fd_sc_hd__nand2_2
XFILLER_67_720 VGND VGND VPWR VPWR sky130_fd_sc_hd__decap_3
Xg_row\[1\].g_col\[1\].pe_place901 g_row\[1\].g_col\[1\].pe__1398_/B VGND VGND VPWR
+ VPWR g_row\[1\].g_col\[1\].pe__1402_/B sky130_fd_sc_hd__buf_6
Xg_row\[1\].g_col\[1\].pe__1643_ g_row\[1\].g_col\[1\].pe__2614_/B g_row\[1\].g_col\[1\].pe__1729_/A2
+ g_row\[1\].g_col\[1\].pe__1729_/A3 g_row\[1\].g_col\[1\].pe__1729_/B1 g_row\[1\].g_col\[1\].pe__1704_/A2
+ VGND VGND VPWR VPWR g_row\[1\].g_col\[1\].pe__1644_/B sky130_fd_sc_hd__a32o_2
Xg_row\[1\].g_col\[0\].pe__1627_ g_row\[1\].g_col\[0\].pe__1579_/A g_row\[1\].g_col\[0\].pe__1579_/B
+ g_row\[1\].g_col\[0\].pe__1626_/X VGND VGND VPWR VPWR g_row\[1\].g_col\[0\].pe__1879_/B
+ sky130_fd_sc_hd__a21oi_2
XFILLER_67_742 VGND VGND VPWR VPWR sky130_fd_sc_hd__fill_1
Xg_row\[1\].g_col\[1\].pe__1574_ g_row\[1\].g_col\[1\].pe__2625_/B g_row\[1\].g_col\[1\].pe__1414_/X
+ g_row\[1\].g_col\[1\].pe__1415_/Y g_row\[1\].g_col\[1\].pe__1920_/A2 g_row\[1\].g_col\[1\].pe__2702_/Q
+ VGND VGND VPWR VPWR g_row\[1\].g_col\[1\].pe__1575_/B sky130_fd_sc_hd__a32o_2
Xg_row\[1\].g_col\[0\].pe_hold3098 g_row\[1\].g_col\[0\].pe__2727_/Q VGND VGND VPWR
+ VPWR g_row\[1\].g_col\[0\].pe_hold3098/X sky130_fd_sc_hd__clkbuf_2
Xg_row\[1\].g_col\[0\].pe__1558_ g_row\[1\].g_col\[0\].pe__2599_/B g_row\[1\].g_col\[0\].pe__1558_/B
+ g_row\[1\].g_col\[0\].pe__1558_/C VGND VGND VPWR VPWR g_row\[1\].g_col\[0\].pe__1607_/A
+ sky130_fd_sc_hd__nand3_2
Xg_row\[0\].g_col\[0\].pe__2754_ clkbuf_leaf_24_clk/X g_row\[0\].g_col\[0\].pe__2754_/D
+ VGND VGND VPWR VPWR g_row\[0\].g_col\[0\].pe__2754_/Q sky130_fd_sc_hd__dfxtp_2
Xg_row\[0\].g_col\[1\].pe__2770_ _274_/CLK g_row\[0\].g_col\[1\].pe__2770_/D VGND
+ VGND VPWR VPWR g_row\[0\].g_col\[1\].pe__2770_/Q sky130_fd_sc_hd__dfxtp_2
XFILLER_66_274 VGND VGND VPWR VPWR sky130_fd_sc_hd__fill_1
XFILLER_81_222 VGND VGND VPWR VPWR sky130_fd_sc_hd__fill_2
XTAP_TAPCELL_ROW_1_226 VGND VPWR sky130_fd_sc_hd__tapvpwrvgnd_1
XTAP_TAPCELL_ROW_68_1226 VGND VPWR sky130_fd_sc_hd__tapvpwrvgnd_1
XTAP_TAPCELL_ROW_68_1237 VGND VPWR sky130_fd_sc_hd__tapvpwrvgnd_1
Xg_row\[0\].g_col\[0\].pe__1705_ g_row\[0\].g_col\[0\].pe__1705_/A g_row\[0\].g_col\[0\].pe__1705_/B
+ VGND VGND VPWR VPWR g_row\[0\].g_col\[0\].pe__1709_/A sky130_fd_sc_hd__xnor2_2
Xg_row\[0\].g_col\[1\].pe__1721_ g_row\[0\].g_col\[1\].pe__1721_/A g_row\[0\].g_col\[1\].pe__1721_/B
+ VGND VGND VPWR VPWR g_row\[0\].g_col\[1\].pe__1722_/A sky130_fd_sc_hd__xnor2_2
Xg_row\[1\].g_col\[0\].pe__1489_ g_row\[1\].g_col\[0\].pe__1733_/A g_row\[1\].g_col\[0\].pe__1489_/B
+ VGND VGND VPWR VPWR g_row\[1\].g_col\[0\].pe__1490_/B sky130_fd_sc_hd__xor2_2
Xg_row\[0\].g_col\[0\].pe__2685_ g_row\[0\].g_col\[0\].pe__2685_/A1 g_row\[0\].g_col\[0\].pe__2680_/B
+ g_row\[0\].g_col\[0\].pe__2684_/X g_row\[0\].g_col\[0\].pe__2685_/C1 VGND VGND VPWR
+ VPWR g_row\[0\].g_col\[0\].pe__2685_/X sky130_fd_sc_hd__o211a_2
Xg_row\[0\].g_col\[1\].pe__1652_ g_row\[0\].g_col\[1\].pe__1761_/A2 g_row\[0\].g_col\[1\].pe__1748_/B
+ g_row\[0\].g_col\[1\].pe__1738_/B1 g_row\[0\].g_col\[1\].pe__1782_/A2 VGND VGND
+ VPWR VPWR g_row\[0\].g_col\[1\].pe__1653_/B sky130_fd_sc_hd__a22o_2
Xg_row\[0\].g_col\[0\].pe__1636_ g_row\[0\].g_col\[0\].pe__1845_/B g_row\[0\].g_col\[0\].pe__1636_/B
+ VGND VGND VPWR VPWR g_row\[0\].g_col\[0\].pe__1847_/B sky130_fd_sc_hd__xor2_2
XFILLER_34_193 VGND VGND VPWR VPWR sky130_fd_sc_hd__decap_3
XTAP_TAPCELL_ROW_81_1426 VGND VPWR sky130_fd_sc_hd__tapvpwrvgnd_1
Xg_row\[0\].g_col\[0\].pe__1567_ g_row\[0\].g_col\[0\].pe__1864_/A g_row\[0\].g_col\[0\].pe__1567_/B
+ VGND VGND VPWR VPWR g_row\[0\].g_col\[0\].pe__1596_/B sky130_fd_sc_hd__xnor2_2
Xg_row\[0\].g_col\[1\].pe__1583_ g_row\[0\].g_col\[1\].pe__1583_/A g_row\[0\].g_col\[1\].pe__1583_/B
+ VGND VGND VPWR VPWR g_row\[0\].g_col\[1\].pe__1634_/A sky130_fd_sc_hd__xnor2_2
Xg_row\[1\].g_col\[1\].pe__2126_ g_row\[1\].g_col\[1\].pe__2125_/A g_row\[1\].g_col\[1\].pe__1449_/A
+ g_row\[1\].g_col\[1\].pe__2125_/X g_row\[1\].g_col\[1\].pe__2126_/B2 VGND VGND VPWR
+ VPWR g_row\[1\].g_col\[1\].pe__2128_/A sky130_fd_sc_hd__a2bb2o_2
Xg_row\[1\].g_col\[1\].pe__2057_ g_row\[1\].g_col\[1\].pe__2068_/A g_row\[1\].g_col\[1\].pe__2068_/B
+ VGND VGND VPWR VPWR g_row\[1\].g_col\[1\].pe__2058_/B sky130_fd_sc_hd__xnor2_2
XTAP_TAPCELL_ROW_20_512 VGND VPWR sky130_fd_sc_hd__tapvpwrvgnd_1
Xg_row\[0\].g_col\[0\].pe__1498_ g_row\[0\].g_col\[0\].pe__1676_/A g_row\[0\].g_col\[0\].pe__1498_/B
+ VGND VGND VPWR VPWR g_row\[0\].g_col\[0\].pe__1499_/B sky130_fd_sc_hd__xnor2_2
Xg_row\[0\].g_col\[1\].pe__2204_ g_row\[0\].g_col\[1\].pe__2731_/Q VGND VGND VPWR
+ VPWR g_row\[0\].g_col\[1\].pe__2204_/Y sky130_fd_sc_hd__inv_2
XTAP_TAPCELL_ROW_79_1388 VGND VPWR sky130_fd_sc_hd__tapvpwrvgnd_1
XTAP_TAPCELL_ROW_79_1399 VGND VPWR sky130_fd_sc_hd__tapvpwrvgnd_1
Xg_row\[0\].g_col\[0\].pe__2119_ g_row\[0\].g_col\[0\].pe__2077_/A g_row\[0\].g_col\[0\].pe__2119_/B
+ VGND VGND VPWR VPWR g_row\[0\].g_col\[0\].pe__2119_/X sky130_fd_sc_hd__and2b_2
Xg_row\[0\].g_col\[1\].pe__2135_ g_row\[0\].g_col\[1\].pe__2135_/A g_row\[0\].g_col\[1\].pe__2135_/B
+ VGND VGND VPWR VPWR g_row\[0\].g_col\[1\].pe__2144_/A sky130_fd_sc_hd__nand2_2
XFILLER_2_738 VGND VGND VPWR VPWR sky130_fd_sc_hd__fill_1
XTAP_TAPCELL_ROW_9_348 VGND VPWR sky130_fd_sc_hd__tapvpwrvgnd_1
Xplace1250 _273_/Q VGND VGND VPWR VPWR place1250/X sky130_fd_sc_hd__buf_6
Xg_row\[0\].g_col\[1\].pe__2066_ g_row\[0\].g_col\[1\].pe__2153_/A g_row\[0\].g_col\[1\].pe__2153_/B
+ VGND VGND VPWR VPWR g_row\[0\].g_col\[1\].pe__2066_/Y sky130_fd_sc_hd__nand2_2
XTAP_TAPCELL_ROW_92_1588 VGND VPWR sky130_fd_sc_hd__tapvpwrvgnd_1
Xplace1272 hold1640/X VGND VGND VPWR VPWR hold1635/A sky130_fd_sc_hd__buf_6
Xplace1283 _271_/A VGND VGND VPWR VPWR _267_/A sky130_fd_sc_hd__buf_6
XFILLER_49_208 VGND VGND VPWR VPWR sky130_fd_sc_hd__decap_3
XFILLER_57_263 VGND VGND VPWR VPWR sky130_fd_sc_hd__fill_2
XFILLER_58_786 VGND VGND VPWR VPWR sky130_fd_sc_hd__fill_2
XFILLER_85_561 VGND VGND VPWR VPWR sky130_fd_sc_hd__decap_3
XFILLER_17_116 VGND VGND VPWR VPWR sky130_fd_sc_hd__fill_2
XFILLER_17_127 VGND VGND VPWR VPWR sky130_fd_sc_hd__decap_3
XFILLER_57_274 VGND VGND VPWR VPWR sky130_fd_sc_hd__fill_1
XFILLER_73_734 VGND VGND VPWR VPWR sky130_fd_sc_hd__decap_3
XTAP_TAPCELL_ROW_28_623 VGND VPWR sky130_fd_sc_hd__tapvpwrvgnd_1
Xg_row\[0\].g_col\[1\].pe__1919_ g_row\[0\].g_col\[1\].pe__2094_/B g_row\[0\].g_col\[1\].pe__1919_/B
+ VGND VGND VPWR VPWR g_row\[0\].g_col\[1\].pe__2043_/A sky130_fd_sc_hd__nand2_2
XFILLER_33_609 VGND VGND VPWR VPWR sky130_fd_sc_hd__fill_2
XFILLER_73_778 VGND VGND VPWR VPWR sky130_fd_sc_hd__fill_1
XTAP_TAPCELL_ROW_28_634 VGND VPWR sky130_fd_sc_hd__tapvpwrvgnd_1
XFILLER_15_83 VGND VGND VPWR VPWR sky130_fd_sc_hd__fill_2
XFILLER_41_686 VGND VGND VPWR VPWR sky130_fd_sc_hd__fill_1
Xg_row\[0\].g_col\[0\].pe_hold1717 g_row\[0\].g_col\[0\].pe__2439_/A VGND VGND VPWR
+ VPWR ANTENNA_153/DIODE sky130_fd_sc_hd__clkbuf_2
XFILLER_5_565 VGND VGND VPWR VPWR sky130_fd_sc_hd__fill_2
XFILLER_68_517 VGND VGND VPWR VPWR sky130_fd_sc_hd__fill_1
Xg_row\[1\].g_col\[1\].pe_hold1782 g_row\[1\].g_col\[1\].pe__1400_/X VGND VGND VPWR
+ VPWR g_row\[1\].g_col\[1\].pe__1401_/B1 sky130_fd_sc_hd__clkbuf_2
Xg_row\[1\].g_col\[0\].pe__2461_ g_row\[1\].g_col\[0\].pe__2757_/Q g_row\[1\].g_col\[0\].pe__2462_/B
+ VGND VGND VPWR VPWR g_row\[1\].g_col\[0\].pe__2519_/B sky130_fd_sc_hd__xnor2_2
Xg_row\[1\].g_col\[0\].pe__1412_ g_row\[1\].g_col\[0\].pe__1749_/A1 place1085/X place1087/X
+ g_row\[1\].g_col\[0\].pe__1641_/B2 VGND VGND VPWR VPWR g_row\[1\].g_col\[0\].pe__1413_/B
+ sky130_fd_sc_hd__a22o_2
XFILLER_49_775 VGND VGND VPWR VPWR sky130_fd_sc_hd__decap_3
XFILLER_64_701 VGND VGND VPWR VPWR sky130_fd_sc_hd__fill_1
Xg_row\[1\].g_col\[0\].pe__2392_ g_row\[1\].g_col\[0\].pe__2392_/A g_row\[1\].g_col\[0\].pe__2392_/B
+ VGND VGND VPWR VPWR g_row\[1\].g_col\[0\].pe__2392_/Y sky130_fd_sc_hd__xnor2_2
XFILLER_76_583 VGND VGND VPWR VPWR sky130_fd_sc_hd__decap_3
XTAP_TAPCELL_ROW_47_910 VGND VPWR sky130_fd_sc_hd__tapvpwrvgnd_1
XTAP_TAPCELL_ROW_47_921 VGND VPWR sky130_fd_sc_hd__tapvpwrvgnd_1
Xg_row\[1\].g_col\[0\].pe__1343_ g_row\[1\].g_col\[0\].pe__2757_/Q g_row\[1\].g_col\[0\].pe__2775_/A
+ g_row\[1\].g_col\[0\].pe__2776_/A VGND VGND VPWR VPWR g_row\[1\].g_col\[0\].pe__1344_/B
+ sky130_fd_sc_hd__o21ai_2
Xg_row\[0\].g_col\[0\].pe__2470_ g_row\[0\].g_col\[0\].pe__2551_/A g_row\[0\].g_col\[0\].pe__2551_/B
+ g_row\[0\].g_col\[0\].pe__2551_/C g_row\[0\].g_col\[0\].pe__2444_/A g_row\[0\].g_col\[0\].pe__2496_/B
+ VGND VGND VPWR VPWR g_row\[0\].g_col\[0\].pe__2471_/C sky130_fd_sc_hd__a311o_2
XFILLER_32_620 VGND VGND VPWR VPWR sky130_fd_sc_hd__decap_3
Xg_row\[0\].g_col\[0\].pe__1421_ g_row\[0\].g_col\[0\].pe__2045_/A g_row\[0\].g_col\[0\].pe__2727_/Q
+ VGND VGND VPWR VPWR g_row\[0\].g_col\[0\].pe__1982_/B sky130_fd_sc_hd__xor2_2
XTAP_TAPCELL_ROW_63_1156 VGND VPWR sky130_fd_sc_hd__tapvpwrvgnd_1
Xg_row\[0\].g_col\[0\].pe__1352_ g_row\[0\].g_col\[0\].pe__2761_/Q g_row\[0\].g_col\[0\].pe__2760_/Q
+ g_row\[0\].g_col\[0\].pe__1348_/B g_row\[0\].g_col\[0\].pe__2771_/Q VGND VGND VPWR
+ VPWR g_row\[0\].g_col\[0\].pe__1353_/B sky130_fd_sc_hd__o31a_2
Xg_row\[0\].g_col\[0\].pe_hold2963 _319_/Q VGND VGND VPWR VPWR g_row\[0\].g_col\[0\].pe_hold2963/X
+ sky130_fd_sc_hd__clkbuf_2
XTAP_TAPCELL_ROW_6_307 VGND VPWR sky130_fd_sc_hd__tapvpwrvgnd_1
Xg_row\[1\].g_col\[1\].pe__2744_ clkbuf_leaf_78_clk/X g_row\[1\].g_col\[1\].pe__2744_/D
+ VGND VGND VPWR VPWR g_row\[1\].g_col\[1\].pe__2744_/Q sky130_fd_sc_hd__dfxtp_2
Xg_row\[1\].g_col\[0\].pe__2728_ clkbuf_leaf_45_clk/X g_row\[1\].g_col\[0\].pe__2728_/D
+ VGND VGND VPWR VPWR g_row\[1\].g_col\[0\].pe__2728_/Q sky130_fd_sc_hd__dfxtp_2
Xg_row\[1\].g_col\[1\].pe__2675_ g_row\[1\].g_col\[1\].pe__2672_/X g_row\[1\].g_col\[1\].pe__2673_/X
+ g_row\[1\].g_col\[1\].pe__2674_/X hold2149/X VGND VGND VPWR VPWR g_row\[1\].g_col\[1\].pe__2678_/B
+ sky130_fd_sc_hd__o31ai_2
Xg_row\[1\].g_col\[0\].pe__2659_ g_row\[1\].g_col\[0\].pe__2663_/A g_row\[1\].g_col\[0\].pe__2659_/B
+ VGND VGND VPWR VPWR g_row\[1\].g_col\[0\].pe__2659_/X sky130_fd_sc_hd__or2_2
XFILLER_59_539 VGND VGND VPWR VPWR sky130_fd_sc_hd__fill_1
Xfanout349 hold1638/X VGND VGND VPWR VPWR hold1639/A sky130_fd_sc_hd__buf_4
Xg_row\[1\].g_col\[1\].pe__1626_ g_row\[1\].g_col\[1\].pe__1626_/A g_row\[1\].g_col\[1\].pe__1626_/B
+ VGND VGND VPWR VPWR g_row\[1\].g_col\[1\].pe__1626_/X sky130_fd_sc_hd__and2_2
Xg_row\[1\].g_col\[1\].pe__1557_ g_row\[1\].g_col\[1\].pe__1602_/A g_row\[1\].g_col\[1\].pe__1557_/B
+ VGND VGND VPWR VPWR g_row\[1\].g_col\[1\].pe__1558_/C sky130_fd_sc_hd__xnor2_2
Xg_row\[0\].g_col\[1\].pe__2753_ clkload15/A g_row\[0\].g_col\[1\].pe__2753_/D VGND
+ VGND VPWR VPWR g_row\[0\].g_col\[1\].pe__2753_/Q sky130_fd_sc_hd__dfxtp_2
XFILLER_27_447 VGND VGND VPWR VPWR sky130_fd_sc_hd__fill_1
XFILLER_82_531 VGND VGND VPWR VPWR sky130_fd_sc_hd__fill_1
Xg_row\[0\].g_col\[0\].pe__2737_ clkbuf_leaf_38_clk/X g_row\[0\].g_col\[0\].pe__2737_/D
+ VGND VGND VPWR VPWR g_row\[0\].g_col\[0\].pe__2737_/Q sky130_fd_sc_hd__dfxtp_2
Xg_row\[0\].g_col\[1\].pe__1704_ g_row\[0\].g_col\[1\].pe__1704_/A1 g_row\[0\].g_col\[1\].pe__1704_/A2
+ g_row\[0\].g_col\[1\].pe__1727_/A2 g_row\[0\].g_col\[1\].pe__1704_/B2 VGND VGND
+ VPWR VPWR g_row\[0\].g_col\[1\].pe__1705_/B sky130_fd_sc_hd__a22o_2
Xg_row\[1\].g_col\[1\].pe__1488_ g_row\[1\].g_col\[1\].pe__2215_/B2 g_row\[1\].g_col\[1\].pe__1732_/A2
+ g_row\[1\].g_col\[1\].pe__1732_/B1 g_row\[1\].g_col\[1\].pe__1704_/A2 VGND VGND
+ VPWR VPWR g_row\[1\].g_col\[1\].pe__1489_/B sky130_fd_sc_hd__a22o_2
Xg_row\[0\].g_col\[0\].pe__2668_ g_row\[0\].g_col\[0\].pe__2670_/A1 g_row\[0\].g_col\[0\].pe__2668_/A2
+ g_row\[0\].g_col\[0\].pe__2677_/B1 g_row\[0\].g_col\[0\].pe__2667_/X VGND VGND VPWR
+ VPWR g_row\[0\].g_col\[0\].pe__2668_/X sky130_fd_sc_hd__o211a_2
Xg_row\[0\].g_col\[1\].pe_hold1847 g_row\[0\].g_col\[1\].pe__2770_/Q VGND VGND VPWR
+ VPWR g_row\[0\].g_col\[1\].pe__2591_/A1 sky130_fd_sc_hd__clkbuf_2
Xg_row\[0\].g_col\[1\].pe__2684_ g_row\[0\].g_col\[1\].pe__2725_/Q g_row\[0\].g_col\[1\].pe__2686_/B
+ VGND VGND VPWR VPWR g_row\[0\].g_col\[1\].pe__2684_/X sky130_fd_sc_hd__or2_2
XFILLER_35_480 VGND VGND VPWR VPWR sky130_fd_sc_hd__decap_3
Xg_row\[0\].g_col\[0\].pe__1619_ g_row\[0\].g_col\[0\].pe__1875_/A g_row\[0\].g_col\[0\].pe__1875_/B
+ VGND VGND VPWR VPWR g_row\[0\].g_col\[0\].pe__1622_/A sky130_fd_sc_hd__nand2_2
Xg_row\[0\].g_col\[1\].pe__1635_ g_row\[0\].g_col\[1\].pe__1587_/A g_row\[0\].g_col\[1\].pe__1587_/B
+ g_row\[0\].g_col\[1\].pe__1634_/X VGND VGND VPWR VPWR g_row\[0\].g_col\[1\].pe__1636_/B
+ sky130_fd_sc_hd__o21a_2
XFILLER_22_141 VGND VGND VPWR VPWR sky130_fd_sc_hd__decap_3
XFILLER_50_450 VGND VGND VPWR VPWR sky130_fd_sc_hd__decap_3
Xg_row\[0\].g_col\[0\].pe__2599_ g_row\[0\].g_col\[0\].pe__2599_/A place1223/X VGND
+ VGND VPWR VPWR g_row\[0\].g_col\[0\].pe__2599_/X sky130_fd_sc_hd__or2_2
Xg_row\[0\].g_col\[1\].pe__1566_ g_row\[0\].g_col\[1\].pe__2138_/B2 g_row\[0\].g_col\[1\].pe__1715_/B
+ g_row\[0\].g_col\[1\].pe__1863_/B1 g_row\[0\].g_col\[1\].pe__2073_/B2 VGND VGND
+ VPWR VPWR g_row\[0\].g_col\[1\].pe__1567_/B sky130_fd_sc_hd__a22o_2
Xg_row\[1\].g_col\[1\].pe__2109_ g_row\[1\].g_col\[1\].pe__2110_/A g_row\[1\].g_col\[1\].pe__2110_/B
+ VGND VGND VPWR VPWR g_row\[1\].g_col\[1\].pe__2111_/A sky130_fd_sc_hd__and2_4
XFILLER_11_837 VGND VGND VPWR VPWR sky130_fd_sc_hd__decap_3
Xg_row\[0\].g_col\[1\].pe__1497_ g_row\[0\].g_col\[1\].pe__2605_/B g_row\[0\].g_col\[1\].pe__1657_/B
+ g_row\[0\].g_col\[1\].pe__2247_/B1 g_row\[0\].g_col\[1\].pe__2603_/B VGND VGND VPWR
+ VPWR g_row\[0\].g_col\[1\].pe__1498_/B sky130_fd_sc_hd__a22o_2
Xg_row\[0\].g_col\[1\].pe__2118_ g_row\[0\].g_col\[1\].pe__2107_/A g_row\[0\].g_col\[1\].pe__2105_/X
+ g_row\[0\].g_col\[1\].pe__2106_/A VGND VGND VPWR VPWR g_row\[0\].g_col\[1\].pe__2148_/A
+ sky130_fd_sc_hd__a21oi_2
Xplace1080 hold1986/X VGND VGND VPWR VPWR place1080/X sky130_fd_sc_hd__buf_6
Xg_row\[0\].g_col\[1\].pe__2049_ g_row\[0\].g_col\[1\].pe__2048_/A g_row\[0\].g_col\[1\].pe__2048_/B
+ g_row\[0\].g_col\[1\].pe__2048_/C VGND VGND VPWR VPWR g_row\[0\].g_col\[1\].pe__2049_/X
+ sky130_fd_sc_hd__a21o_2
XFILLER_46_789 VGND VGND VPWR VPWR sky130_fd_sc_hd__fill_2
XFILLER_61_726 VGND VGND VPWR VPWR sky130_fd_sc_hd__fill_2
XFILLER_14_620 VGND VGND VPWR VPWR sky130_fd_sc_hd__fill_1
XFILLER_26_82 VGND VGND VPWR VPWR sky130_fd_sc_hd__fill_2
XFILLER_73_597 VGND VGND VPWR VPWR sky130_fd_sc_hd__decap_3
Xg_row\[0\].g_col\[0\].pe_hold2226 g_row\[0\].g_col\[0\].pe_hold2290/X VGND VGND VPWR
+ VPWR g_row\[0\].g_col\[0\].pe__1383_/A sky130_fd_sc_hd__clkbuf_2
Xg_row\[0\].g_col\[0\].pe_hold2237 g_row\[0\].g_col\[0\].pe__2683_/X VGND VGND VPWR
+ VPWR g_row\[0\].g_col\[0\].pe__2724_/D sky130_fd_sc_hd__clkbuf_2
Xg_row\[0\].g_col\[1\].pe_place818 g_row\[0\].g_col\[1\].pe__2517_/Y VGND VGND VPWR
+ VPWR g_row\[0\].g_col\[1\].pe__2591_/B1 sky130_fd_sc_hd__buf_6
XFILLER_14_686 VGND VGND VPWR VPWR sky130_fd_sc_hd__decap_3
XTAP_TAPCELL_ROW_52_990 VGND VPWR sky130_fd_sc_hd__tapvpwrvgnd_1
X_297_ _300_/CLK _297_/D VGND VGND VPWR VPWR _297_/Q sky130_fd_sc_hd__dfxtp_2
Xg_row\[1\].g_col\[0\].pe__1961_ g_row\[1\].g_col\[0\].pe__1961_/A g_row\[1\].g_col\[0\].pe__1961_/B
+ VGND VGND VPWR VPWR g_row\[1\].g_col\[0\].pe__1962_/B sky130_fd_sc_hd__or2_2
XFILLER_6_841 VGND VGND VPWR VPWR sky130_fd_sc_hd__fill_1
XTAP_TAPCELL_ROW_11_375 VGND VPWR sky130_fd_sc_hd__tapvpwrvgnd_1
Xg_row\[1\].g_col\[0\].pe__1892_ g_row\[1\].g_col\[0\].pe__1950_/A g_row\[1\].g_col\[0\].pe_hold1924/X
+ g_row\[1\].g_col\[0\].pe__2236_/A1 g_row\[1\].g_col\[0\].pe__1891_/Y VGND VGND VPWR
+ VPWR g_row\[1\].g_col\[0\].pe__1892_/X sky130_fd_sc_hd__o2bb2a_2
XFILLER_68_303 VGND VGND VPWR VPWR sky130_fd_sc_hd__fill_1
XFILLER_69_826 VGND VGND VPWR VPWR sky130_fd_sc_hd__decap_3
Xg_row\[0\].g_col\[0\].pe__1970_ g_row\[0\].g_col\[0\].pe__1970_/A g_row\[0\].g_col\[0\].pe__2163_/B
+ VGND VGND VPWR VPWR g_row\[0\].g_col\[0\].pe__1972_/B sky130_fd_sc_hd__nand2_2
Xg_row\[1\].g_col\[0\].pe__2513_ g_row\[1\].g_col\[0\].pe__2513_/A1 g_row\[1\].g_col\[0\].pe__2560_/A2
+ g_row\[1\].g_col\[0\].pe__2512_/X VGND VGND VPWR VPWR g_row\[1\].g_col\[0\].pe__2513_/Y
+ sky130_fd_sc_hd__a21oi_2
XFILLER_3_64 VGND VGND VPWR VPWR sky130_fd_sc_hd__fill_1
Xg_row\[1\].g_col\[1\].pe__2460_ g_row\[1\].g_col\[1\].pe__2740_/Q g_row\[1\].g_col\[1\].pe__2460_/B
+ VGND VGND VPWR VPWR g_row\[1\].g_col\[1\].pe__2462_/B sky130_fd_sc_hd__xnor2_2
XFILLER_37_701 VGND VGND VPWR VPWR sky130_fd_sc_hd__fill_2
Xg_row\[1\].g_col\[1\].pe__1411_ g_row\[1\].g_col\[1\].pe__1928_/A VGND VGND VPWR
+ VPWR g_row\[1\].g_col\[1\].pe__1808_/A sky130_fd_sc_hd__inv_4
Xg_row\[1\].g_col\[0\].pe__2444_ g_row\[1\].g_col\[0\].pe__2444_/A g_row\[1\].g_col\[0\].pe__2444_/B
+ VGND VGND VPWR VPWR g_row\[1\].g_col\[0\].pe__2551_/A sky130_fd_sc_hd__nor2_2
XFILLER_36_200 VGND VGND VPWR VPWR sky130_fd_sc_hd__decap_3
XFILLER_37_734 VGND VGND VPWR VPWR sky130_fd_sc_hd__fill_1
XFILLER_49_572 VGND VGND VPWR VPWR sky130_fd_sc_hd__fill_1
Xg_row\[1\].g_col\[1\].pe__2391_ g_row\[1\].g_col\[1\].pe__2391_/A g_row\[1\].g_col\[1\].pe__2391_/B
+ VGND VGND VPWR VPWR g_row\[1\].g_col\[1\].pe__2392_/B sky130_fd_sc_hd__xor2_2
Xg_row\[1\].g_col\[0\].pe__2375_ g_row\[1\].g_col\[0\].pe__2375_/A g_row\[1\].g_col\[0\].pe__2375_/B
+ VGND VGND VPWR VPWR g_row\[1\].g_col\[0\].pe__2377_/B sky130_fd_sc_hd__xor2_2
Xg_row\[1\].g_col\[1\].pe__1342_ g_row\[1\].g_col\[1\].pe__2757_/Q g_row\[1\].g_col\[1\].pe__1342_/B
+ VGND VGND VPWR VPWR output1398/A sky130_fd_sc_hd__xnor2_2
Xg_row\[0\].g_col\[0\].pe__2522_ g_row\[0\].g_col\[0\].pe__2595_/A g_row\[0\].g_col\[0\].pe__2522_/B
+ VGND VGND VPWR VPWR g_row\[0\].g_col\[0\].pe__2757_/D sky130_fd_sc_hd__and2_2
XFILLER_52_737 VGND VGND VPWR VPWR sky130_fd_sc_hd__fill_2
XFILLER_91_383 VGND VGND VPWR VPWR sky130_fd_sc_hd__fill_2
XTAP_TAPCELL_ROW_19_497 VGND VPWR sky130_fd_sc_hd__tapvpwrvgnd_1
Xg_row\[0\].g_col\[0\].pe__2453_ g_row\[0\].g_col\[0\].pe__2742_/Q g_row\[0\].g_col\[0\].pe__2453_/B
+ VGND VGND VPWR VPWR g_row\[0\].g_col\[0\].pe__2464_/B sky130_fd_sc_hd__xnor2_2
Xg_row\[0\].g_col\[0\].pe__1404_ place1263/X VGND VGND VPWR VPWR g_row\[0\].g_col\[0\].pe__1838_/A
+ sky130_fd_sc_hd__inv_2
Xg_row\[0\].g_col\[1\].pe__1420_ g_row\[0\].g_col\[1\].pe__1428_/A g_row\[0\].g_col\[1\].pe__1428_/B
+ VGND VGND VPWR VPWR g_row\[0\].g_col\[1\].pe__1650_/A sky130_fd_sc_hd__xor2_2
XFILLER_32_461 VGND VGND VPWR VPWR sky130_fd_sc_hd__fill_1
Xg_row\[0\].g_col\[0\].pe__2384_ g_row\[0\].g_col\[0\].pe__2375_/A g_row\[0\].g_col\[0\].pe__2356_/A
+ g_row\[0\].g_col\[0\].pe__2375_/B VGND VGND VPWR VPWR g_row\[0\].g_col\[0\].pe__2384_/Y
+ sky130_fd_sc_hd__o21ai_2
XFILLER_22_29 VGND VGND VPWR VPWR sky130_fd_sc_hd__fill_2
Xg_row\[0\].g_col\[1\].pe__1351_ g_row\[0\].g_col\[1\].pe__2761_/Q g_row\[0\].g_col\[1\].pe__1351_/B
+ VGND VGND VPWR VPWR output1368/A sky130_fd_sc_hd__xnor2_2
XTAP_TAPCELL_ROW_30_662 VGND VPWR sky130_fd_sc_hd__tapvpwrvgnd_1
XTAP_TAPCELL_ROW_76_1347 VGND VPWR sky130_fd_sc_hd__tapvpwrvgnd_1
XFILLER_87_612 VGND VGND VPWR VPWR sky130_fd_sc_hd__decap_3
Xg_row\[1\].g_col\[1\].pe__2727_ clkbuf_leaf_82_clk/X g_row\[1\].g_col\[1\].pe__2727_/D
+ VGND VGND VPWR VPWR g_row\[1\].g_col\[1\].pe__2727_/Q sky130_fd_sc_hd__dfxtp_2
XFILLER_59_369 VGND VGND VPWR VPWR sky130_fd_sc_hd__fill_1
XFILLER_87_689 VGND VGND VPWR VPWR sky130_fd_sc_hd__fill_2
Xg_row\[1\].g_col\[1\].pe__2658_ g_row\[1\].g_col\[1\].pe__2670_/A1 hold2097/X g_row\[1\].g_col\[1\].pe__2670_/B1
+ g_row\[1\].g_col\[1\].pe__2658_/C1 VGND VGND VPWR VPWR g_row\[1\].g_col\[1\].pe__2658_/X
+ sky130_fd_sc_hd__o211a_2
XFILLER_28_701 VGND VGND VPWR VPWR sky130_fd_sc_hd__fill_2
Xg_row\[1\].g_col\[1\].pe__1609_ g_row\[1\].g_col\[1\].pe__2167_/A g_row\[1\].g_col\[1\].pe__1609_/B
+ VGND VGND VPWR VPWR g_row\[1\].g_col\[1\].pe__1851_/A sky130_fd_sc_hd__xor2_2
XFILLER_28_745 VGND VGND VPWR VPWR sky130_fd_sc_hd__fill_2
XFILLER_67_391 VGND VGND VPWR VPWR sky130_fd_sc_hd__fill_1
Xg_row\[0\].g_col\[1\].pe_hold2345 g_row\[0\].g_col\[1\].pe_hold3005/X VGND VGND VPWR
+ VPWR g_row\[0\].g_col\[1\].pe_hold3006/A sky130_fd_sc_hd__clkbuf_2
Xg_row\[0\].g_col\[1\].pe_hold2334 g_row\[0\].g_col\[1\].pe__2752_/Q VGND VGND VPWR
+ VPWR g_row\[0\].g_col\[1\].pe__2380_/B1 sky130_fd_sc_hd__clkbuf_2
XFILLER_55_564 VGND VGND VPWR VPWR sky130_fd_sc_hd__decap_3
XTAP_TAPCELL_ROW_38_773 VGND VPWR sky130_fd_sc_hd__tapvpwrvgnd_1
Xg_row\[0\].g_col\[1\].pe_hold2378 g_row\[0\].g_col\[1\].pe__2748_/Q VGND VGND VPWR
+ VPWR g_row\[0\].g_col\[1\].pe__2266_/A sky130_fd_sc_hd__clkbuf_2
Xg_row\[0\].g_col\[1\].pe_hold2356 g_row\[0\].g_col\[1\].pe__2633_/X VGND VGND VPWR
+ VPWR g_row\[0\].g_col\[1\].pe__2704_/D sky130_fd_sc_hd__clkbuf_2
Xg_row\[0\].g_col\[1\].pe__2736_ clkbuf_leaf_91_clk/X g_row\[0\].g_col\[1\].pe__2736_/D
+ VGND VGND VPWR VPWR g_row\[0\].g_col\[1\].pe__2736_/Q sky130_fd_sc_hd__dfxtp_2
XTAP_TAPCELL_ROW_38_784 VGND VPWR sky130_fd_sc_hd__tapvpwrvgnd_1
Xg_row\[0\].g_col\[1\].pe_hold2389 g_row\[0\].g_col\[1\].pe__1950_/Y VGND VGND VPWR
+ VPWR g_row\[0\].g_col\[1\].pe__2011_/A1 sky130_fd_sc_hd__clkbuf_2
Xg_row\[0\].g_col\[1\].pe__2667_ place1239/X hold1781/X VGND VGND VPWR VPWR g_row\[0\].g_col\[1\].pe__2667_/X
+ sky130_fd_sc_hd__or2_2
XFILLER_70_578 VGND VGND VPWR VPWR sky130_fd_sc_hd__decap_3
Xg_row\[0\].g_col\[1\].pe__1618_ g_row\[0\].g_col\[1\].pe__1808_/A g_row\[0\].g_col\[1\].pe__2125_/A
+ g_row\[0\].g_col\[1\].pe__1727_/B2 VGND VGND VPWR VPWR g_row\[0\].g_col\[1\].pe__1875_/B
+ sky130_fd_sc_hd__or3b_2
XFILLER_11_645 VGND VGND VPWR VPWR sky130_fd_sc_hd__decap_3
X_151_ _173_/A _151_/B_N VGND VGND VPWR VPWR _151_/Y sky130_fd_sc_hd__nor2b_4
Xg_row\[0\].g_col\[1\].pe__1549_ g_row\[0\].g_col\[1\].pe__2599_/B g_row\[0\].g_col\[1\].pe__1549_/B
+ g_row\[0\].g_col\[1\].pe__1549_/C VGND VGND VPWR VPWR g_row\[0\].g_col\[1\].pe__1669_/A
+ sky130_fd_sc_hd__and3_2
XFILLER_2_365 VGND VGND VPWR VPWR sky130_fd_sc_hd__decap_3
Xg_row\[1\].g_col\[0\].pe_hold2919 g_row\[1\].g_col\[0\].pe_hold2919/A VGND VGND VPWR
+ VPWR g_row\[1\].g_col\[0\].pe__2604_/A2 sky130_fd_sc_hd__clkbuf_2
XFILLER_78_656 VGND VGND VPWR VPWR sky130_fd_sc_hd__decap_3
XFILLER_77_188 VGND VGND VPWR VPWR sky130_fd_sc_hd__fill_1
XFILLER_19_734 VGND VGND VPWR VPWR sky130_fd_sc_hd__fill_2
XFILLER_74_840 VGND VGND VPWR VPWR sky130_fd_sc_hd__fill_2
Xg_row\[1\].g_col\[0\].pe__2160_ g_row\[1\].g_col\[0\].pe__2160_/A VGND VGND VPWR
+ VPWR g_row\[1\].g_col\[0\].pe__2439_/A sky130_fd_sc_hd__inv_2
XFILLER_33_225 VGND VGND VPWR VPWR sky130_fd_sc_hd__decap_3
XFILLER_61_534 VGND VGND VPWR VPWR sky130_fd_sc_hd__fill_2
Xg_row\[1\].g_col\[0\].pe__2091_ g_row\[1\].g_col\[0\].pe__2091_/A g_row\[1\].g_col\[0\].pe__2091_/B
+ g_row\[1\].g_col\[0\].pe__2091_/C VGND VGND VPWR VPWR g_row\[1\].g_col\[0\].pe__2097_/B
+ sky130_fd_sc_hd__and3_4
XFILLER_61_567 VGND VGND VPWR VPWR sky130_fd_sc_hd__fill_1
XFILLER_61_578 VGND VGND VPWR VPWR sky130_fd_sc_hd__decap_3
XTAP_TAPCELL_ROW_16_445 VGND VPWR sky130_fd_sc_hd__tapvpwrvgnd_1
XTAP_TAPCELL_ROW_16_456 VGND VPWR sky130_fd_sc_hd__tapvpwrvgnd_1
Xg_row\[0\].g_col\[0\].pe_hold2001 g_row\[0\].g_col\[0\].pe__1836_/X VGND VGND VPWR
+ VPWR g_row\[0\].g_col\[0\].pe__2739_/D sky130_fd_sc_hd__clkbuf_2
Xg_row\[0\].g_col\[0\].pe_hold2012 g_row\[0\].g_col\[0\].pe_hold2977/X VGND VGND VPWR
+ VPWR g_row\[0\].g_col\[0\].pe__2720_/D sky130_fd_sc_hd__clkbuf_2
Xg_row\[0\].g_col\[0\].pe_hold2023 g_row\[0\].g_col\[0\].pe__1391_/X VGND VGND VPWR
+ VPWR g_row\[0\].g_col\[0\].pe__2731_/D sky130_fd_sc_hd__clkbuf_2
XTAP_TAPCELL_ROW_60_1104 VGND VPWR sky130_fd_sc_hd__tapvpwrvgnd_1
XTAP_TAPCELL_ROW_60_1115 VGND VPWR sky130_fd_sc_hd__tapvpwrvgnd_1
Xg_row\[1\].g_col\[1\].pe__1960_ g_row\[1\].g_col\[1\].pe__1961_/A g_row\[1\].g_col\[1\].pe__1961_/B
+ VGND VGND VPWR VPWR g_row\[1\].g_col\[1\].pe__2024_/A sky130_fd_sc_hd__nand2_2
Xg_row\[1\].g_col\[0\].pe__1944_ g_row\[1\].g_col\[0\].pe__1894_/Y g_row\[1\].g_col\[0\].pe__1895_/X
+ g_row\[1\].g_col\[0\].pe__2151_/A g_row\[1\].g_col\[0\].pe__2236_/A1 VGND VGND VPWR
+ VPWR g_row\[1\].g_col\[0\].pe__1944_/Y sky130_fd_sc_hd__a31oi_2
XFILLER_6_671 VGND VGND VPWR VPWR sky130_fd_sc_hd__fill_1
Xg_row\[1\].g_col\[1\].pe__1891_ g_row\[1\].g_col\[1\].pe__1891_/A g_row\[1\].g_col\[1\].pe__1891_/B
+ VGND VGND VPWR VPWR g_row\[1\].g_col\[1\].pe__1891_/Y sky130_fd_sc_hd__xnor2_2
Xg_row\[1\].g_col\[0\].pe__1875_ g_row\[1\].g_col\[0\].pe__1875_/A g_row\[1\].g_col\[0\].pe__1875_/B
+ g_row\[1\].g_col\[0\].pe__1875_/C VGND VGND VPWR VPWR g_row\[1\].g_col\[0\].pe__1875_/X
+ sky130_fd_sc_hd__and3_2
XTAP_TAPCELL_ROW_58_1077 VGND VPWR sky130_fd_sc_hd__tapvpwrvgnd_1
XFILLER_69_601 VGND VGND VPWR VPWR sky130_fd_sc_hd__decap_3
Xhold3208 hold3208/A VGND VGND VPWR VPWR hold3208/X sky130_fd_sc_hd__clkbuf_2
Xhold3219 hold3219/A VGND VGND VPWR VPWR hold3219/X sky130_fd_sc_hd__clkbuf_2
Xhold2507 hold3255/X VGND VGND VPWR VPWR _257_/B_N sky130_fd_sc_hd__clkbuf_2
Xhold2518 hold3225/X VGND VGND VPWR VPWR hold3226/A sky130_fd_sc_hd__clkbuf_2
Xhold2529 hold3279/X VGND VGND VPWR VPWR hold3280/A sky130_fd_sc_hd__clkbuf_2
Xg_row\[1\].g_col\[1\].pe__2512_ g_row\[1\].g_col\[1\].pe__2519_/A g_row\[1\].g_col\[1\].pe__2499_/A
+ g_row\[1\].g_col\[1\].pe__2559_/A g_row\[1\].g_col\[1\].pe__2157_/A g_row\[1\].g_col\[1\].pe__2403_/A
+ VGND VGND VPWR VPWR g_row\[1\].g_col\[1\].pe__2512_/X sky130_fd_sc_hd__o311a_2
XFILLER_69_656 VGND VGND VPWR VPWR sky130_fd_sc_hd__decap_3
XTAP_TAPCELL_ROW_71_1277 VGND VPWR sky130_fd_sc_hd__tapvpwrvgnd_1
Xg_row\[0\].g_col\[0\].pe__1953_ g_row\[0\].g_col\[0\].pe__1939_/A g_row\[0\].g_col\[0\].pe__1939_/B
+ g_row\[0\].g_col\[0\].pe__1952_/X VGND VGND VPWR VPWR g_row\[0\].g_col\[0\].pe__2013_/A
+ sky130_fd_sc_hd__a21boi_2
Xg_row\[0\].g_col\[0\].pe__1884_ g_row\[0\].g_col\[0\].pe__1633_/A g_row\[0\].g_col\[0\].pe__1633_/B
+ g_row\[0\].g_col\[0\].pe__1883_/X VGND VGND VPWR VPWR g_row\[0\].g_col\[0\].pe__1896_/A
+ sky130_fd_sc_hd__o21a_2
Xg_row\[1\].g_col\[1\].pe__2443_ g_row\[1\].g_col\[1\].pe__2762_/Q g_row\[1\].g_col\[1\].pe__2443_/B
+ VGND VGND VPWR VPWR g_row\[1\].g_col\[1\].pe__2444_/B sky130_fd_sc_hd__and2b_2
Xg_row\[1\].g_col\[0\].pe__2427_ g_row\[1\].g_col\[0\].pe__2769_/Q g_row\[1\].g_col\[0\].pe__2427_/B
+ VGND VGND VPWR VPWR g_row\[1\].g_col\[0\].pe__2494_/A sky130_fd_sc_hd__and2b_2
XFILLER_83_125 VGND VGND VPWR VPWR sky130_fd_sc_hd__decap_3
XFILLER_83_136 VGND VGND VPWR VPWR sky130_fd_sc_hd__fill_2
Xg_row\[1\].g_col\[1\].pe__2374_ g_row\[1\].g_col\[1\].pe__2385_/A g_row\[1\].g_col\[1\].pe__2385_/B
+ VGND VGND VPWR VPWR g_row\[1\].g_col\[1\].pe__2375_/B sky130_fd_sc_hd__xor2_2
XFILLER_80_810 VGND VGND VPWR VPWR sky130_fd_sc_hd__fill_2
Xg_row\[1\].g_col\[0\].pe__2358_ g_row\[1\].g_col\[0\].pe__2358_/A g_row\[1\].g_col\[0\].pe__2358_/B
+ VGND VGND VPWR VPWR g_row\[1\].g_col\[0\].pe__2359_/B sky130_fd_sc_hd__nand2_2
XTAP_TAPCELL_ROW_35_732 VGND VPWR sky130_fd_sc_hd__tapvpwrvgnd_1
Xg_row\[0\].g_col\[0\].pe__2505_ g_row\[0\].g_col\[0\].pe__2505_/A g_row\[0\].g_col\[0\].pe__2504_/X
+ VGND VGND VPWR VPWR g_row\[0\].g_col\[0\].pe__2505_/X sky130_fd_sc_hd__or2b_2
Xg_row\[1\].g_col\[0\].pe__2289_ g_row\[1\].g_col\[0\].pe__2246_/A g_row\[1\].g_col\[0\].pe__2246_/B
+ g_row\[1\].g_col\[0\].pe__2288_/Y VGND VGND VPWR VPWR g_row\[1\].g_col\[0\].pe__2291_/B
+ sky130_fd_sc_hd__o21ai_2
Xg_row\[0\].g_col\[1\].pe__2521_ g_row\[0\].g_col\[1\].pe__2521_/A1 g_row\[0\].g_col\[1\].pe__2591_/A2
+ g_row\[0\].g_col\[1\].pe__2591_/B1 g_row\[0\].g_col\[1\].pe__2520_/X VGND VGND VPWR
+ VPWR g_row\[0\].g_col\[1\].pe__2522_/B sky130_fd_sc_hd__a22o_2
XFILLER_52_589 VGND VGND VPWR VPWR sky130_fd_sc_hd__fill_1
Xg_row\[0\].g_col\[0\].pe__2436_ ANTENNA_142/DIODE g_row\[0\].g_col\[0\].pe__2436_/B
+ VGND VGND VPWR VPWR g_row\[0\].g_col\[0\].pe__2438_/B sky130_fd_sc_hd__xnor2_2
Xg_row\[0\].g_col\[1\].pe__2452_ g_row\[0\].g_col\[1\].pe__2760_/Q g_row\[0\].g_col\[1\].pe__2452_/B
+ VGND VGND VPWR VPWR g_row\[0\].g_col\[1\].pe__2538_/A sky130_fd_sc_hd__xnor2_2
Xg_row\[0\].g_col\[0\].pe__2367_ g_row\[0\].g_col\[0\].pe__2343_/A g_row\[0\].g_col\[0\].pe__2365_/X
+ g_row\[0\].g_col\[0\].pe__2366_/X VGND VGND VPWR VPWR g_row\[0\].g_col\[0\].pe__2367_/X
+ sky130_fd_sc_hd__a21bo_2
Xg_row\[0\].g_col\[1\].pe__1403_ g_row\[0\].g_col\[1\].pe__1403_/A1 g_row\[0\].g_col\[1\].pe__1372_/X
+ g_row\[0\].g_col\[1\].pe__1402_/X g_row\[0\].g_col\[1\].pe__2679_/C1 VGND VGND VPWR
+ VPWR g_row\[0\].g_col\[1\].pe__1403_/X sky130_fd_sc_hd__o211a_2
Xg_row\[0\].g_col\[1\].pe__2383_ g_row\[0\].g_col\[1\].pe__2383_/A VGND VGND VPWR
+ VPWR g_row\[0\].g_col\[1\].pe__2422_/A sky130_fd_sc_hd__inv_2
Xg_row\[0\].g_col\[0\].pe__2298_ g_row\[0\].g_col\[0\].pe__2298_/A g_row\[0\].g_col\[0\].pe__2263_/X
+ VGND VGND VPWR VPWR g_row\[0\].g_col\[0\].pe__2299_/B sky130_fd_sc_hd__or2b_2
XFILLER_4_608 VGND VGND VPWR VPWR sky130_fd_sc_hd__fill_2
XFILLER_59_111 VGND VGND VPWR VPWR sky130_fd_sc_hd__fill_1
XTAP_TAPCELL_ROW_89_1538 VGND VPWR sky130_fd_sc_hd__tapvpwrvgnd_1
XFILLER_56_840 VGND VGND VPWR VPWR sky130_fd_sc_hd__fill_2
XFILLER_74_13 VGND VGND VPWR VPWR sky130_fd_sc_hd__fill_1
XFILLER_75_659 VGND VGND VPWR VPWR sky130_fd_sc_hd__fill_1
XTAP_TAPCELL_ROW_89_1549 VGND VPWR sky130_fd_sc_hd__tapvpwrvgnd_1
XFILLER_16_704 VGND VGND VPWR VPWR sky130_fd_sc_hd__fill_2
XFILLER_28_564 VGND VGND VPWR VPWR sky130_fd_sc_hd__decap_3
Xg_row\[0\].g_col\[1\].pe_hold2131 g_row\[0\].g_col\[1\].pe__1383_/X VGND VGND VPWR
+ VPWR g_row\[0\].g_col\[1\].pe__1384_/B1 sky130_fd_sc_hd__clkbuf_2
XFILLER_55_372 VGND VGND VPWR VPWR sky130_fd_sc_hd__fill_2
XFILLER_70_320 VGND VGND VPWR VPWR sky130_fd_sc_hd__decap_3
Xg_row\[0\].g_col\[1\].pe_hold2175 g_row\[0\].g_col\[1\].pe__2658_/X VGND VGND VPWR
+ VPWR g_row\[0\].g_col\[1\].pe__2714_/D sky130_fd_sc_hd__clkbuf_2
Xg_row\[0\].g_col\[1\].pe_hold2164 g_row\[0\].g_col\[1\].pe__2644_/X VGND VGND VPWR
+ VPWR g_row\[0\].g_col\[1\].pe__2707_/D sky130_fd_sc_hd__clkbuf_2
Xg_row\[0\].g_col\[1\].pe__2719_ clkbuf_leaf_93_clk/X g_row\[0\].g_col\[1\].pe__2719_/D
+ VGND VGND VPWR VPWR hold3018/A sky130_fd_sc_hd__dfxtp_2
XFILLER_82_191 VGND VGND VPWR VPWR sky130_fd_sc_hd__fill_1
Xg_row\[0\].g_col\[1\].pe_hold2197 g_row\[0\].g_col\[1\].pe__2662_/X VGND VGND VPWR
+ VPWR g_row\[0\].g_col\[1\].pe__2716_/D sky130_fd_sc_hd__clkbuf_2
XFILLER_90_45 VGND VGND VPWR VPWR sky130_fd_sc_hd__fill_2
XTAP_TAPCELL_ROW_13_404 VGND VPWR sky130_fd_sc_hd__tapvpwrvgnd_1
XPHY_EDGE_ROW_4_Left_98 VGND VGND VPWR VPWR sky130_fd_sc_hd__decap_3
X_203_ _203_/A _203_/B_N VGND VGND VPWR VPWR _203_/Y sky130_fd_sc_hd__nor2b_4
XFILLER_23_83 VGND VGND VPWR VPWR sky130_fd_sc_hd__fill_2
Xg_row\[0\].g_col\[0\].pe_place871 g_row\[0\].g_col\[0\].pe__1461_/Y VGND VGND VPWR
+ VPWR g_row\[0\].g_col\[0\].pe__1863_/B1 sky130_fd_sc_hd__buf_6
Xg_row\[1\].g_col\[0\].pe__1660_ g_row\[1\].g_col\[0\].pe__1660_/A g_row\[1\].g_col\[0\].pe__1660_/B
+ VGND VGND VPWR VPWR g_row\[1\].g_col\[0\].pe__1660_/Y sky130_fd_sc_hd__nor2_2
Xg_row\[1\].g_col\[0\].pe__1591_ g_row\[1\].g_col\[0\].pe__1591_/A g_row\[1\].g_col\[0\].pe__1591_/B
+ VGND VGND VPWR VPWR g_row\[1\].g_col\[0\].pe__1830_/C sky130_fd_sc_hd__xnor2_2
XFILLER_66_615 VGND VGND VPWR VPWR sky130_fd_sc_hd__decap_3
XFILLER_19_520 VGND VGND VPWR VPWR sky130_fd_sc_hd__fill_2
Xg_row\[1\].g_col\[0\].pe__2212_ g_row\[1\].g_col\[0\].pe__2253_/A g_row\[1\].g_col\[0\].pe__2253_/B
+ VGND VGND VPWR VPWR g_row\[1\].g_col\[0\].pe__2221_/A sky130_fd_sc_hd__xnor2_2
XFILLER_19_564 VGND VGND VPWR VPWR sky130_fd_sc_hd__fill_1
XFILLER_65_158 VGND VGND VPWR VPWR sky130_fd_sc_hd__fill_2
XFILLER_65_169 VGND VGND VPWR VPWR sky130_fd_sc_hd__fill_1
XFILLER_74_692 VGND VGND VPWR VPWR sky130_fd_sc_hd__fill_1
Xg_row\[1\].g_col\[0\].pe__2143_ g_row\[1\].g_col\[0\].pe__2143_/A g_row\[1\].g_col\[0\].pe__2143_/B
+ VGND VGND VPWR VPWR g_row\[1\].g_col\[0\].pe__2144_/B sky130_fd_sc_hd__xnor2_2
XFILLER_22_707 VGND VGND VPWR VPWR sky130_fd_sc_hd__decap_3
Xg_row\[1\].g_col\[1\].pe__2090_ g_row\[1\].g_col\[1\].pe__2348_/A g_row\[1\].g_col\[1\].pe__2090_/B
+ VGND VGND VPWR VPWR g_row\[1\].g_col\[1\].pe__2091_/C sky130_fd_sc_hd__xnor2_2
Xg_row\[1\].g_col\[0\].pe__2074_ place1090/A g_row\[1\].g_col\[0\].pe__1549_/B g_row\[1\].g_col\[0\].pe__2074_/B1
+ g_row\[1\].g_col\[0\].pe__2616_/B VGND VGND VPWR VPWR g_row\[1\].g_col\[0\].pe__2075_/B
+ sky130_fd_sc_hd__a22o_2
Xg_row\[0\].g_col\[0\].pe__2221_ g_row\[0\].g_col\[0\].pe__2221_/A g_row\[0\].g_col\[0\].pe__2221_/B
+ VGND VGND VPWR VPWR g_row\[0\].g_col\[0\].pe__2258_/A sky130_fd_sc_hd__xor2_2
XFILLER_30_784 VGND VGND VPWR VPWR sky130_fd_sc_hd__fill_1
XFILLER_9_74 VGND VGND VPWR VPWR sky130_fd_sc_hd__fill_2
Xg_row\[0\].g_col\[0\].pe__2152_ g_row\[0\].g_col\[0\].pe__1894_/Y g_row\[0\].g_col\[0\].pe__1895_/X
+ g_row\[0\].g_col\[0\].pe__2151_/X VGND VGND VPWR VPWR g_row\[0\].g_col\[0\].pe__2155_/B
+ sky130_fd_sc_hd__a21o_2
Xg_row\[0\].g_col\[0\].pe__2083_ g_row\[0\].g_col\[0\].pe__2083_/A g_row\[0\].g_col\[0\].pe__2163_/B
+ VGND VGND VPWR VPWR g_row\[0\].g_col\[0\].pe__2085_/B sky130_fd_sc_hd__nand2_2
Xg_row\[1\].g_col\[1\].pe__1943_ g_row\[1\].g_col\[1\].pe__1951_/A g_row\[1\].g_col\[1\].pe__1951_/B
+ VGND VGND VPWR VPWR g_row\[1\].g_col\[1\].pe__2151_/A sky130_fd_sc_hd__xnor2_2
Xg_row\[1\].g_col\[0\].pe__1927_ g_row\[1\].g_col\[0\].pe__1980_/A g_row\[1\].g_col\[0\].pe__1927_/B
+ VGND VGND VPWR VPWR g_row\[1\].g_col\[0\].pe__1994_/A sky130_fd_sc_hd__xnor2_2
XTAP_TAPCELL_ROW_73_1306 VGND VPWR sky130_fd_sc_hd__tapvpwrvgnd_1
Xg_row\[1\].g_col\[1\].pe__1874_ g_row\[1\].g_col\[1\].pe__1874_/A g_row\[1\].g_col\[1\].pe__1874_/B
+ VGND VGND VPWR VPWR g_row\[1\].g_col\[1\].pe__1932_/B sky130_fd_sc_hd__xor2_2
Xg_row\[1\].g_col\[0\].pe__1858_ g_row\[1\].g_col\[0\].pe__1908_/A g_row\[1\].g_col\[0\].pe__1858_/B
+ VGND VGND VPWR VPWR g_row\[1\].g_col\[0\].pe__1859_/B sky130_fd_sc_hd__and2_2
XFILLER_69_420 VGND VGND VPWR VPWR sky130_fd_sc_hd__fill_2
Xg_row\[1\].g_col\[0\].pe__1789_ g_row\[1\].g_col\[0\].pe__1789_/A g_row\[1\].g_col\[0\].pe__1789_/B
+ VGND VGND VPWR VPWR g_row\[1\].g_col\[0\].pe__1790_/B sky130_fd_sc_hd__or2_2
XFILLER_57_604 VGND VGND VPWR VPWR sky130_fd_sc_hd__fill_2
Xg_row\[0\].g_col\[0\].pe__1936_ g_row\[0\].g_col\[0\].pe__1936_/A g_row\[0\].g_col\[0\].pe__1936_/B
+ VGND VGND VPWR VPWR g_row\[0\].g_col\[0\].pe__1936_/X sky130_fd_sc_hd__or2_4
Xhold1603 hold3548/X VGND VGND VPWR VPWR hold3549/A sky130_fd_sc_hd__clkbuf_2
Xhold1614 hold2778/X VGND VGND VPWR VPWR hold2779/A sky130_fd_sc_hd__clkbuf_2
Xhold1625 hold3582/X VGND VGND VPWR VPWR hold2795/A sky130_fd_sc_hd__clkbuf_2
Xhold2359 hold2359/A VGND VGND VPWR VPWR hold2359/X sky130_fd_sc_hd__clkbuf_2
Xg_row\[0\].g_col\[1\].pe__1952_ g_row\[0\].g_col\[1\].pe__1952_/A g_row\[0\].g_col\[1\].pe__1938_/A
+ VGND VGND VPWR VPWR g_row\[0\].g_col\[1\].pe__1952_/X sky130_fd_sc_hd__or2b_2
Xhold1658 hold1658/A VGND VGND VPWR VPWR hold1658/X sky130_fd_sc_hd__clkbuf_2
Xg_row\[1\].g_col\[1\].pe__2426_ g_row\[1\].g_col\[1\].pe__2752_/Q g_row\[1\].g_col\[1\].pe__2426_/B
+ VGND VGND VPWR VPWR g_row\[1\].g_col\[1\].pe__2427_/B sky130_fd_sc_hd__xor2_2
Xg_row\[0\].g_col\[1\].pe__1883_ g_row\[0\].g_col\[1\].pe__1883_/A g_row\[0\].g_col\[1\].pe__1883_/B
+ VGND VGND VPWR VPWR g_row\[0\].g_col\[1\].pe__1883_/X sky130_fd_sc_hd__or2_2
XFILLER_44_309 VGND VGND VPWR VPWR sky130_fd_sc_hd__fill_2
XFILLER_84_489 VGND VGND VPWR VPWR sky130_fd_sc_hd__decap_3
Xg_row\[0\].g_col\[0\].pe__1867_ g_row\[0\].g_col\[0\].pe__2348_/A g_row\[0\].g_col\[0\].pe__1867_/B
+ VGND VGND VPWR VPWR g_row\[0\].g_col\[0\].pe__1868_/B sky130_fd_sc_hd__xnor2_2
XFILLER_71_117 VGND VGND VPWR VPWR sky130_fd_sc_hd__fill_1
Xg_row\[0\].g_col\[0\].pe__1798_ place1222/X g_row\[0\].g_col\[0\].pe__1801_/B VGND
+ VGND VPWR VPWR g_row\[0\].g_col\[0\].pe__1806_/B sky130_fd_sc_hd__nand2_2
Xg_row\[1\].g_col\[1\].pe__2357_ g_row\[1\].g_col\[1\].pe__2329_/A g_row\[1\].g_col\[1\].pe__2330_/X
+ g_row\[1\].g_col\[1\].pe__2329_/B VGND VGND VPWR VPWR g_row\[1\].g_col\[1\].pe__2358_/B
+ sky130_fd_sc_hd__a21o_2
XFILLER_44_27 VGND VGND VPWR VPWR sky130_fd_sc_hd__fill_1
XTAP_TAPCELL_ROW_84_1468 VGND VPWR sky130_fd_sc_hd__tapvpwrvgnd_1
Xg_row\[1\].g_col\[1\].pe__2288_ g_row\[1\].g_col\[1\].pe__2288_/A g_row\[1\].g_col\[1\].pe__2288_/B
+ VGND VGND VPWR VPWR g_row\[1\].g_col\[1\].pe__2288_/Y sky130_fd_sc_hd__nand2_2
XFILLER_13_729 VGND VGND VPWR VPWR sky130_fd_sc_hd__decap_3
Xg_row\[0\].g_col\[1\].pe__2504_ g_row\[0\].g_col\[1\].pe__2495_/A g_row\[0\].g_col\[1\].pe__2471_/C
+ g_row\[0\].g_col\[1\].pe__2471_/A VGND VGND VPWR VPWR g_row\[0\].g_col\[1\].pe__2504_/X
+ sky130_fd_sc_hd__a21o_2
Xg_row\[0\].g_col\[0\].pe__2419_ g_row\[0\].g_col\[0\].pe__2450_/A1 ANTENNA_42/DIODE
+ g_row\[0\].g_col\[0\].pe__2430_/B VGND VGND VPWR VPWR g_row\[0\].g_col\[0\].pe__2429_/B
+ sky130_fd_sc_hd__a21oi_2
Xg_row\[0\].g_col\[1\].pe__2435_ g_row\[0\].g_col\[1\].pe__2472_/B g_row\[0\].g_col\[1\].pe__2765_/Q
+ VGND VGND VPWR VPWR g_row\[0\].g_col\[1\].pe__2489_/B sky130_fd_sc_hd__or2b_2
XFILLER_20_250 VGND VGND VPWR VPWR sky130_fd_sc_hd__fill_2
Xg_row\[0\].g_col\[0\].pe_place1206 place1205/A VGND VGND VPWR VPWR g_row\[0\].g_col\[0\].pe__2215_/B2
+ sky130_fd_sc_hd__buf_6
Xg_row\[0\].g_col\[0\].pe_place1228 g_row\[0\].g_col\[0\].pe__2633_/B1 VGND VGND VPWR
+ VPWR g_row\[0\].g_col\[0\].pe__2628_/B1 sky130_fd_sc_hd__buf_6
Xg_row\[0\].g_col\[1\].pe__2366_ g_row\[0\].g_col\[1\].pe__2343_/A g_row\[0\].g_col\[1\].pe__2365_/A
+ g_row\[0\].g_col\[1\].pe__2365_/B VGND VGND VPWR VPWR g_row\[0\].g_col\[1\].pe__2366_/X
+ sky130_fd_sc_hd__a21o_2
Xg_row\[1\].g_col\[1\].pe__2688__1428 VGND VGND VPWR VPWR g_row\[1\].g_col\[1\].pe__2688__1428/HI
+ g_row\[1\].g_col\[1\].pe__2688_/CIN sky130_fd_sc_hd__conb_1
Xg_row\[0\].g_col\[1\].pe__2297_ g_row\[0\].g_col\[1\].pe__2297_/A g_row\[0\].g_col\[1\].pe__2330_/C
+ VGND VGND VPWR VPWR g_row\[0\].g_col\[1\].pe__2305_/A sky130_fd_sc_hd__xor2_2
Xg_row\[1\].g_col\[1\].pe_hold2824 g_row\[1\].g_col\[1\].pe__2650_/X VGND VGND VPWR
+ VPWR g_row\[1\].g_col\[1\].pe_hold2824/X sky130_fd_sc_hd__clkbuf_2
Xg_row\[1\].g_col\[1\].pe_hold2868 g_row\[1\].g_col\[1\].pe__2718_/Q VGND VGND VPWR
+ VPWR g_row\[1\].g_col\[1\].pe__2665_/B sky130_fd_sc_hd__clkbuf_2
Xhold3561 hold3561/A VGND VGND VPWR VPWR hold3561/X sky130_fd_sc_hd__clkbuf_2
Xhold3550 hold3550/A VGND VGND VPWR VPWR hold3550/X sky130_fd_sc_hd__clkbuf_2
Xhold3594 hold3594/A VGND VGND VPWR VPWR hold3594/X sky130_fd_sc_hd__clkbuf_2
Xhold3583 a_inputs_flat[29] VGND VGND VPWR VPWR hold3583/X sky130_fd_sc_hd__clkbuf_2
Xhold3572 hold3572/A VGND VGND VPWR VPWR hold3572/X sky130_fd_sc_hd__clkbuf_2
XFILLER_47_169 VGND VGND VPWR VPWR sky130_fd_sc_hd__fill_2
XFILLER_90_459 VGND VGND VPWR VPWR sky130_fd_sc_hd__fill_2
XFILLER_16_589 VGND VGND VPWR VPWR sky130_fd_sc_hd__decap_3
XFILLER_31_559 VGND VGND VPWR VPWR sky130_fd_sc_hd__fill_1
XTAP_TAPCELL_ROW_26_595 VGND VPWR sky130_fd_sc_hd__tapvpwrvgnd_1
Xg_row\[0\].g_col\[1\].pe_place1151 g_row\[0\].g_col\[1\].pe__2138_/B2 VGND VGND VPWR
+ VPWR g_row\[0\].g_col\[1\].pe__1727_/A2 sky130_fd_sc_hd__buf_6
Xg_row\[0\].g_col\[1\].pe_place1140 g_row\[0\].g_col\[1\].pe__2702_/Q VGND VGND VPWR
+ VPWR g_row\[0\].g_col\[1\].pe__2627_/B sky130_fd_sc_hd__buf_6
Xg_row\[0\].g_col\[1\].pe_place1173 g_row\[0\].g_col\[1\].pe__1836_/A VGND VGND VPWR
+ VPWR g_row\[0\].g_col\[1\].pe__2656_/B1 sky130_fd_sc_hd__buf_6
Xg_row\[0\].g_col\[1\].pe_place1162 g_row\[0\].g_col\[1\].pe__2691_/Q VGND VGND VPWR
+ VPWR g_row\[0\].g_col\[1\].pe__1805_/A2 sky130_fd_sc_hd__buf_6
Xg_row\[1\].g_col\[0\].pe__2761_ clkbuf_leaf_57_clk/X g_row\[1\].g_col\[0\].pe__2761_/D
+ VGND VGND VPWR VPWR g_row\[1\].g_col\[0\].pe__2761_/Q sky130_fd_sc_hd__dfxtp_2
Xg_row\[1\].g_col\[0\].pe__2692_ _294_/CLK g_row\[1\].g_col\[0\].pe__2692_/D VGND
+ VGND VPWR VPWR hold2198/A sky130_fd_sc_hd__dfxtp_2
Xg_row\[1\].g_col\[0\].pe__1712_ g_row\[1\].g_col\[0\].pe__1736_/A g_row\[1\].g_col\[0\].pe__1736_/B
+ VGND VGND VPWR VPWR g_row\[1\].g_col\[0\].pe__1714_/B sky130_fd_sc_hd__nand2_2
XTAP_TAPCELL_ROW_55_1036 VGND VPWR sky130_fd_sc_hd__tapvpwrvgnd_1
Xg_row\[1\].g_col\[0\].pe__1643_ place1093/X g_row\[1\].g_col\[0\].pe__1729_/A2 g_row\[1\].g_col\[0\].pe__1729_/A3
+ g_row\[1\].g_col\[0\].pe__1729_/B1 place1092/X VGND VGND VPWR VPWR g_row\[1\].g_col\[0\].pe__1644_/B
+ sky130_fd_sc_hd__a32o_2
Xg_row\[1\].g_col\[1\].pe__1590_ g_row\[1\].g_col\[1\].pe__1594_/A g_row\[1\].g_col\[1\].pe__1594_/B
+ VGND VGND VPWR VPWR g_row\[1\].g_col\[1\].pe__1591_/B sky130_fd_sc_hd__xor2_2
XFILLER_39_615 VGND VGND VPWR VPWR sky130_fd_sc_hd__fill_1
Xg_row\[0\].g_col\[0\].pe__2770_ clkbuf_leaf_51_clk/X g_row\[0\].g_col\[0\].pe__2770_/D
+ VGND VGND VPWR VPWR g_row\[0\].g_col\[0\].pe__2770_/Q sky130_fd_sc_hd__dfxtp_2
Xg_row\[1\].g_col\[0\].pe__1574_ hold1938/A g_row\[1\].g_col\[0\].pe__1414_/X g_row\[1\].g_col\[0\].pe__1415_/Y
+ g_row\[1\].g_col\[0\].pe__1801_/B hold1795/A VGND VGND VPWR VPWR g_row\[1\].g_col\[0\].pe__1575_/B
+ sky130_fd_sc_hd__a32o_2
Xg_row\[0\].g_col\[0\].pe__1721_ g_row\[0\].g_col\[0\].pe__1721_/A g_row\[0\].g_col\[0\].pe__1721_/B
+ VGND VGND VPWR VPWR g_row\[0\].g_col\[0\].pe__1722_/A sky130_fd_sc_hd__xnor2_2
Xg_row\[1\].g_col\[0\].pe_hold1834 g_row\[1\].g_col\[0\].pe__2757_/Q VGND VGND VPWR
+ VPWR g_row\[1\].g_col\[0\].pe__2521_/A1 sky130_fd_sc_hd__clkbuf_2
Xg_row\[1\].g_col\[0\].pe_hold1823 g_row\[1\].g_col\[0\].pe__2535_/X VGND VGND VPWR
+ VPWR g_row\[1\].g_col\[0\].pe__2536_/B sky130_fd_sc_hd__clkbuf_2
XFILLER_54_607 VGND VGND VPWR VPWR sky130_fd_sc_hd__fill_2
Xg_row\[1\].g_col\[0\].pe_hold1878 g_row\[1\].g_col\[0\].pe_hold2997/X VGND VGND VPWR
+ VPWR g_row\[1\].g_col\[0\].pe__2731_/D sky130_fd_sc_hd__clkbuf_2
Xg_row\[1\].g_col\[0\].pe_hold1867 g_row\[1\].g_col\[0\].pe__2600_/X VGND VGND VPWR
+ VPWR g_row\[1\].g_col\[0\].pe__2690_/D sky130_fd_sc_hd__clkbuf_2
Xg_row\[1\].g_col\[0\].pe_hold1856 g_row\[1\].g_col\[0\].pe_hold2918/X VGND VGND VPWR
+ VPWR g_row\[1\].g_col\[0\].pe_hold2919/A sky130_fd_sc_hd__clkbuf_2
XFILLER_47_670 VGND VGND VPWR VPWR sky130_fd_sc_hd__fill_2
Xg_row\[0\].g_col\[0\].pe__1652_ place1213/X g_row\[0\].g_col\[0\].pe__1748_/B g_row\[0\].g_col\[0\].pe__1738_/B1
+ place1216/X VGND VGND VPWR VPWR g_row\[0\].g_col\[0\].pe__1653_/B sky130_fd_sc_hd__a22o_2
Xg_row\[1\].g_col\[1\].pe__2211_ g_row\[1\].g_col\[1\].pe__2211_/A VGND VGND VPWR
+ VPWR g_row\[1\].g_col\[1\].pe__2253_/B sky130_fd_sc_hd__inv_2
Xg_row\[0\].g_col\[0\].pe__1583_ g_row\[0\].g_col\[0\].pe__1583_/A g_row\[0\].g_col\[0\].pe__1583_/B
+ VGND VGND VPWR VPWR g_row\[0\].g_col\[0\].pe__1634_/A sky130_fd_sc_hd__xnor2_2
Xg_row\[1\].g_col\[1\].pe__2142_ g_row\[1\].g_col\[1\].pe__2142_/A g_row\[1\].g_col\[1\].pe__2187_/B
+ VGND VGND VPWR VPWR g_row\[1\].g_col\[1\].pe__2143_/B sky130_fd_sc_hd__xnor2_2
Xg_row\[1\].g_col\[0\].pe__2126_ g_row\[1\].g_col\[0\].pe__2125_/A g_row\[1\].g_col\[0\].pe__1449_/A
+ g_row\[1\].g_col\[0\].pe__2125_/X g_row\[1\].g_col\[0\].pe__2167_/A VGND VGND VPWR
+ VPWR g_row\[1\].g_col\[0\].pe__2128_/A sky130_fd_sc_hd__a2bb2o_2
XFILLER_22_504 VGND VGND VPWR VPWR sky130_fd_sc_hd__decap_3
XFILLER_22_526 VGND VGND VPWR VPWR sky130_fd_sc_hd__decap_3
XFILLER_34_386 VGND VGND VPWR VPWR sky130_fd_sc_hd__fill_1
XFILLER_62_673 VGND VGND VPWR VPWR sky130_fd_sc_hd__decap_3
XTAP_TAPCELL_ROW_45_882 VGND VPWR sky130_fd_sc_hd__tapvpwrvgnd_1
XTAP_TAPCELL_ROW_66_1198 VGND VPWR sky130_fd_sc_hd__tapvpwrvgnd_1
Xg_row\[1\].g_col\[1\].pe__2073_ g_row\[1\].g_col\[1\].pe__2138_/B2 g_row\[1\].g_col\[1\].pe__2177_/A2
+ g_row\[1\].g_col\[1\].pe__2177_/B1 g_row\[1\].g_col\[1\].pe__2073_/B2 VGND VGND
+ VPWR VPWR g_row\[1\].g_col\[1\].pe__2136_/A sky130_fd_sc_hd__a22o_2
Xg_row\[1\].g_col\[0\].pe__2057_ g_row\[1\].g_col\[0\].pe__2068_/A g_row\[1\].g_col\[0\].pe__2068_/B
+ VGND VGND VPWR VPWR g_row\[1\].g_col\[0\].pe__2058_/B sky130_fd_sc_hd__xnor2_2
Xg_row\[0\].g_col\[1\].pe__2220_ g_row\[0\].g_col\[1\].pe__2220_/A g_row\[0\].g_col\[1\].pe__2220_/B
+ VGND VGND VPWR VPWR g_row\[0\].g_col\[1\].pe__2221_/B sky130_fd_sc_hd__xor2_2
Xg_row\[0\].g_col\[0\].pe__2204_ g_row\[0\].g_col\[0\].pe__2731_/Q VGND VGND VPWR
+ VPWR g_row\[0\].g_col\[0\].pe__2204_/Y sky130_fd_sc_hd__inv_2
XFILLER_30_18 VGND VGND VPWR VPWR sky130_fd_sc_hd__fill_1
Xg_row\[0\].g_col\[0\].pe__2135_ g_row\[0\].g_col\[0\].pe__2135_/A g_row\[0\].g_col\[0\].pe__2135_/B
+ VGND VGND VPWR VPWR g_row\[0\].g_col\[0\].pe__2144_/A sky130_fd_sc_hd__nand2_2
Xg_row\[0\].g_col\[1\].pe__2151_ g_row\[0\].g_col\[1\].pe__2151_/A g_row\[0\].g_col\[1\].pe__2151_/B
+ g_row\[0\].g_col\[1\].pe__2150_/X VGND VGND VPWR VPWR g_row\[0\].g_col\[1\].pe__2151_/X
+ sky130_fd_sc_hd__or3b_4
Xg_row\[0\].g_col\[1\].pe__2082_ g_row\[0\].g_col\[1\].pe__2081_/B g_row\[0\].g_col\[1\].pe__2081_/C
+ g_row\[0\].g_col\[1\].pe__1459_/C VGND VGND VPWR VPWR g_row\[0\].g_col\[1\].pe__2087_/B
+ sky130_fd_sc_hd__a21bo_2
Xg_row\[0\].g_col\[0\].pe__2066_ g_row\[0\].g_col\[0\].pe__2153_/A g_row\[0\].g_col\[0\].pe__2153_/B
+ VGND VGND VPWR VPWR g_row\[0\].g_col\[0\].pe__2066_/Y sky130_fd_sc_hd__nand2_2
Xg_row\[1\].g_col\[1\].pe__1926_ g_row\[1\].g_col\[1\].pe__1980_/B g_row\[1\].g_col\[1\].pe__1980_/C
+ VGND VGND VPWR VPWR g_row\[1\].g_col\[1\].pe__1927_/B sky130_fd_sc_hd__or2_4
Xg_row\[1\].g_col\[1\].pe__1857_ g_row\[1\].g_col\[1\].pe__1857_/A g_row\[1\].g_col\[1\].pe__1857_/B
+ VGND VGND VPWR VPWR g_row\[1\].g_col\[1\].pe__1858_/B sky130_fd_sc_hd__or2_2
Xg_row\[1\].g_col\[1\].pe__1788_ g_row\[1\].g_col\[1\].pe__2728_/Q g_row\[1\].g_col\[1\].pe__1789_/B
+ VGND VGND VPWR VPWR g_row\[1\].g_col\[1\].pe__1795_/B sky130_fd_sc_hd__nand2_2
XFILLER_85_743 VGND VGND VPWR VPWR sky130_fd_sc_hd__decap_3
Xhold1433 hold3142/X VGND VGND VPWR VPWR hold3143/A sky130_fd_sc_hd__clkbuf_2
Xg_row\[0\].g_col\[1\].pe__1935_ g_row\[0\].g_col\[1\].pe__1935_/A g_row\[0\].g_col\[1\].pe__1935_/B
+ VGND VGND VPWR VPWR g_row\[0\].g_col\[1\].pe__1938_/A sky130_fd_sc_hd__xnor2_2
XFILLER_29_147 VGND VGND VPWR VPWR sky130_fd_sc_hd__fill_1
XFILLER_55_15 VGND VGND VPWR VPWR sky130_fd_sc_hd__decap_3
XTAP_TAPCELL_ROW_4_268 VGND VPWR sky130_fd_sc_hd__tapvpwrvgnd_1
Xg_row\[0\].g_col\[0\].pe__1919_ g_row\[0\].g_col\[0\].pe__2094_/B g_row\[0\].g_col\[0\].pe__1919_/B
+ VGND VGND VPWR VPWR g_row\[0\].g_col\[0\].pe__2043_/A sky130_fd_sc_hd__nand2_2
Xhold1444 hold3180/X VGND VGND VPWR VPWR hold3181/A sky130_fd_sc_hd__clkbuf_2
Xhold1455 hold2460/X VGND VGND VPWR VPWR hold2461/A sky130_fd_sc_hd__clkbuf_2
Xhold1466 hold3219/X VGND VGND VPWR VPWR hold3220/A sky130_fd_sc_hd__clkbuf_2
Xhold1477 hold3299/X VGND VGND VPWR VPWR hold3300/A sky130_fd_sc_hd__clkbuf_2
XFILLER_72_437 VGND VGND VPWR VPWR sky130_fd_sc_hd__fill_1
Xhold1488 hold2532/X VGND VGND VPWR VPWR hold2533/A sky130_fd_sc_hd__clkbuf_2
Xhold1499 hold3275/X VGND VGND VPWR VPWR hold3276/A sky130_fd_sc_hd__clkbuf_2
Xg_row\[1\].g_col\[1\].pe__2409_ g_row\[1\].g_col\[1\].pe__2775_/A g_row\[1\].g_col\[1\].pe__2410_/B
+ VGND VGND VPWR VPWR g_row\[1\].g_col\[1\].pe__2519_/A sky130_fd_sc_hd__nor2_2
Xg_row\[0\].g_col\[1\].pe__1866_ g_row\[0\].g_col\[1\].pe__2138_/B2 g_row\[0\].g_col\[1\].pe__1471_/X
+ g_row\[0\].g_col\[1\].pe__1474_/Y g_row\[0\].g_col\[1\].pe__2073_/B2 VGND VGND VPWR
+ VPWR g_row\[0\].g_col\[1\].pe__1867_/B sky130_fd_sc_hd__a22o_2
Xg_row\[1\].g_col\[0\].pe_place849 g_row\[1\].g_col\[0\].pe__1461_/Y VGND VGND VPWR
+ VPWR g_row\[1\].g_col\[0\].pe__1863_/B1 sky130_fd_sc_hd__buf_6
Xg_row\[0\].g_col\[1\].pe__1797_ g_row\[0\].g_col\[1\].pe__1797_/A g_row\[0\].g_col\[1\].pe__1797_/B
+ VGND VGND VPWR VPWR g_row\[0\].g_col\[1\].pe__1807_/A sky130_fd_sc_hd__and2_4
XFILLER_41_813 VGND VGND VPWR VPWR sky130_fd_sc_hd__fill_1
XFILLER_53_684 VGND VGND VPWR VPWR sky130_fd_sc_hd__fill_1
XTAP_TAPCELL_ROW_23_554 VGND VPWR sky130_fd_sc_hd__tapvpwrvgnd_1
XFILLER_40_389 VGND VGND VPWR VPWR sky130_fd_sc_hd__decap_3
Xinput1321 hold3392/X VGND VGND VPWR VPWR hold3393/A sky130_fd_sc_hd__buf_2
Xinput1310 hold3175/X VGND VGND VPWR VPWR hold3176/A sky130_fd_sc_hd__buf_2
Xg_row\[0\].g_col\[1\].pe__2418_ g_row\[0\].g_col\[1\].pe__2421_/A1 g_row\[0\].g_col\[1\].pe__2749_/Q
+ g_row\[0\].g_col\[1\].pe__2432_/B VGND VGND VPWR VPWR g_row\[0\].g_col\[1\].pe__2430_/B
+ sky130_fd_sc_hd__a21o_2
Xinput1343 hold3301/X VGND VGND VPWR VPWR hold3302/A sky130_fd_sc_hd__buf_2
Xinput1332 hold3259/X VGND VGND VPWR VPWR hold3260/A sky130_fd_sc_hd__buf_2
Xg_row\[0\].g_col\[1\].pe__2349_ g_row\[0\].g_col\[1\].pe__2368_/B g_row\[0\].g_col\[1\].pe__2349_/B
+ VGND VGND VPWR VPWR g_row\[0\].g_col\[1\].pe__2350_/B sky130_fd_sc_hd__xor2_2
Xg_row\[1\].g_col\[1\].pe_hold1964 g_row\[1\].g_col\[1\].pe_hold3075/X VGND VGND VPWR
+ VPWR g_row\[1\].g_col\[1\].pe__2679_/A1 sky130_fd_sc_hd__clkbuf_2
Xg_row\[1\].g_col\[1\].pe_hold1953 g_row\[1\].g_col\[1\].pe_hold3089/X VGND VGND VPWR
+ VPWR g_row\[1\].g_col\[1\].pe__2727_/D sky130_fd_sc_hd__clkbuf_2
Xg_row\[1\].g_col\[1\].pe_hold1942 g_row\[1\].g_col\[1\].pe__2611_/X VGND VGND VPWR
+ VPWR g_row\[1\].g_col\[1\].pe__2694_/D sky130_fd_sc_hd__clkbuf_2
XFILLER_76_754 VGND VGND VPWR VPWR sky130_fd_sc_hd__fill_2
Xhold3380 hold3380/A VGND VGND VPWR VPWR hold3380/X sky130_fd_sc_hd__clkbuf_2
Xhold3391 hold3391/A VGND VGND VPWR VPWR hold3391/X sky130_fd_sc_hd__clkbuf_2
XFILLER_29_93 VGND VGND VPWR VPWR sky130_fd_sc_hd__decap_3
Xhold2690 hold3480/X VGND VGND VPWR VPWR hold3481/A sky130_fd_sc_hd__clkbuf_2
XFILLER_50_109 VGND VGND VPWR VPWR sky130_fd_sc_hd__fill_2
XFILLER_91_7 VGND VGND VPWR VPWR sky130_fd_sc_hd__fill_1
XTAP_TAPCELL_ROW_42_841 VGND VPWR sky130_fd_sc_hd__tapvpwrvgnd_1
XFILLER_12_581 VGND VGND VPWR VPWR sky130_fd_sc_hd__decap_3
Xclkbuf_4_14_0_clk clkbuf_0_clk/X VGND VGND VPWR VPWR clkload7/A sky130_fd_sc_hd__clkbuf_16
XFILLER_12_592 VGND VGND VPWR VPWR sky130_fd_sc_hd__decap_3
XANTENNA_2 a_inputs_flat[13] VGND VGND VPWR VPWR sky130_fd_sc_hd__diode_2
Xg_row\[1\].g_col\[1\].pe__2760_ clkbuf_leaf_72_clk/X g_row\[1\].g_col\[1\].pe__2760_/D
+ VGND VGND VPWR VPWR g_row\[1\].g_col\[1\].pe__2760_/Q sky130_fd_sc_hd__dfxtp_2
Xg_row\[1\].g_col\[0\].pe__2744_ clkbuf_leaf_60_clk/X g_row\[1\].g_col\[0\].pe__2744_/D
+ VGND VGND VPWR VPWR g_row\[1\].g_col\[0\].pe__2744_/Q sky130_fd_sc_hd__dfxtp_2
Xg_row\[1\].g_col\[1\].pe__2691_ clkload15/A g_row\[1\].g_col\[1\].pe__2691_/D VGND
+ VGND VPWR VPWR g_row\[1\].g_col\[1\].pe__2691_/Q sky130_fd_sc_hd__dfxtp_2
Xg_row\[1\].g_col\[1\].pe__1711_ g_row\[1\].g_col\[1\].pe__1733_/A g_row\[1\].g_col\[1\].pe__1711_/B
+ VGND VGND VPWR VPWR g_row\[1\].g_col\[1\].pe__1736_/B sky130_fd_sc_hd__xor2_2
Xg_row\[1\].g_col\[1\].pe__1642_ g_row\[1\].g_col\[1\].pe__1728_/A g_row\[1\].g_col\[1\].pe__1642_/B
+ VGND VGND VPWR VPWR g_row\[1\].g_col\[1\].pe__1648_/A sky130_fd_sc_hd__xnor2_2
Xg_row\[1\].g_col\[0\].pe_hold3011 g_row\[1\].g_col\[0\].pe__2737_/Q VGND VGND VPWR
+ VPWR g_row\[1\].g_col\[0\].pe_hold3011/X sky130_fd_sc_hd__clkbuf_2
Xg_row\[1\].g_col\[0\].pe__2675_ g_row\[1\].g_col\[0\].pe__2672_/X g_row\[1\].g_col\[0\].pe__2673_/X
+ g_row\[1\].g_col\[0\].pe__2674_/X hold2015/X VGND VGND VPWR VPWR g_row\[1\].g_col\[0\].pe__2678_/B
+ sky130_fd_sc_hd__o31ai_2
Xg_row\[1\].g_col\[0\].pe__1626_ g_row\[1\].g_col\[0\].pe__1626_/A g_row\[1\].g_col\[0\].pe__1626_/B
+ VGND VGND VPWR VPWR g_row\[1\].g_col\[0\].pe__1626_/X sky130_fd_sc_hd__and2_2
Xg_row\[1\].g_col\[1\].pe_place902 g_row\[1\].g_col\[1\].pe__1398_/B VGND VGND VPWR
+ VPWR g_row\[1\].g_col\[1\].pe__2680_/B sky130_fd_sc_hd__buf_6
Xg_row\[1\].g_col\[1\].pe__1573_ g_row\[1\].g_col\[1\].pe__1808_/A g_row\[1\].g_col\[1\].pe__1573_/B
+ VGND VGND VPWR VPWR g_row\[1\].g_col\[1\].pe__1626_/A sky130_fd_sc_hd__xnor2_2
Xg_row\[1\].g_col\[0\].pe_hold3099 g_row\[1\].g_col\[0\].pe__1380_/X VGND VGND VPWR
+ VPWR g_row\[1\].g_col\[0\].pe_hold3099/X sky130_fd_sc_hd__clkbuf_2
Xg_row\[1\].g_col\[0\].pe__1557_ g_row\[1\].g_col\[0\].pe__2021_/A g_row\[1\].g_col\[0\].pe__1557_/B
+ VGND VGND VPWR VPWR g_row\[1\].g_col\[0\].pe__1558_/C sky130_fd_sc_hd__xnor2_2
XFILLER_39_478 VGND VGND VPWR VPWR sky130_fd_sc_hd__fill_2
Xg_row\[0\].g_col\[0\].pe__2753_ clkbuf_leaf_25_clk/X g_row\[0\].g_col\[0\].pe__2753_/D
+ VGND VGND VPWR VPWR g_row\[0\].g_col\[0\].pe__2753_/Q sky130_fd_sc_hd__dfxtp_2
XFILLER_26_106 VGND VGND VPWR VPWR sky130_fd_sc_hd__fill_1
XTAP_TAPCELL_ROW_1_227 VGND VPWR sky130_fd_sc_hd__tapvpwrvgnd_1
XTAP_TAPCELL_ROW_68_1227 VGND VPWR sky130_fd_sc_hd__tapvpwrvgnd_1
Xg_row\[0\].g_col\[0\].pe__1704_ g_row\[0\].g_col\[0\].pe__1804_/A place1207/X place1209/X
+ g_row\[0\].g_col\[0\].pe__1804_/B VGND VGND VPWR VPWR g_row\[0\].g_col\[0\].pe__1705_/B
+ sky130_fd_sc_hd__a22o_2
Xg_row\[0\].g_col\[0\].pe__2684_ g_row\[0\].g_col\[0\].pe__2684_/A g_row\[0\].g_col\[0\].pe__2684_/B
+ VGND VGND VPWR VPWR g_row\[0\].g_col\[0\].pe__2684_/X sky130_fd_sc_hd__or2_2
Xg_row\[0\].g_col\[1\].pe__1720_ g_row\[0\].g_col\[1\].pe__1742_/B g_row\[0\].g_col\[1\].pe__1743_/B
+ g_row\[0\].g_col\[1\].pe__1719_/Y VGND VGND VPWR VPWR g_row\[0\].g_col\[1\].pe__1723_/A
+ sky130_fd_sc_hd__a21o_2
Xg_row\[1\].g_col\[0\].pe__1488_ place1089/X g_row\[1\].g_col\[0\].pe__1732_/A2 g_row\[1\].g_col\[0\].pe__1732_/B1
+ place1092/X VGND VGND VPWR VPWR g_row\[1\].g_col\[0\].pe__1489_/B sky130_fd_sc_hd__a22o_2
XFILLER_26_139 VGND VGND VPWR VPWR sky130_fd_sc_hd__fill_1
XFILLER_35_651 VGND VGND VPWR VPWR sky130_fd_sc_hd__fill_2
XFILLER_54_459 VGND VGND VPWR VPWR sky130_fd_sc_hd__decap_3
XFILLER_82_757 VGND VGND VPWR VPWR sky130_fd_sc_hd__fill_2
Xg_row\[0\].g_col\[0\].pe__1635_ g_row\[0\].g_col\[0\].pe__1587_/A g_row\[0\].g_col\[0\].pe__1587_/B
+ g_row\[0\].g_col\[0\].pe__1634_/X VGND VGND VPWR VPWR g_row\[0\].g_col\[0\].pe__1636_/B
+ sky130_fd_sc_hd__o21a_2
Xg_row\[0\].g_col\[1\].pe__1651_ g_row\[0\].g_col\[1\].pe__1660_/A g_row\[0\].g_col\[1\].pe__1660_/B
+ VGND VGND VPWR VPWR g_row\[0\].g_col\[1\].pe__1693_/A sky130_fd_sc_hd__xor2_2
XFILLER_35_673 VGND VGND VPWR VPWR sky130_fd_sc_hd__fill_1
XFILLER_50_643 VGND VGND VPWR VPWR sky130_fd_sc_hd__fill_1
XTAP_TAPCELL_ROW_81_1427 VGND VPWR sky130_fd_sc_hd__tapvpwrvgnd_1
Xg_row\[0\].g_col\[0\].pe__1566_ place1210/X g_row\[0\].g_col\[0\].pe__1715_/B g_row\[0\].g_col\[0\].pe__1863_/B1
+ g_row\[0\].g_col\[0\].pe__1866_/B2 VGND VGND VPWR VPWR g_row\[0\].g_col\[0\].pe__1567_/B
+ sky130_fd_sc_hd__a22o_2
Xg_row\[0\].g_col\[1\].pe__1582_ g_row\[0\].g_col\[1\].pe__1630_/B g_row\[0\].g_col\[1\].pe__1582_/B
+ VGND VGND VPWR VPWR g_row\[0\].g_col\[1\].pe__1583_/B sky130_fd_sc_hd__xnor2_2
Xg_row\[1\].g_col\[1\].pe__2125_ g_row\[1\].g_col\[1\].pe__2125_/A g_row\[1\].g_col\[1\].pe__2729_/Q
+ g_row\[1\].g_col\[1\].pe__2125_/C VGND VGND VPWR VPWR g_row\[1\].g_col\[1\].pe__2125_/X
+ sky130_fd_sc_hd__or3_2
Xg_row\[1\].g_col\[0\].pe__2109_ g_row\[1\].g_col\[0\].pe__2110_/A g_row\[1\].g_col\[0\].pe__2110_/B
+ VGND VGND VPWR VPWR g_row\[1\].g_col\[0\].pe__2111_/A sky130_fd_sc_hd__and2_4
Xg_row\[0\].g_col\[0\].pe__1497_ place1218/X g_row\[0\].g_col\[0\].pe__1657_/B g_row\[0\].g_col\[0\].pe__2247_/B1
+ g_row\[0\].g_col\[0\].pe__1672_/A1 VGND VGND VPWR VPWR g_row\[0\].g_col\[0\].pe__1498_/B
+ sky130_fd_sc_hd__a22o_2
Xg_row\[1\].g_col\[1\].pe__2056_ g_row\[1\].g_col\[1\].pe__1997_/A g_row\[1\].g_col\[1\].pe__1997_/B
+ g_row\[1\].g_col\[1\].pe__2055_/Y VGND VGND VPWR VPWR g_row\[1\].g_col\[1\].pe__2068_/B
+ sky130_fd_sc_hd__a21oi_2
XTAP_TAPCELL_ROW_20_513 VGND VPWR sky130_fd_sc_hd__tapvpwrvgnd_1
Xg_row\[0\].g_col\[1\].pe__2203_ g_row\[0\].g_col\[1\].pe__2186_/B g_row\[0\].g_col\[1\].pe__2203_/B
+ VGND VGND VPWR VPWR g_row\[0\].g_col\[1\].pe__2228_/A sky130_fd_sc_hd__and2b_2
Xg_row\[0\].g_col\[1\].pe__2134_ g_row\[0\].g_col\[1\].pe__2222_/A g_row\[0\].g_col\[1\].pe__2184_/B
+ g_row\[0\].g_col\[1\].pe__2184_/C VGND VGND VPWR VPWR g_row\[0\].g_col\[1\].pe__2135_/B
+ sky130_fd_sc_hd__nand3b_2
XTAP_TAPCELL_ROW_79_1389 VGND VPWR sky130_fd_sc_hd__tapvpwrvgnd_1
Xg_row\[0\].g_col\[0\].pe__2118_ g_row\[0\].g_col\[0\].pe__2107_/A g_row\[0\].g_col\[0\].pe__2105_/X
+ g_row\[0\].g_col\[0\].pe__2106_/A VGND VGND VPWR VPWR g_row\[0\].g_col\[0\].pe__2148_/A
+ sky130_fd_sc_hd__a21oi_2
XTAP_TAPCELL_ROW_9_338 VGND VPWR sky130_fd_sc_hd__tapvpwrvgnd_1
XTAP_TAPCELL_ROW_9_349 VGND VPWR sky130_fd_sc_hd__tapvpwrvgnd_1
Xg_row\[0\].g_col\[0\].pe__2049_ g_row\[0\].g_col\[0\].pe__2048_/A g_row\[0\].g_col\[0\].pe__2048_/B
+ g_row\[0\].g_col\[0\].pe__2048_/C VGND VGND VPWR VPWR g_row\[0\].g_col\[0\].pe__2049_/X
+ sky130_fd_sc_hd__a21o_2
Xg_row\[1\].g_col\[1\].pe__1909_ g_row\[1\].g_col\[1\].pe__2030_/A g_row\[1\].g_col\[1\].pe__2026_/B
+ g_row\[1\].g_col\[1\].pe__1449_/Y g_row\[1\].g_col\[1\].pe__2278_/B2 VGND VGND VPWR
+ VPWR g_row\[1\].g_col\[1\].pe__1910_/B sky130_fd_sc_hd__a22o_2
Xg_row\[0\].g_col\[1\].pe__2065_ g_row\[0\].g_col\[1\].pe__2065_/A VGND VGND VPWR
+ VPWR g_row\[0\].g_col\[1\].pe__2445_/A sky130_fd_sc_hd__inv_2
Xplace1262 place1263/X VGND VGND VPWR VPWR place1262/X sky130_fd_sc_hd__buf_6
Xplace1273 hold1641/X VGND VGND VPWR VPWR _195_/A sky130_fd_sc_hd__buf_6
Xplace1284 _171_/A VGND VGND VPWR VPWR _271_/A sky130_fd_sc_hd__buf_6
XTAP_TAPCELL_ROW_92_1589 VGND VPWR sky130_fd_sc_hd__tapvpwrvgnd_1
XFILLER_73_713 VGND VGND VPWR VPWR sky130_fd_sc_hd__decap_3
XTAP_TAPCELL_ROW_28_624 VGND VPWR sky130_fd_sc_hd__tapvpwrvgnd_1
Xg_row\[0\].g_col\[1\].pe__1918_ g_row\[0\].g_col\[1\].pe__2045_/A g_row\[0\].g_col\[1\].pe__2045_/B
+ VGND VGND VPWR VPWR g_row\[0\].g_col\[1\].pe__1919_/B sky130_fd_sc_hd__nand2_2
XTAP_TAPCELL_ROW_28_635 VGND VPWR sky130_fd_sc_hd__tapvpwrvgnd_1
Xg_row\[0\].g_col\[1\].pe__1849_ g_row\[0\].g_col\[1\].pe__1607_/A g_row\[0\].g_col\[1\].pe__1849_/B
+ VGND VGND VPWR VPWR g_row\[0\].g_col\[1\].pe__1850_/B sky130_fd_sc_hd__and2b_2
XFILLER_14_824 VGND VGND VPWR VPWR sky130_fd_sc_hd__fill_2
XFILLER_25_172 VGND VGND VPWR VPWR sky130_fd_sc_hd__decap_3
Xg_row\[0\].g_col\[0\].pe_hold1718 g_row\[0\].g_col\[0\].pe__2198_/X VGND VGND VPWR
+ VPWR g_row\[0\].g_col\[0\].pe__2199_/B sky130_fd_sc_hd__clkbuf_2
XFILLER_40_197 VGND VGND VPWR VPWR sky130_fd_sc_hd__fill_1
Xg_row\[1\].g_col\[0\].pe__2460_ g_row\[1\].g_col\[0\].pe__2740_/Q g_row\[1\].g_col\[0\].pe__2460_/B
+ VGND VGND VPWR VPWR g_row\[1\].g_col\[0\].pe__2462_/B sky130_fd_sc_hd__xnor2_2
XFILLER_1_783 VGND VGND VPWR VPWR sky130_fd_sc_hd__fill_1
Xg_row\[1\].g_col\[1\].pe_hold1783 g_row\[1\].g_col\[1\].pe__1401_/X VGND VGND VPWR
+ VPWR g_row\[1\].g_col\[1\].pe__2736_/D sky130_fd_sc_hd__clkbuf_2
Xg_row\[1\].g_col\[0\].pe__2391_ g_row\[1\].g_col\[0\].pe__2391_/A g_row\[1\].g_col\[0\].pe__2391_/B
+ VGND VGND VPWR VPWR g_row\[1\].g_col\[0\].pe__2392_/B sky130_fd_sc_hd__xor2_2
Xg_row\[1\].g_col\[0\].pe__1411_ g_row\[1\].g_col\[0\].pe__2724_/Q VGND VGND VPWR
+ VPWR g_row\[1\].g_col\[0\].pe__1642_/A sky130_fd_sc_hd__inv_4
XFILLER_48_231 VGND VGND VPWR VPWR sky130_fd_sc_hd__fill_2
XFILLER_48_253 VGND VGND VPWR VPWR sky130_fd_sc_hd__decap_3
Xg_row\[1\].g_col\[0\].pe__1342_ g_row\[1\].g_col\[0\].pe__2757_/Q g_row\[1\].g_col\[0\].pe__1342_/B
+ VGND VGND VPWR VPWR output1381/A sky130_fd_sc_hd__xnor2_2
XTAP_TAPCELL_ROW_47_911 VGND VPWR sky130_fd_sc_hd__tapvpwrvgnd_1
XTAP_TAPCELL_ROW_47_922 VGND VPWR sky130_fd_sc_hd__tapvpwrvgnd_1
XFILLER_17_673 VGND VGND VPWR VPWR sky130_fd_sc_hd__fill_1
XFILLER_16_161 VGND VGND VPWR VPWR sky130_fd_sc_hd__decap_3
XFILLER_32_632 VGND VGND VPWR VPWR sky130_fd_sc_hd__fill_1
XFILLER_44_470 VGND VGND VPWR VPWR sky130_fd_sc_hd__fill_1
Xg_row\[0\].g_col\[0\].pe__1420_ g_row\[0\].g_col\[0\].pe__1428_/A g_row\[0\].g_col\[0\].pe__1428_/B
+ VGND VGND VPWR VPWR g_row\[0\].g_col\[0\].pe__1650_/A sky130_fd_sc_hd__xor2_2
Xg_row\[0\].g_col\[0\].pe_hold2920 _283_/Q VGND VGND VPWR VPWR g_row\[0\].g_col\[0\].pe_hold2920/X
+ sky130_fd_sc_hd__clkbuf_2
XFILLER_32_643 VGND VGND VPWR VPWR sky130_fd_sc_hd__fill_1
XTAP_TAPCELL_ROW_63_1157 VGND VPWR sky130_fd_sc_hd__tapvpwrvgnd_1
Xg_row\[0\].g_col\[0\].pe__1351_ g_row\[0\].g_col\[0\].pe__2761_/Q g_row\[0\].g_col\[0\].pe__1351_/B
+ VGND VGND VPWR VPWR output1410/A sky130_fd_sc_hd__xnor2_2
Xg_row\[0\].g_col\[0\].pe_hold2942 _324_/Q VGND VGND VPWR VPWR g_row\[0\].g_col\[0\].pe__2675_/B1
+ sky130_fd_sc_hd__clkbuf_2
Xg_row\[0\].g_col\[0\].pe_hold2964 g_row\[0\].g_col\[0\].pe__1394_/A VGND VGND VPWR
+ VPWR g_row\[0\].g_col\[0\].pe__2662_/A2 sky130_fd_sc_hd__clkbuf_2
Xg_row\[0\].g_col\[0\].pe_hold2975 _323_/Q VGND VGND VPWR VPWR g_row\[0\].g_col\[0\].pe_hold2975/X
+ sky130_fd_sc_hd__clkbuf_2
Xg_row\[1\].g_col\[1\].pe__2743_ clkload16/A g_row\[1\].g_col\[1\].pe__2743_/D VGND
+ VGND VPWR VPWR g_row\[1\].g_col\[1\].pe__2743_/Q sky130_fd_sc_hd__dfxtp_2
Xg_row\[1\].g_col\[0\].pe__2727_ clkbuf_leaf_44_clk/X g_row\[1\].g_col\[0\].pe__2727_/D
+ VGND VGND VPWR VPWR g_row\[1\].g_col\[0\].pe__2727_/Q sky130_fd_sc_hd__dfxtp_2
XFILLER_59_518 VGND VGND VPWR VPWR sky130_fd_sc_hd__decap_3
XFILLER_87_838 VGND VGND VPWR VPWR sky130_fd_sc_hd__fill_2
Xg_row\[1\].g_col\[1\].pe__2674_ hold2141/X hold2200/X hold1778/X hold2176/X VGND
+ VGND VPWR VPWR g_row\[1\].g_col\[1\].pe__2674_/X sky130_fd_sc_hd__or4_2
Xg_row\[1\].g_col\[0\].pe__2658_ g_row\[1\].g_col\[0\].pe__2670_/A1 g_row\[1\].g_col\[0\].pe__2658_/A2
+ g_row\[1\].g_col\[0\].pe__2670_/B1 g_row\[1\].g_col\[0\].pe__2658_/C1 VGND VGND
+ VPWR VPWR g_row\[1\].g_col\[0\].pe__2658_/X sky130_fd_sc_hd__o211a_2
Xg_row\[1\].g_col\[1\].pe__1625_ g_row\[1\].g_col\[1\].pe__1625_/A g_row\[1\].g_col\[1\].pe__1625_/B
+ VGND VGND VPWR VPWR g_row\[1\].g_col\[1\].pe__1879_/A sky130_fd_sc_hd__xnor2_2
Xg_row\[1\].g_col\[0\].pe__1609_ g_row\[1\].g_col\[0\].pe__1910_/A g_row\[1\].g_col\[0\].pe__1609_/B
+ VGND VGND VPWR VPWR g_row\[1\].g_col\[0\].pe__1851_/A sky130_fd_sc_hd__xor2_2
Xg_row\[1\].g_col\[1\].pe__1556_ g_row\[1\].g_col\[1\].pe__1901_/B2 g_row\[1\].g_col\[1\].pe__1549_/B
+ g_row\[1\].g_col\[1\].pe__1541_/X g_row\[1\].g_col\[1\].pe__1853_/B2 VGND VGND VPWR
+ VPWR g_row\[1\].g_col\[1\].pe__1557_/B sky130_fd_sc_hd__a22o_2
XPHY_EDGE_ROW_6_Left_100 VGND VGND VPWR VPWR sky130_fd_sc_hd__decap_3
Xg_row\[0\].g_col\[1\].pe__2752_ _307_/CLK g_row\[0\].g_col\[1\].pe__2752_/D VGND
+ VGND VPWR VPWR g_row\[0\].g_col\[1\].pe__2752_/Q sky130_fd_sc_hd__dfxtp_2
XFILLER_55_746 VGND VGND VPWR VPWR sky130_fd_sc_hd__decap_3
XFILLER_55_768 VGND VGND VPWR VPWR sky130_fd_sc_hd__decap_3
Xg_row\[0\].g_col\[0\].pe__2736_ clkbuf_leaf_38_clk/X g_row\[0\].g_col\[0\].pe__2736_/D
+ VGND VGND VPWR VPWR g_row\[0\].g_col\[0\].pe__2736_/Q sky130_fd_sc_hd__dfxtp_2
Xg_row\[0\].g_col\[1\].pe__1703_ g_row\[0\].g_col\[1\].pe__1703_/A g_row\[0\].g_col\[1\].pe__1703_/B
+ VGND VGND VPWR VPWR g_row\[0\].g_col\[1\].pe__1824_/B sky130_fd_sc_hd__xnor2_2
Xg_row\[1\].g_col\[1\].pe__1487_ g_row\[1\].g_col\[1\].pe__1514_/A g_row\[1\].g_col\[1\].pe__1514_/B
+ VGND VGND VPWR VPWR g_row\[1\].g_col\[1\].pe__1490_/A sky130_fd_sc_hd__xor2_2
XFILLER_54_256 VGND VGND VPWR VPWR sky130_fd_sc_hd__decap_3
Xg_row\[0\].g_col\[0\].pe__2667_ g_row\[0\].g_col\[0\].pe__2669_/A hold1884/X VGND
+ VGND VPWR VPWR g_row\[0\].g_col\[0\].pe__2667_/X sky130_fd_sc_hd__or2_2
Xg_row\[0\].g_col\[1\].pe_hold1848 g_row\[0\].g_col\[1\].pe__2591_/X VGND VGND VPWR
+ VPWR g_row\[0\].g_col\[1\].pe__2592_/B sky130_fd_sc_hd__clkbuf_2
Xg_row\[0\].g_col\[1\].pe__2683_ g_row\[0\].g_col\[1\].pe__2683_/A1 g_row\[0\].g_col\[1\].pe__2680_/B
+ g_row\[0\].g_col\[1\].pe__2682_/X g_row\[0\].g_col\[1\].pe__2687_/C1 VGND VGND VPWR
+ VPWR g_row\[0\].g_col\[1\].pe__2683_/X sky130_fd_sc_hd__o211a_2
XFILLER_23_610 VGND VGND VPWR VPWR sky130_fd_sc_hd__decap_3
XFILLER_54_289 VGND VGND VPWR VPWR sky130_fd_sc_hd__decap_3
Xg_row\[0\].g_col\[0\].pe__1618_ g_row\[0\].g_col\[0\].pe__1808_/A g_row\[0\].g_col\[0\].pe__2125_/A
+ g_row\[0\].g_col\[0\].pe__1616_/A2 VGND VGND VPWR VPWR g_row\[0\].g_col\[0\].pe__1875_/B
+ sky130_fd_sc_hd__or3b_2
Xg_row\[0\].g_col\[1\].pe__1634_ g_row\[0\].g_col\[1\].pe__1634_/A g_row\[0\].g_col\[1\].pe__1634_/B
+ VGND VGND VPWR VPWR g_row\[0\].g_col\[1\].pe__1634_/X sky130_fd_sc_hd__or2_2
XFILLER_23_643 VGND VGND VPWR VPWR sky130_fd_sc_hd__decap_3
XFILLER_23_676 VGND VGND VPWR VPWR sky130_fd_sc_hd__decap_3
Xg_row\[0\].g_col\[1\].pe__1565_ g_row\[0\].g_col\[1\].pe__1862_/A g_row\[0\].g_col\[1\].pe__1565_/B
+ VGND VGND VPWR VPWR g_row\[0\].g_col\[1\].pe__1596_/A sky130_fd_sc_hd__xor2_2
Xg_row\[1\].g_col\[1\].pe__2108_ g_row\[1\].g_col\[1\].pe__2117_/A g_row\[1\].g_col\[1\].pe__2117_/B
+ VGND VGND VPWR VPWR g_row\[1\].g_col\[1\].pe__2110_/B sky130_fd_sc_hd__xor2_2
XFILLER_11_827 VGND VGND VPWR VPWR sky130_fd_sc_hd__decap_3
Xg_row\[0\].g_col\[0\].pe__1549_ place1221/X g_row\[0\].g_col\[0\].pe__1549_/B g_row\[0\].g_col\[0\].pe__1549_/C
+ VGND VGND VPWR VPWR g_row\[0\].g_col\[0\].pe__1669_/A sky130_fd_sc_hd__and3_2
XFILLER_10_359 VGND VGND VPWR VPWR sky130_fd_sc_hd__fill_1
XFILLER_22_197 VGND VGND VPWR VPWR sky130_fd_sc_hd__decap_3
Xg_row\[0\].g_col\[1\].pe__1496_ g_row\[0\].g_col\[1\].pe__1536_/A g_row\[0\].g_col\[1\].pe__1536_/B
+ VGND VGND VPWR VPWR g_row\[0\].g_col\[1\].pe__1499_/A sky130_fd_sc_hd__xor2_2
Xg_row\[1\].g_col\[1\].pe__2039_ g_row\[1\].g_col\[1\].pe__2038_/A g_row\[1\].g_col\[1\].pe__2038_/B
+ g_row\[1\].g_col\[1\].pe__2038_/C VGND VGND VPWR VPWR g_row\[1\].g_col\[1\].pe__2048_/B
+ sky130_fd_sc_hd__a21o_2
Xg_row\[0\].g_col\[1\].pe__2117_ g_row\[0\].g_col\[1\].pe__2117_/A g_row\[0\].g_col\[1\].pe__2117_/B
+ VGND VGND VPWR VPWR g_row\[0\].g_col\[1\].pe__2161_/A sky130_fd_sc_hd__nor2_2
Xg_row\[0\].g_col\[1\].pe__2048_ g_row\[0\].g_col\[1\].pe__2048_/A g_row\[0\].g_col\[1\].pe__2048_/B
+ g_row\[0\].g_col\[1\].pe__2048_/C VGND VGND VPWR VPWR g_row\[0\].g_col\[1\].pe__2048_/Y
+ sky130_fd_sc_hd__nand3_2
Xplace1092 place1092/A VGND VGND VPWR VPWR place1092/X sky130_fd_sc_hd__buf_6
XFILLER_18_459 VGND VGND VPWR VPWR sky130_fd_sc_hd__fill_1
XFILLER_46_757 VGND VGND VPWR VPWR sky130_fd_sc_hd__fill_1
XFILLER_73_554 VGND VGND VPWR VPWR sky130_fd_sc_hd__decap_3
XFILLER_14_654 VGND VGND VPWR VPWR sky130_fd_sc_hd__decap_3
Xg_row\[0\].g_col\[0\].pe_hold2227 g_row\[0\].g_col\[0\].pe__1383_/X VGND VGND VPWR
+ VPWR g_row\[0\].g_col\[0\].pe__1384_/B1 sky130_fd_sc_hd__clkbuf_2
Xg_row\[0\].g_col\[0\].pe_hold2249 g_row\[0\].g_col\[0\].pe_hold2276/X VGND VGND VPWR
+ VPWR g_row\[0\].g_col\[0\].pe__2687_/A1 sky130_fd_sc_hd__clkbuf_2
XFILLER_14_698 VGND VGND VPWR VPWR sky130_fd_sc_hd__fill_2
XTAP_TAPCELL_ROW_52_991 VGND VPWR sky130_fd_sc_hd__tapvpwrvgnd_1
X_296_ _300_/CLK _296_/D VGND VGND VPWR VPWR _296_/Q sky130_fd_sc_hd__dfxtp_2
Xg_row\[1\].g_col\[0\].pe__1960_ g_row\[1\].g_col\[0\].pe__1961_/A g_row\[1\].g_col\[0\].pe__1961_/B
+ VGND VGND VPWR VPWR g_row\[1\].g_col\[0\].pe__2024_/A sky130_fd_sc_hd__nand2_2
XTAP_TAPCELL_ROW_11_376 VGND VPWR sky130_fd_sc_hd__tapvpwrvgnd_1
Xclkbuf_leaf_102_clk clkbuf_4_0_0_clk/X VGND VGND VPWR VPWR clkload10/A sky130_fd_sc_hd__clkbuf_16
Xg_row\[1\].g_col\[0\].pe__1891_ g_row\[1\].g_col\[0\].pe__1891_/A g_row\[1\].g_col\[0\].pe__1891_/B
+ VGND VGND VPWR VPWR g_row\[1\].g_col\[0\].pe__1891_/Y sky130_fd_sc_hd__xnor2_2
Xg_row\[1\].g_col\[0\].pe__2512_ g_row\[1\].g_col\[0\].pe__2519_/A g_row\[1\].g_col\[0\].pe__2499_/A
+ g_row\[1\].g_col\[0\].pe__2559_/A g_row\[1\].g_col\[0\].pe__2157_/A g_row\[1\].g_col\[0\].pe__2403_/A
+ VGND VGND VPWR VPWR g_row\[1\].g_col\[0\].pe__2512_/X sky130_fd_sc_hd__o311a_2
XPHY_EDGE_ROW_79_Left_173 VGND VGND VPWR VPWR sky130_fd_sc_hd__decap_3
Xg_row\[1\].g_col\[0\].pe__2443_ g_row\[1\].g_col\[0\].pe__2762_/Q g_row\[1\].g_col\[0\].pe__2443_/B
+ VGND VGND VPWR VPWR g_row\[1\].g_col\[0\].pe__2444_/B sky130_fd_sc_hd__and2b_2
XFILLER_68_359 VGND VGND VPWR VPWR sky130_fd_sc_hd__fill_1
Xg_row\[1\].g_col\[1\].pe__2390_ g_row\[1\].g_col\[1\].pe__2390_/A g_row\[1\].g_col\[1\].pe__2390_/B
+ VGND VGND VPWR VPWR g_row\[1\].g_col\[1\].pe__2391_/B sky130_fd_sc_hd__xnor2_2
Xg_row\[1\].g_col\[0\].pe__2374_ g_row\[1\].g_col\[0\].pe__2385_/A g_row\[1\].g_col\[0\].pe__2385_/B
+ VGND VGND VPWR VPWR g_row\[1\].g_col\[0\].pe__2375_/B sky130_fd_sc_hd__xor2_2
XFILLER_76_392 VGND VGND VPWR VPWR sky130_fd_sc_hd__fill_2
Xg_row\[1\].g_col\[1\].pe__1341_ g_row\[1\].g_col\[1\].pe__1348_/A g_row\[1\].g_col\[1\].pe__2775_/A
+ VGND VGND VPWR VPWR g_row\[1\].g_col\[1\].pe__1342_/B sky130_fd_sc_hd__nand2_2
Xg_row\[0\].g_col\[0\].pe__2521_ g_row\[0\].g_col\[0\].pe__2521_/A1 g_row\[0\].g_col\[0\].pe__2406_/Y
+ g_row\[0\].g_col\[0\].pe__2517_/Y g_row\[0\].g_col\[0\].pe__2520_/X VGND VGND VPWR
+ VPWR g_row\[0\].g_col\[0\].pe__2522_/B sky130_fd_sc_hd__a22o_2
XFILLER_64_598 VGND VGND VPWR VPWR sky130_fd_sc_hd__fill_1
XTAP_TAPCELL_ROW_19_498 VGND VPWR sky130_fd_sc_hd__tapvpwrvgnd_1
Xg_row\[0\].g_col\[0\].pe__2452_ g_row\[0\].g_col\[0\].pe__2760_/Q g_row\[0\].g_col\[0\].pe__2452_/B
+ VGND VGND VPWR VPWR g_row\[0\].g_col\[0\].pe__2538_/A sky130_fd_sc_hd__xnor2_2
Xg_row\[0\].g_col\[0\].pe__1403_ g_row\[0\].g_col\[0\].pe__1403_/A1 g_row\[0\].g_col\[0\].pe__2686_/B
+ g_row\[0\].g_col\[0\].pe__1402_/X g_row\[0\].g_col\[0\].pe__1377_/Y VGND VGND VPWR
+ VPWR g_row\[0\].g_col\[0\].pe__1403_/X sky130_fd_sc_hd__o211a_2
XFILLER_20_624 VGND VGND VPWR VPWR sky130_fd_sc_hd__decap_3
XPHY_EDGE_ROW_88_Left_182 VGND VGND VPWR VPWR sky130_fd_sc_hd__decap_3
Xg_row\[0\].g_col\[0\].pe__2383_ g_row\[0\].g_col\[0\].pe__2383_/A VGND VGND VPWR
+ VPWR g_row\[0\].g_col\[0\].pe__2422_/A sky130_fd_sc_hd__inv_2
Xg_row\[0\].g_col\[1\].pe__1350_ g_row\[0\].g_col\[1\].pe__2760_/Q g_row\[0\].g_col\[1\].pe__1348_/B
+ g_row\[0\].g_col\[1\].pe__1348_/A VGND VGND VPWR VPWR g_row\[0\].g_col\[1\].pe__1351_/B
+ sky130_fd_sc_hd__o21ai_2
XTAP_TAPCELL_ROW_30_663 VGND VPWR sky130_fd_sc_hd__tapvpwrvgnd_1
XTAP_TAPCELL_ROW_76_1348 VGND VPWR sky130_fd_sc_hd__tapvpwrvgnd_1
Xg_row\[1\].g_col\[1\].pe__2726_ clkbuf_leaf_84_clk/X g_row\[1\].g_col\[1\].pe__2726_/D
+ VGND VGND VPWR VPWR g_row\[1\].g_col\[1\].pe__2726_/Q sky130_fd_sc_hd__dfxtp_2
XFILLER_87_624 VGND VGND VPWR VPWR sky130_fd_sc_hd__decap_3
XFILLER_87_646 VGND VGND VPWR VPWR sky130_fd_sc_hd__decap_3
Xg_row\[1\].g_col\[1\].pe__2657_ g_row\[1\].g_col\[1\].pe__2669_/A g_row\[1\].g_col\[1\].pe__2657_/B
+ VGND VGND VPWR VPWR g_row\[1\].g_col\[1\].pe__2657_/X sky130_fd_sc_hd__or2_2
Xg_row\[1\].g_col\[1\].pe__1608_ g_row\[1\].g_col\[1\].pe__1608_/A1 g_row\[1\].g_col\[1\].pe__2026_/B
+ g_row\[1\].g_col\[1\].pe__1449_/Y g_row\[1\].g_col\[1\].pe__2036_/B2 VGND VGND VPWR
+ VPWR g_row\[1\].g_col\[1\].pe__1609_/B sky130_fd_sc_hd__a22o_2
XFILLER_67_370 VGND VGND VPWR VPWR sky130_fd_sc_hd__fill_1
Xg_row\[1\].g_col\[1\].pe__2588_ g_row\[1\].g_col\[1\].pe__2592_/A g_row\[1\].g_col\[1\].pe__2588_/B
+ VGND VGND VPWR VPWR g_row\[1\].g_col\[1\].pe__2769_/D sky130_fd_sc_hd__and2_2
XFILLER_27_223 VGND VGND VPWR VPWR sky130_fd_sc_hd__fill_1
XFILLER_83_841 VGND VGND VPWR VPWR sky130_fd_sc_hd__fill_1
Xg_row\[0\].g_col\[1\].pe_hold2335 g_row\[0\].g_col\[1\].pe__2380_/X VGND VGND VPWR
+ VPWR g_row\[0\].g_col\[1\].pe__2381_/B sky130_fd_sc_hd__clkbuf_2
XFILLER_27_245 VGND VGND VPWR VPWR sky130_fd_sc_hd__decap_3
XFILLER_43_727 VGND VGND VPWR VPWR sky130_fd_sc_hd__fill_1
XTAP_TAPCELL_ROW_38_774 VGND VPWR sky130_fd_sc_hd__tapvpwrvgnd_1
Xg_row\[0\].g_col\[0\].pe__2719_ clkbuf_leaf_36_clk/X g_row\[0\].g_col\[0\].pe__2719_/D
+ VGND VGND VPWR VPWR hold2984/A sky130_fd_sc_hd__dfxtp_2
Xg_row\[0\].g_col\[1\].pe_hold2357 g_row\[0\].g_col\[1\].pe__2736_/Q VGND VGND VPWR
+ VPWR g_row\[0\].g_col\[1\].pe__1401_/A1 sky130_fd_sc_hd__clkbuf_2
Xg_row\[0\].g_col\[1\].pe_hold2346 g_row\[0\].g_col\[1\].pe__1403_/X VGND VGND VPWR
+ VPWR g_row\[0\].g_col\[1\].pe__2737_/D sky130_fd_sc_hd__clkbuf_2
Xg_row\[0\].g_col\[1\].pe__2735_ clkbuf_leaf_92_clk/X g_row\[0\].g_col\[1\].pe__2735_/D
+ VGND VGND VPWR VPWR g_row\[0\].g_col\[1\].pe__2735_/Q sky130_fd_sc_hd__dfxtp_2
XTAP_TAPCELL_ROW_38_785 VGND VPWR sky130_fd_sc_hd__tapvpwrvgnd_1
Xg_row\[0\].g_col\[1\].pe_hold2379 g_row\[0\].g_col\[1\].pe__2266_/Y VGND VGND VPWR
+ VPWR g_row\[0\].g_col\[1\].pe__2267_/B1 sky130_fd_sc_hd__clkbuf_2
Xg_row\[0\].g_col\[1\].pe__2666_ g_row\[0\].g_col\[1\].pe__2666_/A1 g_row\[0\].g_col\[1\].pe__2666_/A2
+ g_row\[0\].g_col\[1\].pe__2677_/B1 g_row\[0\].g_col\[1\].pe__2665_/X VGND VGND VPWR
+ VPWR g_row\[0\].g_col\[1\].pe__2666_/X sky130_fd_sc_hd__o211a_2
Xg_row\[0\].g_col\[1\].pe__1617_ g_row\[0\].g_col\[1\].pe__2704_/Q VGND VGND VPWR
+ VPWR g_row\[0\].g_col\[1\].pe__2125_/A sky130_fd_sc_hd__inv_2
XFILLER_11_624 VGND VGND VPWR VPWR sky130_fd_sc_hd__decap_3
XFILLER_23_484 VGND VGND VPWR VPWR sky130_fd_sc_hd__fill_2
XFILLER_23_495 VGND VGND VPWR VPWR sky130_fd_sc_hd__fill_1
Xg_row\[0\].g_col\[1\].pe__1548_ g_row\[0\].g_col\[1\].pe__1550_/A g_row\[0\].g_col\[1\].pe__1550_/B
+ VGND VGND VPWR VPWR g_row\[0\].g_col\[1\].pe__1830_/A sky130_fd_sc_hd__and2b_2
XFILLER_7_617 VGND VGND VPWR VPWR sky130_fd_sc_hd__decap_3
Xg_row\[0\].g_col\[1\].pe__1479_ g_row\[0\].g_col\[1\].pe__1479_/A g_row\[0\].g_col\[1\].pe__1479_/B
+ VGND VGND VPWR VPWR g_row\[0\].g_col\[1\].pe__1479_/Y sky130_fd_sc_hd__nor2_2
XFILLER_12_52 VGND VGND VPWR VPWR sky130_fd_sc_hd__fill_2
XFILLER_12_85 VGND VGND VPWR VPWR sky130_fd_sc_hd__fill_1
XFILLER_3_823 VGND VGND VPWR VPWR sky130_fd_sc_hd__decap_3
XFILLER_93_605 VGND VGND VPWR VPWR sky130_fd_sc_hd__decap_3
XFILLER_19_713 VGND VGND VPWR VPWR sky130_fd_sc_hd__fill_2
XFILLER_46_510 VGND VGND VPWR VPWR sky130_fd_sc_hd__decap_3
XFILLER_19_757 VGND VGND VPWR VPWR sky130_fd_sc_hd__decap_3
XPHY_EDGE_ROW_16_Right_16 VGND VGND VPWR VPWR sky130_fd_sc_hd__decap_3
XFILLER_34_749 VGND VGND VPWR VPWR sky130_fd_sc_hd__fill_1
Xg_row\[1\].g_col\[0\].pe__2090_ g_row\[1\].g_col\[0\].pe__2209_/A g_row\[1\].g_col\[0\].pe__2090_/B
+ VGND VGND VPWR VPWR g_row\[1\].g_col\[0\].pe__2091_/C sky130_fd_sc_hd__xnor2_2
XTAP_TAPCELL_ROW_16_446 VGND VPWR sky130_fd_sc_hd__tapvpwrvgnd_1
XTAP_TAPCELL_ROW_16_457 VGND VPWR sky130_fd_sc_hd__tapvpwrvgnd_1
Xg_row\[0\].g_col\[0\].pe_hold2002 g_row\[0\].g_col\[0\].pe_hold2159/X VGND VGND VPWR
+ VPWR g_row\[0\].g_col\[0\].pe__1392_/A sky130_fd_sc_hd__clkbuf_2
Xg_row\[0\].g_col\[0\].pe_hold2013 g_row\[0\].g_col\[0\].pe_hold3051/X VGND VGND VPWR
+ VPWR g_row\[0\].g_col\[0\].pe__2674_/D sky130_fd_sc_hd__clkbuf_2
Xg_row\[0\].g_col\[0\].pe_hold2024 g_row\[0\].g_col\[0\].pe_hold3043/X VGND VGND VPWR
+ VPWR g_row\[0\].g_col\[0\].pe_hold3044/A sky130_fd_sc_hd__clkbuf_2
XTAP_TAPCELL_ROW_60_1105 VGND VPWR sky130_fd_sc_hd__tapvpwrvgnd_1
XTAP_TAPCELL_ROW_60_1116 VGND VPWR sky130_fd_sc_hd__tapvpwrvgnd_1
XPHY_EDGE_ROW_25_Right_25 VGND VGND VPWR VPWR sky130_fd_sc_hd__decap_3
X_279_ _279_/CLK _279_/D VGND VGND VPWR VPWR _279_/Q sky130_fd_sc_hd__dfxtp_2
Xg_row\[1\].g_col\[0\].pe__1943_ g_row\[1\].g_col\[0\].pe__1951_/A g_row\[1\].g_col\[0\].pe__1951_/B
+ VGND VGND VPWR VPWR g_row\[1\].g_col\[0\].pe__2151_/A sky130_fd_sc_hd__xnor2_2
XFILLER_6_661 VGND VGND VPWR VPWR sky130_fd_sc_hd__decap_3
Xg_row\[1\].g_col\[1\].pe__1890_ g_row\[1\].g_col\[1\].pe__1894_/A g_row\[1\].g_col\[1\].pe__1894_/B
+ VGND VGND VPWR VPWR g_row\[1\].g_col\[1\].pe__1891_/B sky130_fd_sc_hd__xor2_2
Xg_row\[1\].g_col\[0\].pe__1874_ g_row\[1\].g_col\[0\].pe__1874_/A g_row\[1\].g_col\[0\].pe__1874_/B
+ VGND VGND VPWR VPWR g_row\[1\].g_col\[0\].pe__1932_/B sky130_fd_sc_hd__xor2_2
XFILLER_5_182 VGND VGND VPWR VPWR sky130_fd_sc_hd__fill_2
XFILLER_45_3 VGND VGND VPWR VPWR sky130_fd_sc_hd__fill_1
XFILLER_5_193 VGND VGND VPWR VPWR sky130_fd_sc_hd__fill_1
XTAP_TAPCELL_ROW_58_1078 VGND VPWR sky130_fd_sc_hd__tapvpwrvgnd_1
Xhold3209 hold3209/A VGND VGND VPWR VPWR hold3209/X sky130_fd_sc_hd__clkbuf_2
XFILLER_69_624 VGND VGND VPWR VPWR sky130_fd_sc_hd__fill_1
Xhold2508 _257_/Y VGND VGND VPWR VPWR hold2508/X sky130_fd_sc_hd__clkbuf_2
Xhold2519 hold3227/X VGND VGND VPWR VPWR _147_/B_N sky130_fd_sc_hd__clkbuf_2
XTAP_TAPCELL_ROW_71_1278 VGND VPWR sky130_fd_sc_hd__tapvpwrvgnd_1
Xg_row\[0\].g_col\[0\].pe__1952_ g_row\[0\].g_col\[0\].pe__1952_/A g_row\[0\].g_col\[0\].pe__1938_/A
+ VGND VGND VPWR VPWR g_row\[0\].g_col\[0\].pe__1952_/X sky130_fd_sc_hd__or2b_2
XFILLER_68_178 VGND VGND VPWR VPWR sky130_fd_sc_hd__decap_3
Xg_row\[0\].g_col\[0\].pe__1883_ g_row\[0\].g_col\[0\].pe__1883_/A g_row\[0\].g_col\[0\].pe__1883_/B
+ VGND VGND VPWR VPWR g_row\[0\].g_col\[0\].pe__1883_/X sky130_fd_sc_hd__or2_2
Xg_row\[1\].g_col\[1\].pe__2442_ g_row\[1\].g_col\[1\].pe__2443_/B g_row\[1\].g_col\[1\].pe__2762_/Q
+ VGND VGND VPWR VPWR g_row\[1\].g_col\[1\].pe__2444_/A sky130_fd_sc_hd__and2b_2
Xg_row\[1\].g_col\[0\].pe__2426_ g_row\[1\].g_col\[0\].pe__2752_/Q g_row\[1\].g_col\[0\].pe__2426_/B
+ VGND VGND VPWR VPWR g_row\[1\].g_col\[0\].pe__2427_/B sky130_fd_sc_hd__xor2_2
XFILLER_49_370 VGND VGND VPWR VPWR sky130_fd_sc_hd__fill_1
XFILLER_65_841 VGND VGND VPWR VPWR sky130_fd_sc_hd__fill_1
XPHY_EDGE_ROW_34_Right_34 VGND VGND VPWR VPWR sky130_fd_sc_hd__decap_3
Xg_row\[1\].g_col\[1\].pe__2373_ g_row\[1\].g_col\[1\].pe__2337_/B g_row\[1\].g_col\[1\].pe__2368_/B
+ g_row\[1\].g_col\[1\].pe__2350_/B g_row\[1\].g_col\[1\].pe__2350_/A VGND VGND VPWR
+ VPWR g_row\[1\].g_col\[1\].pe__2385_/B sky130_fd_sc_hd__a22o_2
XFILLER_83_159 VGND VGND VPWR VPWR sky130_fd_sc_hd__decap_3
Xg_row\[1\].g_col\[0\].pe__2357_ g_row\[1\].g_col\[0\].pe__2329_/A g_row\[1\].g_col\[0\].pe__2330_/X
+ g_row\[1\].g_col\[0\].pe__2329_/B VGND VGND VPWR VPWR g_row\[1\].g_col\[0\].pe__2358_/B
+ sky130_fd_sc_hd__a21o_2
XFILLER_25_727 VGND VGND VPWR VPWR sky130_fd_sc_hd__fill_1
XFILLER_52_524 VGND VGND VPWR VPWR sky130_fd_sc_hd__decap_3
XFILLER_64_373 VGND VGND VPWR VPWR sky130_fd_sc_hd__fill_2
Xg_row\[0\].g_col\[0\].pe__2504_ g_row\[0\].g_col\[0\].pe__2495_/A g_row\[0\].g_col\[0\].pe__2471_/C
+ g_row\[0\].g_col\[0\].pe__2471_/A VGND VGND VPWR VPWR g_row\[0\].g_col\[0\].pe__2504_/X
+ sky130_fd_sc_hd__a21o_2
Xg_row\[1\].g_col\[0\].pe__2288_ g_row\[1\].g_col\[0\].pe__2288_/A g_row\[1\].g_col\[0\].pe__2288_/B
+ VGND VGND VPWR VPWR g_row\[1\].g_col\[0\].pe__2288_/Y sky130_fd_sc_hd__nand2_2
Xg_row\[0\].g_col\[1\].pe__2520_ g_row\[0\].g_col\[1\].pe__2499_/B g_row\[0\].g_col\[1\].pe__2519_/Y
+ g_row\[0\].g_col\[1\].pe__2559_/A VGND VGND VPWR VPWR g_row\[0\].g_col\[1\].pe__2520_/X
+ sky130_fd_sc_hd__a21o_2
XFILLER_52_557 VGND VGND VPWR VPWR sky130_fd_sc_hd__fill_1
XTAP_TAPCELL_ROW_35_733 VGND VPWR sky130_fd_sc_hd__tapvpwrvgnd_1
Xg_row\[0\].g_col\[1\].pe__2451_ g_row\[0\].g_col\[1\].pe__2451_/A g_row\[0\].g_col\[1\].pe__2451_/B
+ VGND VGND VPWR VPWR g_row\[0\].g_col\[1\].pe__2452_/B sky130_fd_sc_hd__xnor2_2
Xg_row\[0\].g_col\[0\].pe__2435_ g_row\[0\].g_col\[0\].pe__2472_/B g_row\[0\].g_col\[0\].pe__2765_/Q
+ VGND VGND VPWR VPWR g_row\[0\].g_col\[0\].pe__2489_/B sky130_fd_sc_hd__or2b_2
Xg_row\[0\].g_col\[1\].pe__1402_ g_row\[0\].g_col\[1\].pe__2672_/C g_row\[0\].g_col\[1\].pe__1402_/B
+ VGND VGND VPWR VPWR g_row\[0\].g_col\[1\].pe__1402_/X sky130_fd_sc_hd__or2_2
XFILLER_20_421 VGND VGND VPWR VPWR sky130_fd_sc_hd__decap_3
XFILLER_32_270 VGND VGND VPWR VPWR sky130_fd_sc_hd__decap_3
Xg_row\[0\].g_col\[0\].pe__2366_ g_row\[0\].g_col\[0\].pe__2343_/A g_row\[0\].g_col\[0\].pe__2365_/A
+ g_row\[0\].g_col\[0\].pe__2365_/B VGND VGND VPWR VPWR g_row\[0\].g_col\[0\].pe__2366_/X
+ sky130_fd_sc_hd__a21o_2
XPHY_EDGE_ROW_43_Right_43 VGND VGND VPWR VPWR sky130_fd_sc_hd__decap_3
Xg_row\[0\].g_col\[0\].pe__2297_ g_row\[0\].g_col\[0\].pe__2297_/A g_row\[0\].g_col\[0\].pe__2330_/C
+ VGND VGND VPWR VPWR g_row\[0\].g_col\[0\].pe__2305_/A sky130_fd_sc_hd__xor2_2
XFILLER_0_804 VGND VGND VPWR VPWR sky130_fd_sc_hd__decap_3
XFILLER_58_37 VGND VGND VPWR VPWR sky130_fd_sc_hd__decap_3
XFILLER_59_134 VGND VGND VPWR VPWR sky130_fd_sc_hd__fill_1
Xg_row\[1\].g_col\[1\].pe__2709_ clkbuf_leaf_93_clk/X g_row\[1\].g_col\[1\].pe__2709_/D
+ VGND VGND VPWR VPWR g_row\[1\].g_col\[1\].pe__2709_/Q sky130_fd_sc_hd__dfxtp_2
XFILLER_87_487 VGND VGND VPWR VPWR sky130_fd_sc_hd__fill_2
XPHY_EDGE_ROW_52_Right_52 VGND VGND VPWR VPWR sky130_fd_sc_hd__decap_3
XTAP_TAPCELL_ROW_89_1539 VGND VPWR sky130_fd_sc_hd__tapvpwrvgnd_1
XFILLER_74_126 VGND VGND VPWR VPWR sky130_fd_sc_hd__fill_1
XFILLER_55_340 VGND VGND VPWR VPWR sky130_fd_sc_hd__decap_3
Xg_row\[0\].g_col\[1\].pe_hold2132 g_row\[0\].g_col\[1\].pe__1384_/X VGND VGND VPWR
+ VPWR g_row\[0\].g_col\[1\].pe__2728_/D sky130_fd_sc_hd__clkbuf_2
XFILLER_83_671 VGND VGND VPWR VPWR sky130_fd_sc_hd__fill_1
Xg_row\[0\].g_col\[1\].pe_hold2187 g_row\[0\].g_col\[1\].pe__2642_/X VGND VGND VPWR
+ VPWR g_row\[0\].g_col\[1\].pe__2706_/D sky130_fd_sc_hd__clkbuf_2
Xg_row\[0\].g_col\[1\].pe__2718_ _327_/CLK g_row\[0\].g_col\[1\].pe__2718_/D VGND
+ VGND VPWR VPWR hold1976/A sky130_fd_sc_hd__dfxtp_2
XFILLER_43_557 VGND VGND VPWR VPWR sky130_fd_sc_hd__decap_3
XTAP_TAPCELL_ROW_13_405 VGND VPWR sky130_fd_sc_hd__tapvpwrvgnd_1
Xg_row\[0\].g_col\[1\].pe__2649_ g_row\[0\].g_col\[1\].pe__2661_/A hold2200/X VGND
+ VGND VPWR VPWR g_row\[0\].g_col\[1\].pe__2649_/X sky130_fd_sc_hd__or2_2
XFILLER_51_590 VGND VGND VPWR VPWR sky130_fd_sc_hd__fill_2
XPHY_EDGE_ROW_61_Right_61 VGND VGND VPWR VPWR sky130_fd_sc_hd__decap_3
XFILLER_11_454 VGND VGND VPWR VPWR sky130_fd_sc_hd__fill_2
Xg_row\[0\].g_col\[0\].pe_place872 g_row\[0\].g_col\[0\].pe__1449_/Y VGND VGND VPWR
+ VPWR g_row\[0\].g_col\[0\].pe__1738_/B1 sky130_fd_sc_hd__buf_6
XFILLER_3_697 VGND VGND VPWR VPWR sky130_fd_sc_hd__decap_3
XFILLER_78_421 VGND VGND VPWR VPWR sky130_fd_sc_hd__decap_3
XPHY_EDGE_ROW_70_Right_70 VGND VGND VPWR VPWR sky130_fd_sc_hd__decap_3
Xg_row\[1\].g_col\[0\].pe__1590_ g_row\[1\].g_col\[0\].pe__1594_/A g_row\[1\].g_col\[0\].pe__1594_/B
+ VGND VGND VPWR VPWR g_row\[1\].g_col\[0\].pe__1591_/B sky130_fd_sc_hd__xor2_2
XFILLER_93_413 VGND VGND VPWR VPWR sky130_fd_sc_hd__decap_3
XFILLER_17_7 VGND VGND VPWR VPWR sky130_fd_sc_hd__fill_2
XFILLER_47_841 VGND VGND VPWR VPWR sky130_fd_sc_hd__fill_1
XFILLER_65_137 VGND VGND VPWR VPWR sky130_fd_sc_hd__decap_3
XFILLER_66_638 VGND VGND VPWR VPWR sky130_fd_sc_hd__decap_3
Xg_row\[1\].g_col\[0\].pe__2211_ g_row\[1\].g_col\[0\].pe__2211_/A VGND VGND VPWR
+ VPWR g_row\[1\].g_col\[0\].pe__2253_/B sky130_fd_sc_hd__inv_2
XFILLER_19_543 VGND VGND VPWR VPWR sky130_fd_sc_hd__decap_3
XFILLER_34_513 VGND VGND VPWR VPWR sky130_fd_sc_hd__decap_3
Xg_row\[1\].g_col\[0\].pe__2142_ g_row\[1\].g_col\[0\].pe__2142_/A g_row\[1\].g_col\[0\].pe__2187_/B
+ VGND VGND VPWR VPWR g_row\[1\].g_col\[0\].pe__2143_/B sky130_fd_sc_hd__xnor2_2
XFILLER_46_395 VGND VGND VPWR VPWR sky130_fd_sc_hd__fill_2
Xg_row\[1\].g_col\[0\].pe__2073_ place1094/A g_row\[1\].g_col\[0\].pe__1558_/B g_row\[1\].g_col\[0\].pe__2177_/B1
+ g_row\[1\].g_col\[0\].pe__2612_/B VGND VGND VPWR VPWR g_row\[1\].g_col\[0\].pe__2136_/A
+ sky130_fd_sc_hd__a22o_2
XFILLER_15_760 VGND VGND VPWR VPWR sky130_fd_sc_hd__decap_3
XFILLER_15_782 VGND VGND VPWR VPWR sky130_fd_sc_hd__fill_2
Xg_row\[0\].g_col\[0\].pe__2220_ g_row\[0\].g_col\[0\].pe__2220_/A g_row\[0\].g_col\[0\].pe__2220_/B
+ VGND VGND VPWR VPWR g_row\[0\].g_col\[0\].pe__2221_/B sky130_fd_sc_hd__xor2_2
XFILLER_9_97 VGND VGND VPWR VPWR sky130_fd_sc_hd__decap_3
Xg_row\[0\].g_col\[0\].pe__2151_ g_row\[0\].g_col\[0\].pe__2151_/A g_row\[0\].g_col\[0\].pe__2151_/B
+ g_row\[0\].g_col\[0\].pe__2150_/X VGND VGND VPWR VPWR g_row\[0\].g_col\[0\].pe__2151_/X
+ sky130_fd_sc_hd__or3b_4
Xg_row\[0\].g_col\[0\].pe__2082_ g_row\[0\].g_col\[0\].pe__2081_/B g_row\[0\].g_col\[0\].pe__2081_/C
+ g_row\[0\].g_col\[0\].pe__2167_/A VGND VGND VPWR VPWR g_row\[0\].g_col\[0\].pe__2087_/B
+ sky130_fd_sc_hd__a21bo_2
Xg_row\[1\].g_col\[1\].pe__1942_ g_row\[1\].g_col\[1\].pe__2005_/A g_row\[1\].g_col\[1\].pe__1942_/B
+ VGND VGND VPWR VPWR g_row\[1\].g_col\[1\].pe__1951_/B sky130_fd_sc_hd__nor2_2
Xg_row\[1\].g_col\[0\].pe__1926_ g_row\[1\].g_col\[0\].pe__1980_/B g_row\[1\].g_col\[0\].pe__1980_/C
+ VGND VGND VPWR VPWR g_row\[1\].g_col\[0\].pe__1927_/B sky130_fd_sc_hd__or2_4
Xg_row\[1\].g_col\[1\].pe__1873_ g_row\[1\].g_col\[1\].pe__2125_/C g_row\[1\].g_col\[1\].pe__1873_/B
+ VGND VGND VPWR VPWR g_row\[1\].g_col\[1\].pe__1874_/B sky130_fd_sc_hd__xor2_2
XTAP_TAPCELL_ROW_73_1307 VGND VPWR sky130_fd_sc_hd__tapvpwrvgnd_1
Xg_row\[1\].g_col\[0\].pe__1857_ g_row\[1\].g_col\[0\].pe__1857_/A g_row\[1\].g_col\[0\].pe__1857_/B
+ VGND VGND VPWR VPWR g_row\[1\].g_col\[0\].pe__1858_/B sky130_fd_sc_hd__or2_2
Xg_row\[1\].g_col\[0\].pe__1788_ g_row\[1\].g_col\[0\].pe__1789_/A g_row\[1\].g_col\[0\].pe__1789_/B
+ VGND VGND VPWR VPWR g_row\[1\].g_col\[0\].pe__1795_/B sky130_fd_sc_hd__nand2_2
Xg_row\[0\].g_col\[0\].pe__1935_ g_row\[0\].g_col\[0\].pe__1935_/A g_row\[0\].g_col\[0\].pe__1935_/B
+ VGND VGND VPWR VPWR g_row\[0\].g_col\[0\].pe__1938_/A sky130_fd_sc_hd__xnor2_2
Xhold1604 hold3552/X VGND VGND VPWR VPWR hold2759/A sky130_fd_sc_hd__clkbuf_2
Xhold1615 hold3560/X VGND VGND VPWR VPWR hold3561/A sky130_fd_sc_hd__clkbuf_2
Xhold1626 hold2796/X VGND VGND VPWR VPWR hold2797/A sky130_fd_sc_hd__clkbuf_2
Xg_row\[0\].g_col\[1\].pe__1951_ g_row\[0\].g_col\[1\].pe__1951_/A g_row\[0\].g_col\[1\].pe__1951_/B
+ VGND VGND VPWR VPWR g_row\[0\].g_col\[1\].pe__2009_/C sky130_fd_sc_hd__and2_2
XFILLER_38_841 VGND VGND VPWR VPWR sky130_fd_sc_hd__fill_1
XFILLER_56_126 VGND VGND VPWR VPWR sky130_fd_sc_hd__fill_1
Xhold1637 hold1656/X VGND VGND VPWR VPWR hold1657/A sky130_fd_sc_hd__clkbuf_2
Xg_row\[1\].g_col\[1\].pe__2425_ g_row\[1\].g_col\[1\].pe__2425_/A g_row\[1\].g_col\[1\].pe__2425_/B
+ VGND VGND VPWR VPWR g_row\[1\].g_col\[1\].pe__2508_/A sky130_fd_sc_hd__nor2_2
Xg_row\[0\].g_col\[1\].pe__1882_ g_row\[0\].g_col\[1\].pe__1882_/A g_row\[0\].g_col\[1\].pe__1882_/B
+ VGND VGND VPWR VPWR g_row\[0\].g_col\[1\].pe__1885_/A sky130_fd_sc_hd__xor2_2
XFILLER_65_660 VGND VGND VPWR VPWR sky130_fd_sc_hd__decap_3
Xg_row\[0\].g_col\[0\].pe__1866_ place1210/X g_row\[0\].g_col\[0\].pe__1657_/B g_row\[0\].g_col\[0\].pe__2247_/B1
+ g_row\[0\].g_col\[0\].pe__1866_/B2 VGND VGND VPWR VPWR g_row\[0\].g_col\[0\].pe__1867_/B
+ sky130_fd_sc_hd__a22o_2
Xg_row\[1\].g_col\[0\].pe__2409_ g_row\[1\].g_col\[0\].pe__2775_/A g_row\[1\].g_col\[0\].pe__2410_/B
+ VGND VGND VPWR VPWR g_row\[1\].g_col\[0\].pe__2519_/A sky130_fd_sc_hd__nor2_2
XFILLER_65_671 VGND VGND VPWR VPWR sky130_fd_sc_hd__fill_1
Xg_row\[0\].g_col\[0\].pe__1797_ g_row\[0\].g_col\[0\].pe__1797_/A g_row\[0\].g_col\[0\].pe__1797_/B
+ VGND VGND VPWR VPWR g_row\[0\].g_col\[0\].pe__1807_/A sky130_fd_sc_hd__and2_4
Xg_row\[1\].g_col\[1\].pe__2356_ g_row\[1\].g_col\[1\].pe__2356_/A g_row\[1\].g_col\[1\].pe__2356_/B
+ VGND VGND VPWR VPWR g_row\[1\].g_col\[1\].pe__2377_/A sky130_fd_sc_hd__nor2_2
XFILLER_25_535 VGND VGND VPWR VPWR sky130_fd_sc_hd__decap_3
XTAP_TAPCELL_ROW_84_1469 VGND VPWR sky130_fd_sc_hd__tapvpwrvgnd_1
Xclkbuf_leaf_91_clk clkload1/A VGND VGND VPWR VPWR clkbuf_leaf_91_clk/X sky130_fd_sc_hd__clkbuf_16
Xg_row\[1\].g_col\[1\].pe__2287_ g_row\[1\].g_col\[1\].pe__2287_/A g_row\[1\].g_col\[1\].pe__2309_/B
+ VGND VGND VPWR VPWR g_row\[1\].g_col\[1\].pe__2291_/A sky130_fd_sc_hd__xnor2_2
Xg_row\[0\].g_col\[1\].pe__2503_ g_row\[0\].g_col\[1\].pe__2579_/A g_row\[0\].g_col\[1\].pe__2503_/B
+ g_row\[0\].g_col\[1\].pe__2585_/B g_row\[0\].g_col\[1\].pe__2502_/X VGND VGND VPWR
+ VPWR g_row\[0\].g_col\[1\].pe__2506_/C sky130_fd_sc_hd__or4b_2
Xg_row\[0\].g_col\[0\].pe__2418_ g_row\[0\].g_col\[0\].pe__2450_/A1 g_row\[0\].g_col\[0\].pe__2749_/Q
+ g_row\[0\].g_col\[0\].pe__2432_/B VGND VGND VPWR VPWR g_row\[0\].g_col\[0\].pe__2430_/B
+ sky130_fd_sc_hd__a21o_2
Xg_row\[0\].g_col\[1\].pe__2434_ g_row\[0\].g_col\[1\].pe__2748_/Q g_row\[0\].g_col\[1\].pe__2434_/B
+ VGND VGND VPWR VPWR g_row\[0\].g_col\[1\].pe__2472_/B sky130_fd_sc_hd__xnor2_2
XFILLER_21_752 VGND VGND VPWR VPWR sky130_fd_sc_hd__fill_2
Xg_row\[0\].g_col\[1\].pe__2365_ g_row\[0\].g_col\[1\].pe__2365_/A g_row\[0\].g_col\[1\].pe__2365_/B
+ VGND VGND VPWR VPWR g_row\[0\].g_col\[1\].pe__2365_/X sky130_fd_sc_hd__and2_2
Xg_row\[0\].g_col\[0\].pe__2349_ g_row\[0\].g_col\[0\].pe__2368_/B g_row\[0\].g_col\[0\].pe__2349_/B
+ VGND VGND VPWR VPWR g_row\[0\].g_col\[0\].pe__2350_/B sky130_fd_sc_hd__xor2_2
Xg_row\[0\].g_col\[0\].pe_place1229 g_row\[0\].g_col\[0\].pe__1377_/Y VGND VGND VPWR
+ VPWR g_row\[0\].g_col\[0\].pe__2633_/B1 sky130_fd_sc_hd__buf_6
Xg_row\[0\].g_col\[1\].pe__2296_ g_row\[0\].g_col\[1\].pe__2329_/A g_row\[0\].g_col\[1\].pe__2296_/B
+ VGND VGND VPWR VPWR g_row\[0\].g_col\[1\].pe__2330_/C sky130_fd_sc_hd__nand2_2
Xg_row\[1\].g_col\[1\].pe_hold2825 g_row\[1\].g_col\[1\].pe_hold2825/A VGND VGND VPWR
+ VPWR g_row\[1\].g_col\[1\].pe__2710_/D sky130_fd_sc_hd__clkbuf_2
XFILLER_79_229 VGND VGND VPWR VPWR sky130_fd_sc_hd__fill_1
Xg_row\[1\].g_col\[1\].pe_hold2869 g_row\[1\].g_col\[1\].pe__2665_/X VGND VGND VPWR
+ VPWR g_row\[1\].g_col\[1\].pe__2666_/C1 sky130_fd_sc_hd__clkbuf_2
Xhold3551 hold3551/A VGND VGND VPWR VPWR hold3551/X sky130_fd_sc_hd__clkbuf_2
Xhold3540 hold3540/A VGND VGND VPWR VPWR hold3540/X sky130_fd_sc_hd__clkbuf_2
XFILLER_48_605 VGND VGND VPWR VPWR sky130_fd_sc_hd__decap_3
Xhold3584 hold3584/A VGND VGND VPWR VPWR hold3584/X sky130_fd_sc_hd__clkbuf_2
Xhold3573 hold3573/A VGND VGND VPWR VPWR hold3573/X sky130_fd_sc_hd__clkbuf_2
Xhold3562 hold3562/A VGND VGND VPWR VPWR hold3562/X sky130_fd_sc_hd__clkbuf_2
XFILLER_29_841 VGND VGND VPWR VPWR sky130_fd_sc_hd__fill_1
XFILLER_90_405 VGND VGND VPWR VPWR sky130_fd_sc_hd__decap_3
XFILLER_28_373 VGND VGND VPWR VPWR sky130_fd_sc_hd__fill_1
XFILLER_16_557 VGND VGND VPWR VPWR sky130_fd_sc_hd__decap_3
XFILLER_71_630 VGND VGND VPWR VPWR sky130_fd_sc_hd__decap_3
Xclkbuf_leaf_82_clk clkbuf_4_8_0_clk/X VGND VGND VPWR VPWR clkbuf_leaf_82_clk/X sky130_fd_sc_hd__clkbuf_16
XFILLER_31_505 VGND VGND VPWR VPWR sky130_fd_sc_hd__decap_3
XTAP_TAPCELL_ROW_26_596 VGND VPWR sky130_fd_sc_hd__tapvpwrvgnd_1
XFILLER_12_752 VGND VGND VPWR VPWR sky130_fd_sc_hd__decap_3
XFILLER_12_774 VGND VGND VPWR VPWR sky130_fd_sc_hd__decap_3
XFILLER_34_83 VGND VGND VPWR VPWR sky130_fd_sc_hd__fill_1
XFILLER_8_701 VGND VGND VPWR VPWR sky130_fd_sc_hd__decap_3
Xg_row\[0\].g_col\[1\].pe_place1141 g_row\[0\].g_col\[1\].pe__2625_/B VGND VGND VPWR
+ VPWR g_row\[0\].g_col\[1\].pe__2030_/A sky130_fd_sc_hd__buf_6
Xg_row\[0\].g_col\[1\].pe_place1130 g_row\[0\].g_col\[1\].pe__2726_/Q VGND VGND VPWR
+ VPWR g_row\[0\].g_col\[1\].pe__2686_/A sky130_fd_sc_hd__buf_6
Xg_row\[0\].g_col\[1\].pe_place1163 g_row\[0\].g_col\[1\].pe__2690_/Q VGND VGND VPWR
+ VPWR g_row\[0\].g_col\[1\].pe__2599_/B sky130_fd_sc_hd__buf_6
Xg_row\[0\].g_col\[1\].pe_place1152 g_row\[0\].g_col\[1\].pe__2696_/Q VGND VGND VPWR
+ VPWR g_row\[0\].g_col\[1\].pe__2138_/B2 sky130_fd_sc_hd__buf_6
XFILLER_50_82 VGND VGND VPWR VPWR sky130_fd_sc_hd__fill_2
Xg_row\[1\].g_col\[0\].pe__2760_ clkbuf_leaf_58_clk/X g_row\[1\].g_col\[0\].pe__2760_/D
+ VGND VGND VPWR VPWR g_row\[1\].g_col\[0\].pe__2760_/Q sky130_fd_sc_hd__dfxtp_2
Xg_row\[1\].g_col\[0\].pe__2691_ _304_/CLK g_row\[1\].g_col\[0\].pe__2691_/D VGND
+ VGND VPWR VPWR place1104/A sky130_fd_sc_hd__dfxtp_2
Xg_row\[1\].g_col\[0\].pe__1711_ g_row\[1\].g_col\[0\].pe__1733_/A g_row\[1\].g_col\[0\].pe__1711_/B
+ VGND VGND VPWR VPWR g_row\[1\].g_col\[0\].pe__1736_/B sky130_fd_sc_hd__xor2_2
XTAP_TAPCELL_ROW_55_1037 VGND VPWR sky130_fd_sc_hd__tapvpwrvgnd_1
Xg_row\[1\].g_col\[0\].pe__1642_ g_row\[1\].g_col\[0\].pe__1642_/A g_row\[1\].g_col\[0\].pe__1642_/B
+ VGND VGND VPWR VPWR g_row\[1\].g_col\[0\].pe__1648_/A sky130_fd_sc_hd__xnor2_2
Xg_row\[1\].g_col\[0\].pe__1573_ g_row\[1\].g_col\[0\].pe__1642_/A g_row\[1\].g_col\[0\].pe__1573_/B
+ VGND VGND VPWR VPWR g_row\[1\].g_col\[0\].pe__1626_/A sky130_fd_sc_hd__xnor2_2
Xg_row\[0\].g_col\[0\].pe__1720_ g_row\[0\].g_col\[0\].pe__1742_/B g_row\[0\].g_col\[0\].pe__1743_/B
+ g_row\[0\].g_col\[0\].pe__1719_/Y VGND VGND VPWR VPWR g_row\[0\].g_col\[0\].pe__1723_/A
+ sky130_fd_sc_hd__a21o_2
Xg_row\[1\].g_col\[0\].pe_hold1824 g_row\[1\].g_col\[0\].pe__2760_/Q VGND VGND VPWR
+ VPWR g_row\[1\].g_col\[0\].pe__2541_/A1 sky130_fd_sc_hd__clkbuf_2
Xg_row\[1\].g_col\[1\].pe__2210_ g_row\[1\].g_col\[1\].pe__2210_/A g_row\[1\].g_col\[1\].pe__2210_/B
+ VGND VGND VPWR VPWR g_row\[1\].g_col\[1\].pe__2211_/A sky130_fd_sc_hd__xor2_2
Xg_row\[1\].g_col\[0\].pe_hold1868 g_row\[1\].g_col\[0\].pe_hold2957/X VGND VGND VPWR
+ VPWR g_row\[1\].g_col\[0\].pe_hold2958/A sky130_fd_sc_hd__clkbuf_2
Xg_row\[1\].g_col\[0\].pe_hold1857 g_row\[1\].g_col\[0\].pe__2604_/X VGND VGND VPWR
+ VPWR g_row\[1\].g_col\[0\].pe__2691_/D sky130_fd_sc_hd__clkbuf_2
XFILLER_19_373 VGND VGND VPWR VPWR sky130_fd_sc_hd__fill_2
XFILLER_75_90 VGND VGND VPWR VPWR sky130_fd_sc_hd__fill_1
Xg_row\[0\].g_col\[0\].pe__1651_ g_row\[0\].g_col\[0\].pe__1660_/A g_row\[0\].g_col\[0\].pe__1660_/B
+ VGND VGND VPWR VPWR g_row\[0\].g_col\[0\].pe__1693_/A sky130_fd_sc_hd__xor2_2
Xclkbuf_leaf_73_clk clkload4/A VGND VGND VPWR VPWR _303_/CLK sky130_fd_sc_hd__clkbuf_16
Xg_row\[0\].g_col\[0\].pe__1582_ g_row\[0\].g_col\[0\].pe__1630_/B g_row\[0\].g_col\[0\].pe__1582_/B
+ VGND VGND VPWR VPWR g_row\[0\].g_col\[0\].pe__1583_/B sky130_fd_sc_hd__xnor2_2
Xg_row\[1\].g_col\[1\].pe__2141_ g_row\[1\].g_col\[1\].pe__2174_/A g_row\[1\].g_col\[1\].pe__2174_/B
+ VGND VGND VPWR VPWR g_row\[1\].g_col\[1\].pe__2187_/B sky130_fd_sc_hd__xor2_2
Xg_row\[1\].g_col\[0\].pe__2125_ g_row\[1\].g_col\[0\].pe__2125_/A g_row\[1\].g_col\[0\].pe__2729_/Q
+ g_row\[1\].g_col\[0\].pe__2125_/C VGND VGND VPWR VPWR g_row\[1\].g_col\[0\].pe__2125_/X
+ sky130_fd_sc_hd__or3_2
Xg_row\[1\].g_col\[1\].pe__2072_ g_row\[1\].g_col\[1\].pe__2038_/B g_row\[1\].g_col\[1\].pe__2038_/C
+ g_row\[1\].g_col\[1\].pe__2038_/A VGND VGND VPWR VPWR g_row\[1\].g_col\[1\].pe__2077_/A
+ sky130_fd_sc_hd__a21boi_2
XFILLER_15_590 VGND VGND VPWR VPWR sky130_fd_sc_hd__fill_1
XFILLER_22_549 VGND VGND VPWR VPWR sky130_fd_sc_hd__decap_3
XFILLER_61_173 VGND VGND VPWR VPWR sky130_fd_sc_hd__decap_3
XTAP_TAPCELL_ROW_45_883 VGND VPWR sky130_fd_sc_hd__tapvpwrvgnd_1
XTAP_TAPCELL_ROW_66_1199 VGND VPWR sky130_fd_sc_hd__tapvpwrvgnd_1
Xg_row\[1\].g_col\[0\].pe__2056_ g_row\[1\].g_col\[0\].pe__1997_/A g_row\[1\].g_col\[0\].pe__1997_/B
+ g_row\[1\].g_col\[0\].pe__2055_/Y VGND VGND VPWR VPWR g_row\[1\].g_col\[0\].pe__2068_/B
+ sky130_fd_sc_hd__a21oi_2
Xg_row\[0\].g_col\[0\].pe__2203_ g_row\[0\].g_col\[0\].pe__2186_/B g_row\[0\].g_col\[0\].pe__2203_/B
+ VGND VGND VPWR VPWR g_row\[0\].g_col\[0\].pe__2228_/A sky130_fd_sc_hd__and2b_2
XPHY_EDGE_ROW_15_Left_109 VGND VGND VPWR VPWR sky130_fd_sc_hd__decap_3
Xg_row\[0\].g_col\[0\].pe__2134_ g_row\[0\].g_col\[0\].pe__2222_/A g_row\[0\].g_col\[0\].pe__2184_/B
+ g_row\[0\].g_col\[0\].pe__2184_/C VGND VGND VPWR VPWR g_row\[0\].g_col\[0\].pe__2135_/B
+ sky130_fd_sc_hd__nand3b_2
Xg_row\[0\].g_col\[1\].pe__2150_ g_row\[0\].g_col\[1\].pe__2111_/A g_row\[0\].g_col\[1\].pe__2153_/C
+ g_row\[0\].g_col\[1\].pe__2150_/C VGND VGND VPWR VPWR g_row\[0\].g_col\[1\].pe__2150_/X
+ sky130_fd_sc_hd__and3b_2
Xg_row\[0\].g_col\[1\].pe__2081_ g_row\[0\].g_col\[1\].pe__1459_/C g_row\[0\].g_col\[1\].pe__2081_/B
+ g_row\[0\].g_col\[1\].pe__2081_/C VGND VGND VPWR VPWR g_row\[0\].g_col\[1\].pe__2087_/A
+ sky130_fd_sc_hd__nand3b_2
Xg_row\[0\].g_col\[0\].pe__2065_ g_row\[0\].g_col\[0\].pe__2065_/A VGND VGND VPWR
+ VPWR g_row\[0\].g_col\[0\].pe__2445_/A sky130_fd_sc_hd__inv_2
Xg_row\[1\].g_col\[1\].pe__1925_ g_row\[1\].g_col\[1\].pe__1924_/B g_row\[1\].g_col\[1\].pe__1924_/C
+ g_row\[1\].g_col\[1\].pe__2094_/A VGND VGND VPWR VPWR g_row\[1\].g_col\[1\].pe__1980_/C
+ sky130_fd_sc_hd__o21a_2
Xg_row\[1\].g_col\[0\].pe__1909_ place1084/X g_row\[1\].g_col\[0\].pe__2026_/B g_row\[1\].g_col\[0\].pe__1449_/Y
+ place1086/A VGND VGND VPWR VPWR g_row\[1\].g_col\[0\].pe__1910_/B sky130_fd_sc_hd__a22o_2
Xg_row\[1\].g_col\[1\].pe__1856_ g_row\[1\].g_col\[1\].pe__1857_/A g_row\[1\].g_col\[1\].pe__1857_/B
+ VGND VGND VPWR VPWR g_row\[1\].g_col\[1\].pe__1908_/A sky130_fd_sc_hd__nand2_2
Xg_row\[1\].g_col\[1\].pe__1787_ g_row\[1\].g_col\[1\].pe__1791_/A g_row\[1\].g_col\[1\].pe__1797_/A
+ VGND VGND VPWR VPWR g_row\[1\].g_col\[1\].pe__1789_/B sky130_fd_sc_hd__xor2_2
XPHY_EDGE_ROW_24_Left_118 VGND VGND VPWR VPWR sky130_fd_sc_hd__decap_3
Xhold1434 hold2418/X VGND VGND VPWR VPWR hold2419/A sky130_fd_sc_hd__clkbuf_2
Xg_row\[0\].g_col\[1\].pe__1934_ g_row\[0\].g_col\[1\].pe__1999_/A g_row\[0\].g_col\[1\].pe__1999_/B
+ VGND VGND VPWR VPWR g_row\[0\].g_col\[1\].pe__1935_/B sky130_fd_sc_hd__xor2_2
XPHY_EDGE_ROW_2_Right_2 VGND VGND VPWR VPWR sky130_fd_sc_hd__decap_3
XTAP_TAPCELL_ROW_4_269 VGND VPWR sky130_fd_sc_hd__tapvpwrvgnd_1
Xg_row\[0\].g_col\[0\].pe__1918_ g_row\[0\].g_col\[0\].pe__2045_/A g_row\[0\].g_col\[0\].pe__2045_/B
+ VGND VGND VPWR VPWR g_row\[0\].g_col\[0\].pe__1919_/B sky130_fd_sc_hd__nand2_2
Xhold1445 hold3184/X VGND VGND VPWR VPWR hold3185/A sky130_fd_sc_hd__clkbuf_2
Xhold1456 hold3201/X VGND VGND VPWR VPWR hold3202/A sky130_fd_sc_hd__clkbuf_2
Xhold1467 hold2478/X VGND VGND VPWR VPWR hold2479/A sky130_fd_sc_hd__clkbuf_2
XFILLER_44_129 VGND VGND VPWR VPWR sky130_fd_sc_hd__fill_2
Xg_row\[0\].g_col\[0\].pe__1849_ g_row\[0\].g_col\[0\].pe__1607_/A g_row\[0\].g_col\[0\].pe__1849_/B
+ VGND VGND VPWR VPWR g_row\[0\].g_col\[0\].pe__1850_/B sky130_fd_sc_hd__and2b_2
Xhold1478 hold3303/X VGND VGND VPWR VPWR hold3304/A sky130_fd_sc_hd__clkbuf_2
Xhold1489 hold3222/X VGND VGND VPWR VPWR hold3223/A sky130_fd_sc_hd__clkbuf_2
Xg_row\[1\].g_col\[1\].pe__2408_ g_row\[1\].g_col\[1\].pe__2739_/Q VGND VGND VPWR
+ VPWR g_row\[1\].g_col\[1\].pe__2410_/B sky130_fd_sc_hd__inv_2
Xg_row\[0\].g_col\[1\].pe__1865_ g_row\[0\].g_col\[1\].pe__1899_/A g_row\[0\].g_col\[1\].pe__1899_/B
+ VGND VGND VPWR VPWR g_row\[0\].g_col\[1\].pe__1868_/A sky130_fd_sc_hd__xor2_2
XFILLER_53_652 VGND VGND VPWR VPWR sky130_fd_sc_hd__decap_3
Xclkbuf_leaf_64_clk clkload5/A VGND VGND VPWR VPWR _308_/CLK sky130_fd_sc_hd__clkbuf_16
Xg_row\[1\].g_col\[1\].pe__2339_ g_row\[1\].g_col\[1\].pe__2311_/A g_row\[1\].g_col\[1\].pe__2311_/B
+ g_row\[1\].g_col\[1\].pe__2319_/B g_row\[1\].g_col\[1\].pe__2318_/B g_row\[1\].g_col\[1\].pe__2318_/A
+ VGND VGND VPWR VPWR g_row\[1\].g_col\[1\].pe__2350_/A sky130_fd_sc_hd__a32o_2
Xg_row\[1\].g_col\[0\].pe_place817 g_row\[1\].g_col\[0\].pe__2591_/B1 VGND VGND VPWR
+ VPWR g_row\[1\].g_col\[0\].pe__2560_/B1 sky130_fd_sc_hd__buf_6
Xg_row\[0\].g_col\[1\].pe__1796_ g_row\[0\].g_col\[1\].pe__1796_/A g_row\[0\].g_col\[1\].pe__1796_/B
+ VGND VGND VPWR VPWR g_row\[0\].g_col\[1\].pe__1797_/B sky130_fd_sc_hd__or2_2
XFILLER_71_37 VGND VGND VPWR VPWR sky130_fd_sc_hd__fill_1
XTAP_TAPCELL_ROW_23_555 VGND VPWR sky130_fd_sc_hd__tapvpwrvgnd_1
XPHY_EDGE_ROW_33_Left_127 VGND VGND VPWR VPWR sky130_fd_sc_hd__decap_3
Xinput1311 hold3266/X VGND VGND VPWR VPWR hold3267/A sky130_fd_sc_hd__buf_2
Xinput1300 hold3455/X VGND VGND VPWR VPWR hold3456/A sky130_fd_sc_hd__buf_2
Xg_row\[0\].g_col\[1\].pe__2417_ g_row\[0\].g_col\[1\].pe__2754_/Q g_row\[0\].g_col\[1\].pe__2266_/Y
+ g_row\[0\].g_col\[1\].pe__2434_/B VGND VGND VPWR VPWR g_row\[0\].g_col\[1\].pe__2432_/B
+ sky130_fd_sc_hd__o21ai_2
Xinput1344 hold3462/X VGND VGND VPWR VPWR hold3463/A sky130_fd_sc_hd__buf_2
Xinput1333 hold3371/X VGND VGND VPWR VPWR hold3372/A sky130_fd_sc_hd__buf_2
Xinput1322 hold3490/X VGND VGND VPWR VPWR hold3491/A sky130_fd_sc_hd__buf_2
Xg_row\[0\].g_col\[1\].pe__2348_ g_row\[0\].g_col\[1\].pe__2348_/A g_row\[0\].g_col\[1\].pe__2348_/B
+ VGND VGND VPWR VPWR g_row\[0\].g_col\[1\].pe__2349_/B sky130_fd_sc_hd__nand2_2
XFILLER_5_748 VGND VGND VPWR VPWR sky130_fd_sc_hd__decap_3
Xg_row\[0\].g_col\[1\].pe__2279_ g_row\[0\].g_col\[1\].pe__2630_/B g_row\[0\].g_col\[1\].pe__2313_/A2
+ g_row\[0\].g_col\[1\].pe__1541_/X g_row\[0\].g_col\[1\].pe__2627_/B VGND VGND VPWR
+ VPWR g_row\[0\].g_col\[1\].pe__2280_/B sky130_fd_sc_hd__a22o_2
XFILLER_20_85 VGND VGND VPWR VPWR sky130_fd_sc_hd__fill_2
Xg_row\[1\].g_col\[1\].pe_hold1954 g_row\[1\].g_col\[1\].pe_hold3102/X VGND VGND VPWR
+ VPWR g_row\[1\].g_col\[1\].pe__1386_/A1 sky130_fd_sc_hd__clkbuf_2
Xg_row\[1\].g_col\[1\].pe_hold1943 g_row\[1\].g_col\[1\].pe__2700_/Q VGND VGND VPWR
+ VPWR g_row\[1\].g_col\[1\].pe__2623_/B sky130_fd_sc_hd__clkbuf_2
XFILLER_88_560 VGND VGND VPWR VPWR sky130_fd_sc_hd__decap_3
XPHY_EDGE_ROW_42_Left_136 VGND VGND VPWR VPWR sky130_fd_sc_hd__decap_3
Xhold3370 hold3370/A VGND VGND VPWR VPWR hold3370/X sky130_fd_sc_hd__clkbuf_2
Xg_row\[1\].g_col\[1\].pe_hold1987 place1080/X VGND VGND VPWR VPWR g_row\[1\].g_col\[1\].pe__2631_/A2
+ sky130_fd_sc_hd__clkbuf_2
Xg_row\[1\].g_col\[1\].pe_hold1965 g_row\[1\].g_col\[1\].pe_hold3076/X VGND VGND VPWR
+ VPWR g_row\[1\].g_col\[1\].pe__2722_/D sky130_fd_sc_hd__clkbuf_2
XFILLER_75_221 VGND VGND VPWR VPWR sky130_fd_sc_hd__decap_3
Xhold3381 hold3381/A VGND VGND VPWR VPWR hold3381/X sky130_fd_sc_hd__clkbuf_2
Xhold3392 hold3392/A VGND VGND VPWR VPWR hold3392/X sky130_fd_sc_hd__clkbuf_2
XFILLER_29_83 VGND VGND VPWR VPWR sky130_fd_sc_hd__fill_1
XFILLER_36_619 VGND VGND VPWR VPWR sky130_fd_sc_hd__decap_3
Xhold2680 hold3435/X VGND VGND VPWR VPWR hold3436/A sky130_fd_sc_hd__clkbuf_2
Xhold2691 hold3482/X VGND VGND VPWR VPWR hold3483/A sky130_fd_sc_hd__clkbuf_2
XFILLER_29_671 VGND VGND VPWR VPWR sky130_fd_sc_hd__fill_1
XFILLER_28_170 VGND VGND VPWR VPWR sky130_fd_sc_hd__decap_3
Xclkbuf_leaf_55_clk clkload8/A VGND VGND VPWR VPWR clkbuf_leaf_55_clk/X sky130_fd_sc_hd__clkbuf_16
XFILLER_16_365 VGND VGND VPWR VPWR sky130_fd_sc_hd__decap_3
XPHY_EDGE_ROW_51_Left_145 VGND VGND VPWR VPWR sky130_fd_sc_hd__decap_3
XTAP_TAPCELL_ROW_42_842 VGND VPWR sky130_fd_sc_hd__tapvpwrvgnd_1
XFILLER_61_70 VGND VGND VPWR VPWR sky130_fd_sc_hd__fill_1
XFILLER_8_542 VGND VGND VPWR VPWR sky130_fd_sc_hd__fill_2
XANTENNA_3 a_inputs_flat[12] VGND VGND VPWR VPWR sky130_fd_sc_hd__diode_2
XFILLER_8_586 VGND VGND VPWR VPWR sky130_fd_sc_hd__fill_2
XFILLER_6_54 VGND VGND VPWR VPWR sky130_fd_sc_hd__fill_2
Xg_row\[1\].g_col\[0\].pe__2743_ clkload7/A g_row\[1\].g_col\[0\].pe__2743_/D VGND
+ VGND VPWR VPWR g_row\[1\].g_col\[0\].pe__2743_/Q sky130_fd_sc_hd__dfxtp_2
Xg_row\[1\].g_col\[1\].pe__2690_ clkbuf_leaf_87_clk/X g_row\[1\].g_col\[1\].pe__2690_/D
+ VGND VGND VPWR VPWR g_row\[1\].g_col\[1\].pe__2690_/Q sky130_fd_sc_hd__dfxtp_2
Xg_row\[1\].g_col\[1\].pe__1710_ g_row\[1\].g_col\[1\].pe__2693_/Q g_row\[1\].g_col\[1\].pe__1732_/A2
+ g_row\[1\].g_col\[1\].pe__1732_/B1 g_row\[1\].g_col\[1\].pe__2605_/B VGND VGND VPWR
+ VPWR g_row\[1\].g_col\[1\].pe__1711_/B sky130_fd_sc_hd__a22o_2
XPHY_EDGE_ROW_60_Left_154 VGND VGND VPWR VPWR sky130_fd_sc_hd__decap_3
Xg_row\[1\].g_col\[1\].pe__1641_ g_row\[1\].g_col\[1\].pe__1727_/A1 g_row\[1\].g_col\[1\].pe__2699_/Q
+ g_row\[1\].g_col\[1\].pe__2698_/Q g_row\[1\].g_col\[1\].pe__1727_/B2 VGND VGND VPWR
+ VPWR g_row\[1\].g_col\[1\].pe__1642_/B sky130_fd_sc_hd__a22o_2
Xg_row\[1\].g_col\[0\].pe_hold3012 g_row\[1\].g_col\[0\].pe_hold3012/A VGND VGND VPWR
+ VPWR g_row\[1\].g_col\[0\].pe__1403_/A1 sky130_fd_sc_hd__clkbuf_2
Xg_row\[1\].g_col\[0\].pe_hold3001 hold1763/X VGND VGND VPWR VPWR g_row\[1\].g_col\[0\].pe__2656_/A2
+ sky130_fd_sc_hd__clkbuf_2
Xg_row\[1\].g_col\[0\].pe__2674_ hold3100/X hold1894/A hold1763/X hold3085/X VGND
+ VGND VPWR VPWR g_row\[1\].g_col\[0\].pe__2674_/X sky130_fd_sc_hd__or4_2
Xg_row\[1\].g_col\[0\].pe__1625_ g_row\[1\].g_col\[0\].pe__1625_/A g_row\[1\].g_col\[0\].pe__1625_/B
+ VGND VGND VPWR VPWR g_row\[1\].g_col\[0\].pe__1879_/A sky130_fd_sc_hd__xnor2_2
XFILLER_79_582 VGND VGND VPWR VPWR sky130_fd_sc_hd__fill_2
Xg_row\[1\].g_col\[1\].pe_place903 g_row\[1\].g_col\[1\].pe__2686_/B VGND VGND VPWR
+ VPWR g_row\[1\].g_col\[1\].pe__1403_/A2 sky130_fd_sc_hd__buf_6
Xg_row\[1\].g_col\[1\].pe__1572_ g_row\[1\].g_col\[1\].pe__1804_/A g_row\[1\].g_col\[1\].pe__2704_/Q
+ g_row\[1\].g_col\[1\].pe__2703_/Q g_row\[1\].g_col\[1\].pe__1804_/B VGND VGND VPWR
+ VPWR g_row\[1\].g_col\[1\].pe__1573_/B sky130_fd_sc_hd__a22o_2
Xg_row\[1\].g_col\[0\].pe_hold3078 g_row\[1\].g_col\[0\].pe__2733_/Q VGND VGND VPWR
+ VPWR g_row\[1\].g_col\[0\].pe_hold3078/X sky130_fd_sc_hd__clkbuf_2
Xg_row\[1\].g_col\[0\].pe__1556_ g_row\[1\].g_col\[0\].pe__2605_/B g_row\[1\].g_col\[0\].pe__1549_/B
+ g_row\[1\].g_col\[0\].pe__2074_/B1 g_row\[1\].g_col\[0\].pe__2603_/B VGND VGND VPWR
+ VPWR g_row\[1\].g_col\[0\].pe__1557_/B sky130_fd_sc_hd__a22o_2
Xg_row\[0\].g_col\[0\].pe__2752_ clkbuf_leaf_25_clk/X g_row\[0\].g_col\[0\].pe__2752_/D
+ VGND VGND VPWR VPWR g_row\[0\].g_col\[0\].pe__2752_/Q sky130_fd_sc_hd__dfxtp_2
XTAP_TAPCELL_ROW_1_228 VGND VPWR sky130_fd_sc_hd__tapvpwrvgnd_1
XTAP_TAPCELL_ROW_68_1228 VGND VPWR sky130_fd_sc_hd__tapvpwrvgnd_1
Xg_row\[0\].g_col\[0\].pe__1703_ g_row\[0\].g_col\[0\].pe__1703_/A g_row\[0\].g_col\[0\].pe__1703_/B
+ VGND VGND VPWR VPWR g_row\[0\].g_col\[0\].pe__1824_/B sky130_fd_sc_hd__xnor2_2
Xg_row\[0\].g_col\[0\].pe__2683_ g_row\[0\].g_col\[0\].pe__2683_/A1 g_row\[0\].g_col\[0\].pe__2680_/B
+ g_row\[0\].g_col\[0\].pe__2682_/X g_row\[0\].g_col\[0\].pe__2685_/C1 VGND VGND VPWR
+ VPWR g_row\[0\].g_col\[0\].pe__2683_/X sky130_fd_sc_hd__o211a_2
Xg_row\[1\].g_col\[0\].pe__1487_ g_row\[1\].g_col\[0\].pe__1514_/A g_row\[1\].g_col\[0\].pe__1514_/B
+ VGND VGND VPWR VPWR g_row\[1\].g_col\[0\].pe__1490_/A sky130_fd_sc_hd__xor2_2
Xclkbuf_leaf_46_clk clkload6/A VGND VGND VPWR VPWR clkbuf_leaf_46_clk/X sky130_fd_sc_hd__clkbuf_16
Xg_row\[0\].g_col\[0\].pe__1634_ g_row\[0\].g_col\[0\].pe__1634_/A g_row\[0\].g_col\[0\].pe__1634_/B
+ VGND VGND VPWR VPWR g_row\[0\].g_col\[0\].pe__1634_/X sky130_fd_sc_hd__or2_2
Xg_row\[0\].g_col\[1\].pe__1650_ g_row\[0\].g_col\[1\].pe__1650_/A g_row\[0\].g_col\[1\].pe__1650_/B
+ VGND VGND VPWR VPWR g_row\[0\].g_col\[1\].pe__1660_/B sky130_fd_sc_hd__xnor2_2
XFILLER_81_279 VGND VGND VPWR VPWR sky130_fd_sc_hd__fill_1
Xg_row\[0\].g_col\[1\].pe__1581_ g_row\[0\].g_col\[1\].pe__1523_/A g_row\[0\].g_col\[1\].pe__1523_/B
+ g_row\[0\].g_col\[1\].pe__1580_/X VGND VGND VPWR VPWR g_row\[0\].g_col\[1\].pe__1582_/B
+ sky130_fd_sc_hd__a21oi_2
Xg_row\[1\].g_col\[1\].pe__2124_ g_row\[1\].g_col\[1\].pe__2123_/B g_row\[1\].g_col\[1\].pe__2123_/C
+ g_row\[1\].g_col\[1\].pe__2165_/A VGND VGND VPWR VPWR g_row\[1\].g_col\[1\].pe__2128_/C
+ sky130_fd_sc_hd__a21o_2
XTAP_TAPCELL_ROW_81_1428 VGND VPWR sky130_fd_sc_hd__tapvpwrvgnd_1
Xg_row\[0\].g_col\[0\].pe__1565_ g_row\[0\].g_col\[0\].pe__1910_/A g_row\[0\].g_col\[0\].pe__1565_/B
+ VGND VGND VPWR VPWR g_row\[0\].g_col\[0\].pe__1596_/A sky130_fd_sc_hd__xor2_2
Xg_row\[1\].g_col\[0\].pe__2108_ g_row\[1\].g_col\[0\].pe__2117_/A g_row\[1\].g_col\[0\].pe__2117_/B
+ VGND VGND VPWR VPWR g_row\[1\].g_col\[0\].pe__2110_/B sky130_fd_sc_hd__xor2_2
Xg_row\[0\].g_col\[0\].pe__1496_ g_row\[0\].g_col\[0\].pe__1536_/A g_row\[0\].g_col\[0\].pe__1536_/B
+ VGND VGND VPWR VPWR g_row\[0\].g_col\[0\].pe__1499_/A sky130_fd_sc_hd__xor2_2
Xg_row\[1\].g_col\[1\].pe__2055_ g_row\[1\].g_col\[1\].pe__2055_/A g_row\[1\].g_col\[1\].pe__2055_/B
+ VGND VGND VPWR VPWR g_row\[1\].g_col\[1\].pe__2055_/Y sky130_fd_sc_hd__nor2_2
Xg_row\[1\].g_col\[0\].pe__2039_ g_row\[1\].g_col\[0\].pe__2038_/A g_row\[1\].g_col\[0\].pe__2038_/B
+ g_row\[1\].g_col\[0\].pe__2038_/C VGND VGND VPWR VPWR g_row\[1\].g_col\[0\].pe__2048_/B
+ sky130_fd_sc_hd__a21o_2
XTAP_TAPCELL_ROW_20_503 VGND VPWR sky130_fd_sc_hd__tapvpwrvgnd_1
XTAP_TAPCELL_ROW_20_514 VGND VPWR sky130_fd_sc_hd__tapvpwrvgnd_1
Xg_row\[0\].g_col\[1\].pe__2202_ g_row\[0\].g_col\[1\].pe__2202_/A g_row\[0\].g_col\[1\].pe__2202_/B
+ VGND VGND VPWR VPWR g_row\[0\].g_col\[1\].pe__2238_/A sky130_fd_sc_hd__nor2_2
Xg_row\[0\].g_col\[1\].pe__2133_ g_row\[0\].g_col\[1\].pe__2184_/C g_row\[0\].g_col\[1\].pe__2184_/B
+ g_row\[0\].g_col\[1\].pe__2222_/A VGND VGND VPWR VPWR g_row\[0\].g_col\[1\].pe__2135_/A
+ sky130_fd_sc_hd__a21bo_2
Xg_row\[0\].g_col\[0\].pe__2117_ g_row\[0\].g_col\[0\].pe__2117_/A g_row\[0\].g_col\[0\].pe__2117_/B
+ VGND VGND VPWR VPWR g_row\[0\].g_col\[0\].pe__2161_/A sky130_fd_sc_hd__nor2_2
XFILLER_2_707 VGND VGND VPWR VPWR sky130_fd_sc_hd__decap_3
XTAP_TAPCELL_ROW_9_339 VGND VPWR sky130_fd_sc_hd__tapvpwrvgnd_1
Xg_row\[0\].g_col\[0\].pe__2048_ g_row\[0\].g_col\[0\].pe__2048_/A g_row\[0\].g_col\[0\].pe__2048_/B
+ g_row\[0\].g_col\[0\].pe__2048_/C VGND VGND VPWR VPWR g_row\[0\].g_col\[0\].pe__2048_/Y
+ sky130_fd_sc_hd__nand3_2
Xplace1241 place1250/X VGND VGND VPWR VPWR place1241/X sky130_fd_sc_hd__buf_6
Xg_row\[1\].g_col\[1\].pe__1908_ g_row\[1\].g_col\[1\].pe__1908_/A g_row\[1\].g_col\[1\].pe__1908_/B
+ VGND VGND VPWR VPWR g_row\[1\].g_col\[1\].pe__1935_/A sky130_fd_sc_hd__xor2_2
Xg_row\[0\].g_col\[1\].pe__2064_ _203_/A g_row\[0\].g_col\[1\].pe__2064_/B VGND VGND
+ VPWR VPWR g_row\[0\].g_col\[1\].pe__2064_/Y sky130_fd_sc_hd__nor2_2
Xplace1263 _273_/Q VGND VGND VPWR VPWR place1263/X sky130_fd_sc_hd__buf_6
Xplace1285 hold1640/X VGND VGND VPWR VPWR _171_/A sky130_fd_sc_hd__buf_6
XFILLER_66_26 VGND VGND VPWR VPWR sky130_fd_sc_hd__fill_2
XFILLER_58_755 VGND VGND VPWR VPWR sky130_fd_sc_hd__fill_1
XFILLER_85_530 VGND VGND VPWR VPWR sky130_fd_sc_hd__fill_2
XFILLER_45_405 VGND VGND VPWR VPWR sky130_fd_sc_hd__decap_3
XFILLER_58_799 VGND VGND VPWR VPWR sky130_fd_sc_hd__fill_1
XFILLER_73_725 VGND VGND VPWR VPWR sky130_fd_sc_hd__decap_3
Xg_row\[0\].g_col\[1\].pe__1917_ g_row\[0\].g_col\[1\].pe__2045_/A g_row\[0\].g_col\[1\].pe__2045_/B
+ VGND VGND VPWR VPWR g_row\[0\].g_col\[1\].pe__2094_/B sky130_fd_sc_hd__or2_2
XTAP_TAPCELL_ROW_28_625 VGND VPWR sky130_fd_sc_hd__tapvpwrvgnd_1
XTAP_TAPCELL_ROW_28_636 VGND VPWR sky130_fd_sc_hd__tapvpwrvgnd_1
Xclkbuf_leaf_37_clk clkbuf_4_6_0_clk/X VGND VGND VPWR VPWR clkbuf_leaf_37_clk/X sky130_fd_sc_hd__clkbuf_16
Xg_row\[0\].g_col\[1\].pe__1848_ g_row\[0\].g_col\[1\].pe__1606_/A g_row\[0\].g_col\[1\].pe__1848_/B
+ VGND VGND VPWR VPWR g_row\[0\].g_col\[1\].pe__1850_/A sky130_fd_sc_hd__and2b_2
XFILLER_25_151 VGND VGND VPWR VPWR sky130_fd_sc_hd__decap_3
XFILLER_53_493 VGND VGND VPWR VPWR sky130_fd_sc_hd__fill_2
Xg_row\[0\].g_col\[1\].pe__1779_ g_row\[0\].g_col\[1\].pe__1813_/A g_row\[0\].g_col\[1\].pe__1813_/B
+ VGND VGND VPWR VPWR g_row\[0\].g_col\[1\].pe__1779_/Y sky130_fd_sc_hd__nor2_2
Xg_row\[0\].g_col\[0\].pe_hold1719 ANTENNA_42/DIODE VGND VGND VPWR VPWR g_row\[0\].g_col\[0\].pe__2308_/A
+ sky130_fd_sc_hd__clkbuf_2
XFILLER_31_40 VGND VGND VPWR VPWR sky130_fd_sc_hd__fill_2
Xg_row\[1\].g_col\[1\].pe_hold3120 g_row\[1\].g_col\[1\].pe__2706_/Q VGND VGND VPWR
+ VPWR g_row\[1\].g_col\[1\].pe_hold3120/X sky130_fd_sc_hd__clkbuf_2
Xg_row\[1\].g_col\[1\].pe_hold1751 g_row\[1\].g_col\[1\].pe__2768_/Q VGND VGND VPWR
+ VPWR g_row\[1\].g_col\[1\].pe__2581_/A1 sky130_fd_sc_hd__clkbuf_2
Xg_row\[1\].g_col\[1\].pe_hold1740 g_row\[1\].g_col\[1\].pe__2334_/X VGND VGND VPWR
+ VPWR g_row\[1\].g_col\[1\].pe__2335_/B sky130_fd_sc_hd__clkbuf_2
XFILLER_0_250 VGND VGND VPWR VPWR sky130_fd_sc_hd__fill_2
XFILLER_48_210 VGND VGND VPWR VPWR sky130_fd_sc_hd__fill_2
Xg_row\[1\].g_col\[0\].pe__2390_ g_row\[1\].g_col\[0\].pe__2390_/A g_row\[1\].g_col\[0\].pe__2390_/B
+ VGND VGND VPWR VPWR g_row\[1\].g_col\[0\].pe__2391_/B sky130_fd_sc_hd__xnor2_2
XFILLER_76_530 VGND VGND VPWR VPWR sky130_fd_sc_hd__fill_2
Xg_row\[1\].g_col\[0\].pe__1341_ g_row\[1\].g_col\[0\].pe__2776_/A g_row\[1\].g_col\[0\].pe__2775_/A
+ VGND VGND VPWR VPWR g_row\[1\].g_col\[0\].pe__1342_/B sky130_fd_sc_hd__nand2_2
XFILLER_36_427 VGND VGND VPWR VPWR sky130_fd_sc_hd__fill_1
XFILLER_64_714 VGND VGND VPWR VPWR sky130_fd_sc_hd__decap_3
XFILLER_76_574 VGND VGND VPWR VPWR sky130_fd_sc_hd__decap_3
XFILLER_76_596 VGND VGND VPWR VPWR sky130_fd_sc_hd__fill_2
XTAP_TAPCELL_ROW_47_912 VGND VPWR sky130_fd_sc_hd__tapvpwrvgnd_1
XFILLER_36_449 VGND VGND VPWR VPWR sky130_fd_sc_hd__fill_1
XFILLER_48_298 VGND VGND VPWR VPWR sky130_fd_sc_hd__fill_2
Xclkbuf_leaf_28_clk clkload3/A VGND VGND VPWR VPWR _314_/CLK sky130_fd_sc_hd__clkbuf_16
Xg_row\[0\].g_col\[0\].pe_hold2910 _280_/Q VGND VGND VPWR VPWR g_row\[0\].g_col\[0\].pe_hold2910/X
+ sky130_fd_sc_hd__clkbuf_2
Xg_row\[0\].g_col\[0\].pe_hold2921 g_row\[0\].g_col\[0\].pe_hold2921/A VGND VGND VPWR
+ VPWR g_row\[0\].g_col\[0\].pe__2615_/A2 sky130_fd_sc_hd__clkbuf_2
XTAP_TAPCELL_ROW_63_1158 VGND VPWR sky130_fd_sc_hd__tapvpwrvgnd_1
Xg_row\[0\].g_col\[0\].pe__1350_ g_row\[0\].g_col\[0\].pe__2760_/Q g_row\[0\].g_col\[0\].pe__1348_/B
+ g_row\[0\].g_col\[0\].pe__2776_/A VGND VGND VPWR VPWR g_row\[0\].g_col\[0\].pe__1351_/B
+ sky130_fd_sc_hd__o21ai_2
Xg_row\[0\].g_col\[0\].pe_hold2943 g_row\[0\].g_col\[0\].pe__2675_/Y VGND VGND VPWR
+ VPWR g_row\[0\].g_col\[0\].pe__2678_/B sky130_fd_sc_hd__clkbuf_2
XFILLER_31_165 VGND VGND VPWR VPWR sky130_fd_sc_hd__decap_3
Xg_row\[0\].g_col\[0\].pe_hold2976 g_row\[0\].g_col\[0\].pe__2672_/C VGND VGND VPWR
+ VPWR g_row\[0\].g_col\[0\].pe__2670_/A2 sky130_fd_sc_hd__clkbuf_2
Xg_row\[1\].g_col\[1\].pe__2742_ clkload16/A g_row\[1\].g_col\[1\].pe__2742_/D VGND
+ VGND VPWR VPWR g_row\[1\].g_col\[1\].pe__2742_/Q sky130_fd_sc_hd__dfxtp_2
Xg_row\[1\].g_col\[0\].pe__2726_ clkbuf_leaf_44_clk/X g_row\[1\].g_col\[0\].pe__2726_/D
+ VGND VGND VPWR VPWR g_row\[1\].g_col\[0\].pe__2726_/Q sky130_fd_sc_hd__dfxtp_2
Xg_row\[1\].g_col\[1\].pe__2673_ hold2162/X hold2186/A hold2139/X hold2119/X VGND
+ VGND VPWR VPWR g_row\[1\].g_col\[1\].pe__2673_/X sky130_fd_sc_hd__or4_2
Xg_row\[1\].g_col\[0\].pe__2657_ g_row\[1\].g_col\[0\].pe__2669_/A g_row\[1\].g_col\[0\].pe__2657_/B
+ VGND VGND VPWR VPWR g_row\[1\].g_col\[0\].pe__2657_/X sky130_fd_sc_hd__or2_2
Xg_row\[1\].g_col\[1\].pe__1624_ g_row\[1\].g_col\[1\].pe__2125_/C g_row\[1\].g_col\[1\].pe__1624_/B
+ VGND VGND VPWR VPWR g_row\[1\].g_col\[1\].pe__1625_/B sky130_fd_sc_hd__xor2_2
Xg_row\[1\].g_col\[0\].pe__1608_ g_row\[1\].g_col\[0\].pe__2241_/B2 g_row\[1\].g_col\[0\].pe__2026_/B
+ g_row\[1\].g_col\[0\].pe__1449_/Y place1090/X VGND VGND VPWR VPWR g_row\[1\].g_col\[0\].pe__1609_/B
+ sky130_fd_sc_hd__a22o_2
XFILLER_39_221 VGND VGND VPWR VPWR sky130_fd_sc_hd__decap_3
Xg_row\[1\].g_col\[1\].pe__1555_ g_row\[1\].g_col\[1\].pe__1555_/A g_row\[1\].g_col\[1\].pe__1555_/B
+ VGND VGND VPWR VPWR g_row\[1\].g_col\[1\].pe__1562_/B sky130_fd_sc_hd__and2_2
Xg_row\[1\].g_col\[0\].pe__2588_ g_row\[1\].g_col\[0\].pe__2595_/A g_row\[1\].g_col\[0\].pe__2588_/B
+ VGND VGND VPWR VPWR g_row\[1\].g_col\[0\].pe__2769_/D sky130_fd_sc_hd__and2_2
Xg_row\[0\].g_col\[0\].pe__2735_ clkbuf_leaf_38_clk/X g_row\[0\].g_col\[0\].pe__2735_/D
+ VGND VGND VPWR VPWR g_row\[0\].g_col\[0\].pe__2735_/Q sky130_fd_sc_hd__dfxtp_2
Xg_row\[0\].g_col\[1\].pe__2751_ clkbuf_leaf_7_clk/X g_row\[0\].g_col\[1\].pe__2751_/D
+ VGND VGND VPWR VPWR g_row\[0\].g_col\[1\].pe__2751_/Q sky130_fd_sc_hd__dfxtp_2
XFILLER_27_449 VGND VGND VPWR VPWR sky130_fd_sc_hd__fill_1
XFILLER_36_29 VGND VGND VPWR VPWR sky130_fd_sc_hd__fill_1
XFILLER_82_533 VGND VGND VPWR VPWR sky130_fd_sc_hd__decap_3
Xclkbuf_leaf_19_clk clkbuf_4_4_0_clk/X VGND VGND VPWR VPWR _292_/CLK sky130_fd_sc_hd__clkbuf_16
Xg_row\[0\].g_col\[1\].pe__1702_ g_row\[0\].g_col\[1\].pe__1831_/A g_row\[0\].g_col\[1\].pe__1831_/B
+ g_row\[0\].g_col\[1\].pe__1827_/A g_row\[0\].g_col\[1\].pe__1827_/B VGND VGND VPWR
+ VPWR g_row\[0\].g_col\[1\].pe__1702_/X sky130_fd_sc_hd__o22a_2
Xg_row\[1\].g_col\[1\].pe__1486_ g_row\[1\].g_col\[1\].pe__1730_/A g_row\[1\].g_col\[1\].pe__1486_/B
+ VGND VGND VPWR VPWR g_row\[1\].g_col\[1\].pe__1514_/B sky130_fd_sc_hd__xor2_2
XFILLER_42_419 VGND VGND VPWR VPWR sky130_fd_sc_hd__fill_1
Xg_row\[0\].g_col\[0\].pe__2666_ g_row\[0\].g_col\[0\].pe__2670_/A1 g_row\[0\].g_col\[0\].pe__2666_/A2
+ g_row\[0\].g_col\[0\].pe__2555_/A g_row\[0\].g_col\[0\].pe__2665_/X VGND VGND VPWR
+ VPWR g_row\[0\].g_col\[0\].pe__2666_/X sky130_fd_sc_hd__o211a_2
Xg_row\[0\].g_col\[1\].pe_hold1849 g_row\[0\].g_col\[1\].pe__2592_/X VGND VGND VPWR
+ VPWR g_row\[0\].g_col\[1\].pe__2770_/D sky130_fd_sc_hd__clkbuf_2
Xg_row\[0\].g_col\[1\].pe__2682_ g_row\[0\].g_col\[1\].pe__2724_/Q g_row\[0\].g_col\[1\].pe__2686_/B
+ VGND VGND VPWR VPWR g_row\[0\].g_col\[1\].pe__2682_/X sky130_fd_sc_hd__or2_2
Xg_row\[0\].g_col\[0\].pe__1617_ g_row\[0\].g_col\[1\].pe__2635_/C VGND VGND VPWR
+ VPWR g_row\[0\].g_col\[0\].pe__2125_/A sky130_fd_sc_hd__inv_2
Xg_row\[0\].g_col\[1\].pe__1633_ g_row\[0\].g_col\[1\].pe__1633_/A g_row\[0\].g_col\[1\].pe__1633_/B
+ VGND VGND VPWR VPWR g_row\[0\].g_col\[1\].pe__1845_/B sky130_fd_sc_hd__xor2_2
Xg_row\[0\].g_col\[0\].pe__1548_ g_row\[0\].g_col\[0\].pe__1550_/A g_row\[0\].g_col\[0\].pe__1550_/B
+ VGND VGND VPWR VPWR g_row\[0\].g_col\[0\].pe__1830_/A sky130_fd_sc_hd__and2b_2
Xg_row\[0\].g_col\[1\].pe__1564_ g_row\[0\].g_col\[1\].pe__2177_/A1 g_row\[0\].g_col\[1\].pe__2026_/B
+ g_row\[0\].g_col\[1\].pe__1738_/B1 g_row\[0\].g_col\[1\].pe__1704_/A2 VGND VGND
+ VPWR VPWR g_row\[0\].g_col\[1\].pe__1565_/B sky130_fd_sc_hd__a22o_2
Xg_row\[1\].g_col\[1\].pe__2107_ g_row\[1\].g_col\[1\].pe__2107_/A g_row\[1\].g_col\[1\].pe__2107_/B
+ VGND VGND VPWR VPWR g_row\[1\].g_col\[1\].pe__2117_/B sky130_fd_sc_hd__xnor2_2
XFILLER_22_176 VGND VGND VPWR VPWR sky130_fd_sc_hd__fill_2
Xg_row\[0\].g_col\[1\].pe__1495_ g_row\[0\].g_col\[1\].pe__1673_/A g_row\[0\].g_col\[1\].pe__1495_/B
+ VGND VGND VPWR VPWR g_row\[0\].g_col\[1\].pe__1536_/B sky130_fd_sc_hd__xnor2_2
Xg_row\[1\].g_col\[1\].pe__2038_ g_row\[1\].g_col\[1\].pe__2038_/A g_row\[1\].g_col\[1\].pe__2038_/B
+ g_row\[1\].g_col\[1\].pe__2038_/C VGND VGND VPWR VPWR g_row\[1\].g_col\[1\].pe__2048_/A
+ sky130_fd_sc_hd__nand3_2
XFILLER_50_496 VGND VGND VPWR VPWR sky130_fd_sc_hd__decap_3
Xg_row\[0\].g_col\[0\].pe__1479_ g_row\[0\].g_col\[0\].pe__1479_/A g_row\[0\].g_col\[0\].pe__1479_/B
+ VGND VGND VPWR VPWR g_row\[0\].g_col\[0\].pe__1479_/Y sky130_fd_sc_hd__nor2_2
XFILLER_6_309 VGND VGND VPWR VPWR sky130_fd_sc_hd__fill_2
Xg_row\[0\].g_col\[1\].pe__2116_ g_row\[0\].g_col\[1\].pe__2116_/A VGND VGND VPWR
+ VPWR g_row\[0\].g_col\[1\].pe__2116_/Y sky130_fd_sc_hd__inv_2
Xg_row\[0\].g_col\[1\].pe__2047_ g_row\[0\].g_col\[1\].pe__2047_/A g_row\[0\].g_col\[1\].pe__2047_/B
+ VGND VGND VPWR VPWR g_row\[0\].g_col\[1\].pe__2048_/C sky130_fd_sc_hd__xor2_2
XFILLER_78_806 VGND VGND VPWR VPWR sky130_fd_sc_hd__fill_2
Xplace1082 hold1795/A VGND VGND VPWR VPWR place1082/X sky130_fd_sc_hd__buf_6
Xplace1093 place1094/X VGND VGND VPWR VPWR place1093/X sky130_fd_sc_hd__buf_6
XFILLER_58_530 VGND VGND VPWR VPWR sky130_fd_sc_hd__fill_2
Xclkbuf_4_13_0_clk clkbuf_0_clk/X VGND VGND VPWR VPWR clkload6/A sky130_fd_sc_hd__clkbuf_16
XFILLER_93_57 VGND VGND VPWR VPWR sky130_fd_sc_hd__fill_2
XFILLER_33_419 VGND VGND VPWR VPWR sky130_fd_sc_hd__decap_3
XFILLER_14_600 VGND VGND VPWR VPWR sky130_fd_sc_hd__fill_2
XFILLER_14_611 VGND VGND VPWR VPWR sky130_fd_sc_hd__decap_3
XFILLER_26_482 VGND VGND VPWR VPWR sky130_fd_sc_hd__fill_2
XFILLER_73_588 VGND VGND VPWR VPWR sky130_fd_sc_hd__decap_3
XFILLER_26_493 VGND VGND VPWR VPWR sky130_fd_sc_hd__decap_3
XFILLER_53_290 VGND VGND VPWR VPWR sky130_fd_sc_hd__decap_3
Xg_row\[0\].g_col\[0\].pe_hold2228 g_row\[0\].g_col\[0\].pe__1384_/X VGND VGND VPWR
+ VPWR g_row\[0\].g_col\[0\].pe__2728_/D sky130_fd_sc_hd__clkbuf_2
XFILLER_9_158 VGND VGND VPWR VPWR sky130_fd_sc_hd__fill_2
XTAP_TAPCELL_ROW_52_992 VGND VPWR sky130_fd_sc_hd__tapvpwrvgnd_1
X_295_ _300_/CLK _295_/D VGND VGND VPWR VPWR _295_/Q sky130_fd_sc_hd__dfxtp_2
XFILLER_6_810 VGND VGND VPWR VPWR sky130_fd_sc_hd__fill_2
XFILLER_9_169 VGND VGND VPWR VPWR sky130_fd_sc_hd__fill_1
XTAP_TAPCELL_ROW_11_377 VGND VPWR sky130_fd_sc_hd__tapvpwrvgnd_1
Xg_row\[1\].g_col\[0\].pe__1890_ g_row\[1\].g_col\[0\].pe__1894_/A g_row\[1\].g_col\[0\].pe__1894_/B
+ VGND VGND VPWR VPWR g_row\[1\].g_col\[0\].pe__1891_/B sky130_fd_sc_hd__xor2_2
Xg_row\[1\].g_col\[0\].pe__2442_ g_row\[1\].g_col\[0\].pe__2443_/B g_row\[1\].g_col\[0\].pe__2762_/Q
+ VGND VGND VPWR VPWR g_row\[1\].g_col\[0\].pe__2444_/A sky130_fd_sc_hd__and2b_2
Xg_row\[1\].g_col\[1\].pe__1340_ g_row\[1\].g_col\[1\].pe__1340_/A VGND VGND VPWR
+ VPWR g_row\[1\].g_col\[1\].pe__2689_/A sky130_fd_sc_hd__inv_2
Xg_row\[1\].g_col\[0\].pe__2373_ g_row\[1\].g_col\[0\].pe__2337_/B g_row\[1\].g_col\[0\].pe__2368_/B
+ g_row\[1\].g_col\[0\].pe__2350_/B g_row\[1\].g_col\[0\].pe__2350_/A VGND VGND VPWR
+ VPWR g_row\[1\].g_col\[0\].pe__2385_/B sky130_fd_sc_hd__a22o_2
XFILLER_36_224 VGND VGND VPWR VPWR sky130_fd_sc_hd__fill_2
XFILLER_64_533 VGND VGND VPWR VPWR sky130_fd_sc_hd__decap_3
XFILLER_37_769 VGND VGND VPWR VPWR sky130_fd_sc_hd__fill_2
Xg_row\[0\].g_col\[0\].pe__2520_ g_row\[0\].g_col\[0\].pe__2499_/B g_row\[0\].g_col\[0\].pe__2519_/Y
+ g_row\[0\].g_col\[0\].pe__2559_/A VGND VGND VPWR VPWR g_row\[0\].g_col\[0\].pe__2520_/X
+ sky130_fd_sc_hd__a21o_2
XFILLER_24_419 VGND VGND VPWR VPWR sky130_fd_sc_hd__fill_1
XTAP_TAPCELL_ROW_19_488 VGND VPWR sky130_fd_sc_hd__tapvpwrvgnd_1
XTAP_TAPCELL_ROW_19_499 VGND VPWR sky130_fd_sc_hd__tapvpwrvgnd_1
Xg_row\[0\].g_col\[0\].pe__2451_ g_row\[0\].g_col\[0\].pe__2451_/A g_row\[0\].g_col\[0\].pe__2451_/B
+ VGND VGND VPWR VPWR g_row\[0\].g_col\[0\].pe__2452_/B sky130_fd_sc_hd__xnor2_2
XFILLER_32_441 VGND VGND VPWR VPWR sky130_fd_sc_hd__decap_3
XFILLER_51_238 VGND VGND VPWR VPWR sky130_fd_sc_hd__decap_3
Xg_row\[0\].g_col\[0\].pe__1402_ g_row\[0\].g_col\[0\].pe__2672_/C g_row\[0\].g_col\[0\].pe__1402_/B
+ VGND VGND VPWR VPWR g_row\[0\].g_col\[0\].pe__1402_/X sky130_fd_sc_hd__or2_2
XFILLER_20_658 VGND VGND VPWR VPWR sky130_fd_sc_hd__fill_2
XFILLER_9_670 VGND VGND VPWR VPWR sky130_fd_sc_hd__fill_2
XTAP_TAPCELL_ROW_30_653 VGND VPWR sky130_fd_sc_hd__tapvpwrvgnd_1
XTAP_TAPCELL_ROW_30_664 VGND VPWR sky130_fd_sc_hd__tapvpwrvgnd_1
XFILLER_9_692 VGND VGND VPWR VPWR sky130_fd_sc_hd__decap_3
XTAP_TAPCELL_ROW_76_1349 VGND VPWR sky130_fd_sc_hd__tapvpwrvgnd_1
Xclkbuf_leaf_8_clk clkload0/A VGND VGND VPWR VPWR _276_/CLK sky130_fd_sc_hd__clkbuf_16
XFILLER_87_603 VGND VGND VPWR VPWR sky130_fd_sc_hd__decap_3
Xg_row\[1\].g_col\[1\].pe__2725_ clkbuf_leaf_85_clk/X g_row\[1\].g_col\[1\].pe__2725_/D
+ VGND VGND VPWR VPWR g_row\[1\].g_col\[1\].pe__2725_/Q sky130_fd_sc_hd__dfxtp_2
Xg_row\[1\].g_col\[0\].pe__2709_ clkbuf_leaf_41_clk/X g_row\[1\].g_col\[0\].pe__2709_/D
+ VGND VGND VPWR VPWR g_row\[1\].g_col\[0\].pe__2709_/Q sky130_fd_sc_hd__dfxtp_2
Xg_row\[1\].g_col\[1\].pe__2656_ g_row\[1\].g_col\[1\].pe__2656_/A1 g_row\[1\].g_col\[1\].pe__2656_/A2
+ g_row\[1\].g_col\[1\].pe__2683_/C1 g_row\[1\].g_col\[1\].pe__2656_/C1 VGND VGND
+ VPWR VPWR g_row\[1\].g_col\[1\].pe__2656_/X sky130_fd_sc_hd__o211a_2
Xg_row\[1\].g_col\[1\].pe__1607_ g_row\[1\].g_col\[1\].pe__1607_/A g_row\[1\].g_col\[1\].pe__1849_/B
+ VGND VGND VPWR VPWR g_row\[1\].g_col\[1\].pe__1633_/A sky130_fd_sc_hd__xor2_2
Xg_row\[1\].g_col\[1\].pe__2587_ g_row\[1\].g_col\[1\].pe__2587_/A1 g_row\[1\].g_col\[1\].pe__2591_/A2
+ g_row\[1\].g_col\[1\].pe__2591_/B1 g_row\[1\].g_col\[1\].pe__2586_/X VGND VGND VPWR
+ VPWR g_row\[1\].g_col\[1\].pe__2587_/X sky130_fd_sc_hd__a22o_2
Xg_row\[1\].g_col\[1\].pe__1538_ g_row\[1\].g_col\[1\].pe__2736_/Q VGND VGND VPWR
+ VPWR g_row\[1\].g_col\[1\].pe__1602_/A sky130_fd_sc_hd__inv_2
Xg_row\[0\].g_col\[1\].pe_hold2336 g_row\[0\].g_col\[1\].pe_hold2396/X VGND VGND VPWR
+ VPWR g_row\[0\].g_col\[1\].pe__2639_/B sky130_fd_sc_hd__clkbuf_2
Xg_row\[0\].g_col\[1\].pe_hold2325 g_row\[0\].g_col\[1\].pe__2745_/Q VGND VGND VPWR
+ VPWR g_row\[0\].g_col\[1\].pe__2116_/A sky130_fd_sc_hd__clkbuf_2
XFILLER_27_257 VGND VGND VPWR VPWR sky130_fd_sc_hd__fill_1
Xg_row\[0\].g_col\[0\].pe__2718_ clkbuf_leaf_35_clk/X g_row\[0\].g_col\[0\].pe__2718_/D
+ VGND VGND VPWR VPWR hold2069/A sky130_fd_sc_hd__dfxtp_2
Xg_row\[1\].g_col\[1\].pe__1469_ g_row\[1\].g_col\[1\].pe__2733_/Q g_row\[1\].g_col\[1\].pe__2250_/A
+ VGND VGND VPWR VPWR g_row\[1\].g_col\[1\].pe__1471_/A sky130_fd_sc_hd__nand2_2
Xg_row\[0\].g_col\[1\].pe_hold2369 g_row\[0\].g_col\[1\].pe__2738_/Q VGND VGND VPWR
+ VPWR g_row\[0\].g_col\[1\].pe__1406_/A sky130_fd_sc_hd__clkbuf_2
Xg_row\[0\].g_col\[1\].pe_hold2358 g_row\[0\].g_col\[1\].pe__1401_/X VGND VGND VPWR
+ VPWR g_row\[0\].g_col\[1\].pe__2736_/D sky130_fd_sc_hd__clkbuf_2
Xg_row\[0\].g_col\[1\].pe_hold2347 g_row\[0\].g_col\[1\].pe_hold2940/X VGND VGND VPWR
+ VPWR g_row\[0\].g_col\[1\].pe__2398_/A sky130_fd_sc_hd__clkbuf_2
Xg_row\[0\].g_col\[1\].pe__2734_ clkload11/A g_row\[0\].g_col\[1\].pe__2734_/D VGND
+ VGND VPWR VPWR g_row\[0\].g_col\[1\].pe__2734_/Q sky130_fd_sc_hd__dfxtp_2
XFILLER_63_38 VGND VGND VPWR VPWR sky130_fd_sc_hd__fill_1
XFILLER_70_536 VGND VGND VPWR VPWR sky130_fd_sc_hd__decap_3
XTAP_TAPCELL_ROW_38_775 VGND VPWR sky130_fd_sc_hd__tapvpwrvgnd_1
XTAP_TAPCELL_ROW_38_786 VGND VPWR sky130_fd_sc_hd__tapvpwrvgnd_1
Xg_row\[0\].g_col\[0\].pe__2649_ place1263/X hold1894/X VGND VGND VPWR VPWR g_row\[0\].g_col\[0\].pe__2649_/X
+ sky130_fd_sc_hd__or2_2
Xg_row\[0\].g_col\[1\].pe__2665_ place1239/X hold1976/X VGND VGND VPWR VPWR g_row\[0\].g_col\[1\].pe__2665_/X
+ sky130_fd_sc_hd__or2_2
XFILLER_70_558 VGND VGND VPWR VPWR sky130_fd_sc_hd__fill_1
Xg_row\[0\].g_col\[1\].pe__1616_ g_row\[0\].g_col\[1\].pe__2163_/A g_row\[0\].g_col\[1\].pe__1727_/B2
+ g_row\[0\].g_col\[1\].pe__2045_/B VGND VGND VPWR VPWR g_row\[0\].g_col\[1\].pe__1875_/A
+ sky130_fd_sc_hd__a21o_2
XFILLER_11_614 VGND VGND VPWR VPWR sky130_fd_sc_hd__fill_2
XFILLER_11_636 VGND VGND VPWR VPWR sky130_fd_sc_hd__fill_1
Xg_row\[0\].g_col\[1\].pe__1547_ g_row\[0\].g_col\[1\].pe__1547_/A g_row\[0\].g_col\[1\].pe__1547_/B
+ VGND VGND VPWR VPWR g_row\[0\].g_col\[1\].pe__1550_/B sky130_fd_sc_hd__xor2_2
Xg_row\[0\].g_col\[1\].pe__1478_ g_row\[0\].g_col\[1\].pe__1478_/A g_row\[0\].g_col\[1\].pe__1478_/B
+ VGND VGND VPWR VPWR g_row\[0\].g_col\[1\].pe__1662_/B sky130_fd_sc_hd__xor2_2
XFILLER_5_3 VGND VGND VPWR VPWR sky130_fd_sc_hd__fill_1
XFILLER_78_625 VGND VGND VPWR VPWR sky130_fd_sc_hd__decap_3
XFILLER_46_533 VGND VGND VPWR VPWR sky130_fd_sc_hd__decap_3
XFILLER_46_555 VGND VGND VPWR VPWR sky130_fd_sc_hd__decap_3
XFILLER_46_577 VGND VGND VPWR VPWR sky130_fd_sc_hd__decap_3
XFILLER_61_503 VGND VGND VPWR VPWR sky130_fd_sc_hd__fill_1
XFILLER_14_430 VGND VGND VPWR VPWR sky130_fd_sc_hd__decap_3
XTAP_TAPCELL_ROW_16_447 VGND VPWR sky130_fd_sc_hd__tapvpwrvgnd_1
Xg_row\[0\].g_col\[0\].pe_hold2003 g_row\[0\].g_col\[0\].pe__1392_/X VGND VGND VPWR
+ VPWR g_row\[0\].g_col\[0\].pe__1393_/B1 sky130_fd_sc_hd__clkbuf_2
Xg_row\[0\].g_col\[0\].pe_hold2014 g_row\[0\].g_col\[0\].pe_hold3053/X VGND VGND VPWR
+ VPWR g_row\[0\].g_col\[0\].pe__2712_/D sky130_fd_sc_hd__clkbuf_2
Xg_row\[0\].g_col\[0\].pe_hold2025 g_row\[0\].g_col\[0\].pe__1399_/X VGND VGND VPWR
+ VPWR g_row\[0\].g_col\[0\].pe__2735_/D sky130_fd_sc_hd__clkbuf_2
XFILLER_14_474 VGND VGND VPWR VPWR sky130_fd_sc_hd__fill_2
XTAP_TAPCELL_ROW_60_1106 VGND VPWR sky130_fd_sc_hd__tapvpwrvgnd_1
XFILLER_53_82 VGND VGND VPWR VPWR sky130_fd_sc_hd__fill_1
XTAP_TAPCELL_ROW_60_1117 VGND VPWR sky130_fd_sc_hd__tapvpwrvgnd_1
X_278_ _278_/CLK _278_/D VGND VGND VPWR VPWR _278_/Q sky130_fd_sc_hd__dfxtp_2
Xg_row\[1\].g_col\[0\].pe__1942_ g_row\[1\].g_col\[0\].pe__2005_/A g_row\[1\].g_col\[0\].pe__1942_/B
+ VGND VGND VPWR VPWR g_row\[1\].g_col\[0\].pe__1951_/B sky130_fd_sc_hd__nor2_2
Xg_row\[1\].g_col\[0\].pe__1873_ g_row\[1\].g_col\[0\].pe__2125_/C g_row\[1\].g_col\[0\].pe__1873_/B
+ VGND VGND VPWR VPWR g_row\[1\].g_col\[0\].pe__1874_/B sky130_fd_sc_hd__xor2_2
XTAP_TAPCELL_ROW_58_1079 VGND VPWR sky130_fd_sc_hd__tapvpwrvgnd_1
XFILLER_69_614 VGND VGND VPWR VPWR sky130_fd_sc_hd__fill_2
XFILLER_69_636 VGND VGND VPWR VPWR sky130_fd_sc_hd__decap_3
Xg_row\[0\].g_col\[0\].pe__1951_ g_row\[0\].g_col\[0\].pe__1951_/A g_row\[0\].g_col\[0\].pe__1951_/B
+ VGND VGND VPWR VPWR g_row\[0\].g_col\[0\].pe__2009_/C sky130_fd_sc_hd__and2_2
Xhold2509 hold2509/A VGND VGND VPWR VPWR _334_/D sky130_fd_sc_hd__clkbuf_2
Xg_row\[1\].g_col\[1\].pe__2510_ g_row\[1\].g_col\[1\].pe__2516_/B g_row\[1\].g_col\[1\].pe__2507_/Y
+ g_row\[1\].g_col\[1\].pe__2508_/Y g_row\[1\].g_col\[1\].pe__2509_/X VGND VGND VPWR
+ VPWR g_row\[1\].g_col\[1\].pe__2510_/X sky130_fd_sc_hd__a31o_2
XFILLER_69_647 VGND VGND VPWR VPWR sky130_fd_sc_hd__decap_3
XFILLER_69_669 VGND VGND VPWR VPWR sky130_fd_sc_hd__decap_3
XTAP_TAPCELL_ROW_71_1268 VGND VPWR sky130_fd_sc_hd__tapvpwrvgnd_1
XTAP_TAPCELL_ROW_71_1279 VGND VPWR sky130_fd_sc_hd__tapvpwrvgnd_1
XFILLER_84_606 VGND VGND VPWR VPWR sky130_fd_sc_hd__decap_3
Xg_row\[0\].g_col\[0\].pe__1882_ g_row\[0\].g_col\[0\].pe__1882_/A g_row\[0\].g_col\[0\].pe__1882_/B
+ VGND VGND VPWR VPWR g_row\[0\].g_col\[0\].pe__1885_/A sky130_fd_sc_hd__xor2_2
Xg_row\[1\].g_col\[1\].pe__2441_ g_row\[1\].g_col\[1\].pe__2745_/Q g_row\[1\].g_col\[1\].pe__2441_/B
+ VGND VGND VPWR VPWR g_row\[1\].g_col\[1\].pe__2443_/B sky130_fd_sc_hd__xnor2_2
Xg_row\[1\].g_col\[0\].pe__2425_ g_row\[1\].g_col\[0\].pe__2425_/A g_row\[1\].g_col\[0\].pe__2425_/B
+ VGND VGND VPWR VPWR g_row\[1\].g_col\[0\].pe__2508_/A sky130_fd_sc_hd__nor2_2
XFILLER_49_393 VGND VGND VPWR VPWR sky130_fd_sc_hd__decap_3
XFILLER_65_820 VGND VGND VPWR VPWR sky130_fd_sc_hd__fill_2
Xg_row\[1\].g_col\[1\].pe__2372_ g_row\[1\].g_col\[1\].pe__2372_/A g_row\[1\].g_col\[1\].pe__2386_/A
+ VGND VGND VPWR VPWR g_row\[1\].g_col\[1\].pe__2385_/A sky130_fd_sc_hd__xnor2_2
Xg_row\[1\].g_col\[0\].pe__2356_ g_row\[1\].g_col\[0\].pe__2356_/A g_row\[1\].g_col\[0\].pe__2356_/B
+ VGND VGND VPWR VPWR g_row\[1\].g_col\[0\].pe__2377_/A sky130_fd_sc_hd__nor2_2
XFILLER_37_566 VGND VGND VPWR VPWR sky130_fd_sc_hd__decap_3
XFILLER_91_160 VGND VGND VPWR VPWR sky130_fd_sc_hd__fill_1
Xg_row\[0\].g_col\[0\].pe__2503_ g_row\[0\].g_col\[0\].pe__2579_/A g_row\[0\].g_col\[0\].pe__2503_/B
+ g_row\[0\].g_col\[0\].pe__2585_/B g_row\[0\].g_col\[0\].pe__2502_/X VGND VGND VPWR
+ VPWR g_row\[0\].g_col\[0\].pe__2506_/C sky130_fd_sc_hd__or4b_2
Xg_row\[1\].g_col\[0\].pe__2287_ g_row\[1\].g_col\[0\].pe__2287_/A g_row\[1\].g_col\[0\].pe__2309_/B
+ VGND VGND VPWR VPWR g_row\[1\].g_col\[0\].pe__2291_/A sky130_fd_sc_hd__xnor2_2
XFILLER_52_569 VGND VGND VPWR VPWR sky130_fd_sc_hd__decap_3
XTAP_TAPCELL_ROW_35_734 VGND VPWR sky130_fd_sc_hd__tapvpwrvgnd_1
Xg_row\[0\].g_col\[1\].pe__2450_ g_row\[0\].g_col\[1\].pe__2399_/Y g_row\[0\].g_col\[1\].pe__2742_/Q
+ g_row\[0\].g_col\[1\].pe__2453_/B VGND VGND VPWR VPWR g_row\[0\].g_col\[1\].pe__2451_/B
+ sky130_fd_sc_hd__a21o_2
Xg_row\[0\].g_col\[0\].pe__2434_ ANTENNA_43/DIODE g_row\[0\].g_col\[0\].pe__2434_/B
+ VGND VGND VPWR VPWR g_row\[0\].g_col\[0\].pe__2472_/B sky130_fd_sc_hd__xnor2_2
Xg_row\[0\].g_col\[1\].pe__1401_ g_row\[0\].g_col\[1\].pe__1401_/A1 g_row\[0\].g_col\[1\].pe__2678_/A
+ g_row\[0\].g_col\[1\].pe__1400_/X g_row\[0\].g_col\[1\].pe__2679_/C1 VGND VGND VPWR
+ VPWR g_row\[0\].g_col\[1\].pe__1401_/X sky130_fd_sc_hd__o211a_2
Xg_row\[0\].g_col\[0\].pe__2365_ g_row\[0\].g_col\[0\].pe__2365_/A g_row\[0\].g_col\[0\].pe__2365_/B
+ VGND VGND VPWR VPWR g_row\[0\].g_col\[0\].pe__2365_/X sky130_fd_sc_hd__and2_2
Xg_row\[0\].g_col\[1\].pe__2381_ g_row\[0\].g_col\[1\].pe__2381_/A g_row\[0\].g_col\[1\].pe__2381_/B
+ VGND VGND VPWR VPWR g_row\[0\].g_col\[1\].pe__2752_/D sky130_fd_sc_hd__and2_4
Xg_row\[0\].g_col\[0\].pe__2296_ g_row\[0\].g_col\[0\].pe__2329_/A g_row\[0\].g_col\[0\].pe__2296_/B
+ VGND VGND VPWR VPWR g_row\[0\].g_col\[0\].pe__2330_/C sky130_fd_sc_hd__nand2_2
Xg_row\[1\].g_col\[1\].pe__2708_ clkbuf_leaf_81_clk/X g_row\[1\].g_col\[1\].pe__2708_/D
+ VGND VGND VPWR VPWR g_row\[1\].g_col\[1\].pe__2708_/Q sky130_fd_sc_hd__dfxtp_2
Xg_row\[1\].g_col\[1\].pe__2639_ g_row\[1\].g_col\[1\].pe__2639_/A g_row\[1\].g_col\[1\].pe__2639_/B
+ VGND VGND VPWR VPWR g_row\[1\].g_col\[1\].pe__2639_/X sky130_fd_sc_hd__or2_2
XFILLER_28_533 VGND VGND VPWR VPWR sky130_fd_sc_hd__fill_2
Xg_row\[0\].g_col\[1\].pe_hold2144 g_row\[0\].g_col\[1\].pe_hold2219/X VGND VGND VPWR
+ VPWR g_row\[0\].g_col\[1\].pe__2673_/D sky130_fd_sc_hd__clkbuf_2
Xg_row\[0\].g_col\[1\].pe_hold2133 g_row\[0\].g_col\[1\].pe_hold2970/X VGND VGND VPWR
+ VPWR g_row\[0\].g_col\[1\].pe__2674_/D sky130_fd_sc_hd__clkbuf_2
Xg_row\[0\].g_col\[1\].pe_hold2155 g_row\[0\].g_col\[1\].pe__2729_/Q VGND VGND VPWR
+ VPWR g_row\[0\].g_col\[1\].pe__1386_/A1 sky130_fd_sc_hd__clkbuf_2
Xg_row\[0\].g_col\[1\].pe__2717_ clkbuf_leaf_94_clk/X g_row\[0\].g_col\[1\].pe__2717_/D
+ VGND VGND VPWR VPWR hold3115/A sky130_fd_sc_hd__dfxtp_2
XFILLER_15_238 VGND VGND VPWR VPWR sky130_fd_sc_hd__fill_2
XFILLER_43_536 VGND VGND VPWR VPWR sky130_fd_sc_hd__decap_3
XFILLER_70_344 VGND VGND VPWR VPWR sky130_fd_sc_hd__decap_3
Xg_row\[0\].g_col\[1\].pe_hold2188 g_row\[0\].g_col\[1\].pe__2696_/Q VGND VGND VPWR
+ VPWR g_row\[0\].g_col\[1\].pe__2614_/B sky130_fd_sc_hd__clkbuf_2
XFILLER_30_219 VGND VGND VPWR VPWR sky130_fd_sc_hd__decap_3
XFILLER_90_25 VGND VGND VPWR VPWR sky130_fd_sc_hd__decap_3
XTAP_TAPCELL_ROW_13_406 VGND VPWR sky130_fd_sc_hd__tapvpwrvgnd_1
Xg_row\[0\].g_col\[1\].pe__2648_ g_row\[0\].g_col\[1\].pe__2670_/A1 g_row\[0\].g_col\[1\].pe__2648_/A2
+ g_row\[0\].g_col\[1\].pe__2670_/B1 g_row\[0\].g_col\[1\].pe__2647_/X VGND VGND VPWR
+ VPWR g_row\[0\].g_col\[1\].pe__2648_/X sky130_fd_sc_hd__o211a_2
XFILLER_70_399 VGND VGND VPWR VPWR sky130_fd_sc_hd__fill_1
X_201_ _203_/A _201_/B_N VGND VGND VPWR VPWR _201_/Y sky130_fd_sc_hd__nor2b_4
Xg_row\[0\].g_col\[1\].pe__2579_ g_row\[0\].g_col\[1\].pe__2579_/A g_row\[0\].g_col\[1\].pe__2579_/B
+ g_row\[0\].g_col\[1\].pe__2579_/C VGND VGND VPWR VPWR g_row\[0\].g_col\[1\].pe__2579_/Y
+ sky130_fd_sc_hd__nand3_2
Xg_row\[0\].g_col\[0\].pe_place873 g_row\[0\].g_col\[0\].pe__1424_/Y VGND VGND VPWR
+ VPWR g_row\[0\].g_col\[0\].pe__1732_/B1 sky130_fd_sc_hd__buf_6
XFILLER_3_676 VGND VGND VPWR VPWR sky130_fd_sc_hd__decap_3
XFILLER_2_197 VGND VGND VPWR VPWR sky130_fd_sc_hd__fill_1
XFILLER_66_628 VGND VGND VPWR VPWR sky130_fd_sc_hd__fill_1
Xg_row\[1\].g_col\[0\].pe__2210_ g_row\[1\].g_col\[0\].pe__2210_/A g_row\[1\].g_col\[0\].pe__2210_/B
+ VGND VGND VPWR VPWR g_row\[1\].g_col\[0\].pe__2211_/A sky130_fd_sc_hd__xor2_2
XFILLER_46_330 VGND VGND VPWR VPWR sky130_fd_sc_hd__fill_1
XFILLER_34_503 VGND VGND VPWR VPWR sky130_fd_sc_hd__fill_2
XFILLER_74_683 VGND VGND VPWR VPWR sky130_fd_sc_hd__decap_3
Xg_row\[1\].g_col\[0\].pe__2141_ g_row\[1\].g_col\[0\].pe__2174_/A g_row\[1\].g_col\[0\].pe__2174_/B
+ VGND VGND VPWR VPWR g_row\[1\].g_col\[0\].pe__2187_/B sky130_fd_sc_hd__xor2_2
XFILLER_61_333 VGND VGND VPWR VPWR sky130_fd_sc_hd__fill_1
Xg_row\[1\].g_col\[0\].pe__2072_ g_row\[1\].g_col\[0\].pe__2038_/B g_row\[1\].g_col\[0\].pe__2038_/C
+ g_row\[1\].g_col\[0\].pe__2038_/A VGND VGND VPWR VPWR g_row\[1\].g_col\[0\].pe__2077_/A
+ sky130_fd_sc_hd__a21boi_2
Xg_row\[0\].g_col\[0\].pe__2150_ g_row\[0\].g_col\[0\].pe__2111_/A g_row\[0\].g_col\[0\].pe__2153_/C
+ g_row\[0\].g_col\[0\].pe__2150_/C VGND VGND VPWR VPWR g_row\[0\].g_col\[0\].pe__2150_/X
+ sky130_fd_sc_hd__and3b_2
Xg_row\[0\].g_col\[0\].pe__2081_ g_row\[0\].g_col\[0\].pe__2167_/A g_row\[0\].g_col\[0\].pe__2081_/B
+ g_row\[0\].g_col\[0\].pe__2081_/C VGND VGND VPWR VPWR g_row\[0\].g_col\[0\].pe__2087_/A
+ sky130_fd_sc_hd__nand3b_2
Xg_row\[1\].g_col\[1\].pe__1941_ g_row\[1\].g_col\[1\].pe__1941_/A g_row\[1\].g_col\[1\].pe__1941_/B
+ g_row\[1\].g_col\[1\].pe__1941_/C VGND VGND VPWR VPWR g_row\[1\].g_col\[1\].pe__1942_/B
+ sky130_fd_sc_hd__and3_2
Xg_row\[1\].g_col\[0\].pe__1925_ g_row\[1\].g_col\[0\].pe__1924_/B g_row\[1\].g_col\[0\].pe__1924_/C
+ g_row\[1\].g_col\[0\].pe__1924_/A VGND VGND VPWR VPWR g_row\[1\].g_col\[0\].pe__1980_/C
+ sky130_fd_sc_hd__o21a_2
Xg_row\[1\].g_col\[1\].pe__1872_ g_row\[1\].g_col\[1\].pe__2340_/B2 g_row\[1\].g_col\[1\].pe__1982_/B
+ g_row\[1\].g_col\[1\].pe__1424_/Y g_row\[1\].g_col\[1\].pe__2625_/B VGND VGND VPWR
+ VPWR g_row\[1\].g_col\[1\].pe__1873_/B sky130_fd_sc_hd__a22o_2
XTAP_TAPCELL_ROW_73_1308 VGND VPWR sky130_fd_sc_hd__tapvpwrvgnd_1
Xg_row\[1\].g_col\[0\].pe__1856_ g_row\[1\].g_col\[0\].pe__1857_/A g_row\[1\].g_col\[0\].pe__1857_/B
+ VGND VGND VPWR VPWR g_row\[1\].g_col\[0\].pe__1908_/A sky130_fd_sc_hd__nand2_2
Xhold3018 hold3018/A VGND VGND VPWR VPWR hold3018/X sky130_fd_sc_hd__clkbuf_2
Xhold3029 hold3029/A VGND VGND VPWR VPWR hold3029/X sky130_fd_sc_hd__clkbuf_2
Xg_row\[1\].g_col\[0\].pe__1787_ g_row\[1\].g_col\[0\].pe__1791_/A g_row\[1\].g_col\[0\].pe__1797_/A
+ VGND VGND VPWR VPWR g_row\[1\].g_col\[0\].pe__1789_/B sky130_fd_sc_hd__xor2_2
Xg_row\[0\].g_col\[0\].pe__1934_ g_row\[0\].g_col\[0\].pe__1999_/A g_row\[0\].g_col\[0\].pe__1999_/B
+ VGND VGND VPWR VPWR g_row\[0\].g_col\[0\].pe__1935_/B sky130_fd_sc_hd__xor2_2
Xhold1605 hold2760/X VGND VGND VPWR VPWR hold2761/A sky130_fd_sc_hd__clkbuf_2
Xhold1616 hold3564/X VGND VGND VPWR VPWR hold2783/A sky130_fd_sc_hd__clkbuf_2
Xhold2339 hold2339/A VGND VGND VPWR VPWR hold2339/X sky130_fd_sc_hd__clkbuf_2
Xg_row\[0\].g_col\[1\].pe__1950_ g_row\[0\].g_col\[1\].pe__1950_/A g_row\[0\].g_col\[1\].pe__1950_/B
+ VGND VGND VPWR VPWR g_row\[0\].g_col\[1\].pe__1950_/Y sky130_fd_sc_hd__nand2_2
XFILLER_84_447 VGND VGND VPWR VPWR sky130_fd_sc_hd__fill_1
Xg_row\[0\].g_col\[0\].pe__1865_ g_row\[0\].g_col\[0\].pe__1899_/A g_row\[0\].g_col\[0\].pe__1899_/B
+ VGND VGND VPWR VPWR g_row\[0\].g_col\[0\].pe__1868_/A sky130_fd_sc_hd__xor2_2
Xhold1627 hold3572/X VGND VGND VPWR VPWR hold3573/A sky130_fd_sc_hd__clkbuf_2
Xhold1638 hold1658/X VGND VGND VPWR VPWR hold1638/X sky130_fd_sc_hd__clkbuf_2
Xg_row\[1\].g_col\[1\].pe__2424_ g_row\[1\].g_col\[1\].pe__2424_/A g_row\[1\].g_col\[1\].pe__2424_/B
+ VGND VGND VPWR VPWR g_row\[1\].g_col\[1\].pe__2425_/B sky130_fd_sc_hd__and2_2
Xg_row\[1\].g_col\[0\].pe__2408_ g_row\[1\].g_col\[0\].pe__2739_/Q VGND VGND VPWR
+ VPWR g_row\[1\].g_col\[0\].pe__2410_/B sky130_fd_sc_hd__inv_2
Xg_row\[0\].g_col\[1\].pe__1881_ g_row\[0\].g_col\[1\].pe__1936_/A g_row\[0\].g_col\[1\].pe__1936_/B
+ VGND VGND VPWR VPWR g_row\[0\].g_col\[1\].pe__1882_/B sky130_fd_sc_hd__xnor2_2
XFILLER_37_374 VGND VGND VPWR VPWR sky130_fd_sc_hd__decap_3
Xg_row\[0\].g_col\[0\].pe__1796_ g_row\[0\].g_col\[0\].pe__1796_/A g_row\[0\].g_col\[0\].pe__1796_/B
+ VGND VGND VPWR VPWR g_row\[0\].g_col\[0\].pe__1797_/B sky130_fd_sc_hd__or2_2
Xg_row\[1\].g_col\[1\].pe__2355_ g_row\[1\].g_col\[1\].pe__2355_/A g_row\[1\].g_col\[1\].pe__2355_/B
+ VGND VGND VPWR VPWR g_row\[1\].g_col\[1\].pe__2356_/B sky130_fd_sc_hd__nor2_2
Xg_row\[1\].g_col\[0\].pe__2339_ g_row\[1\].g_col\[0\].pe__2311_/A g_row\[1\].g_col\[0\].pe__2311_/B
+ g_row\[1\].g_col\[0\].pe__2319_/B g_row\[1\].g_col\[0\].pe__2318_/B g_row\[1\].g_col\[0\].pe__2318_/A
+ VGND VGND VPWR VPWR g_row\[1\].g_col\[0\].pe__2350_/A sky130_fd_sc_hd__a32o_2
XFILLER_25_558 VGND VGND VPWR VPWR sky130_fd_sc_hd__fill_2
XFILLER_52_333 VGND VGND VPWR VPWR sky130_fd_sc_hd__decap_3
XFILLER_64_193 VGND VGND VPWR VPWR sky130_fd_sc_hd__decap_3
XFILLER_80_653 VGND VGND VPWR VPWR sky130_fd_sc_hd__fill_1
Xg_row\[1\].g_col\[1\].pe__2286_ g_row\[1\].g_col\[1\].pe__2286_/A g_row\[1\].g_col\[1\].pe__2310_/B
+ VGND VGND VPWR VPWR g_row\[1\].g_col\[1\].pe__2309_/B sky130_fd_sc_hd__xnor2_2
Xg_row\[1\].g_col\[0\].pe_place1110 g_row\[1\].g_col\[0\].pe__2679_/C1 VGND VGND VPWR
+ VPWR g_row\[1\].g_col\[0\].pe__2677_/B1 sky130_fd_sc_hd__buf_6
Xg_row\[0\].g_col\[1\].pe__2502_ g_row\[0\].g_col\[1\].pe__2551_/A g_row\[0\].g_col\[1\].pe__2558_/B
+ g_row\[0\].g_col\[1\].pe__2546_/B g_row\[0\].g_col\[1\].pe__2502_/D VGND VGND VPWR
+ VPWR g_row\[0\].g_col\[1\].pe__2502_/X sky130_fd_sc_hd__and4_2
Xg_row\[0\].g_col\[0\].pe__2417_ g_row\[0\].g_col\[0\].pe__2754_/Q g_row\[0\].g_col\[0\].pe__2266_/Y
+ g_row\[0\].g_col\[0\].pe__2434_/B VGND VGND VPWR VPWR g_row\[0\].g_col\[0\].pe__2432_/B
+ sky130_fd_sc_hd__o21ai_2
Xg_row\[0\].g_col\[1\].pe__2433_ g_row\[0\].g_col\[1\].pe__2474_/B g_row\[0\].g_col\[1\].pe__2766_/Q
+ VGND VGND VPWR VPWR g_row\[0\].g_col\[1\].pe__2487_/B sky130_fd_sc_hd__and2b_2
Xg_row\[0\].g_col\[1\].pe__2364_ g_row\[0\].g_col\[1\].pe__2364_/A g_row\[0\].g_col\[1\].pe__2364_/B
+ VGND VGND VPWR VPWR g_row\[0\].g_col\[1\].pe__2365_/B sky130_fd_sc_hd__xnor2_2
Xg_row\[0\].g_col\[0\].pe__2348_ g_row\[0\].g_col\[0\].pe__2348_/A g_row\[0\].g_col\[0\].pe__2348_/B
+ VGND VGND VPWR VPWR g_row\[0\].g_col\[0\].pe__2349_/B sky130_fd_sc_hd__nand2_2
Xg_row\[0\].g_col\[0\].pe_place1219 place1220/X VGND VGND VPWR VPWR g_row\[0\].g_col\[0\].pe__1672_/A1
+ sky130_fd_sc_hd__buf_6
Xg_row\[0\].g_col\[0\].pe__2279_ g_row\[0\].g_col\[0\].pe__2121_/A g_row\[0\].g_col\[0\].pe__2279_/A2
+ g_row\[0\].g_col\[0\].pe__2279_/B1 g_row\[0\].g_col\[0\].pe__2083_/A VGND VGND VPWR
+ VPWR g_row\[0\].g_col\[0\].pe__2280_/B sky130_fd_sc_hd__a22o_2
Xg_row\[0\].g_col\[1\].pe__2295_ g_row\[0\].g_col\[1\].pe__2295_/A g_row\[0\].g_col\[1\].pe__2295_/B
+ g_row\[0\].g_col\[1\].pe__2292_/X VGND VGND VPWR VPWR g_row\[0\].g_col\[1\].pe__2296_/B
+ sky130_fd_sc_hd__or3b_2
Xg_row\[1\].g_col\[1\].pe_hold2826 g_row\[1\].g_col\[1\].pe__2720_/Q VGND VGND VPWR
+ VPWR g_row\[1\].g_col\[1\].pe__2669_/B sky130_fd_sc_hd__clkbuf_2
XFILLER_0_602 VGND VGND VPWR VPWR sky130_fd_sc_hd__fill_1
Xhold3552 hold3552/A VGND VGND VPWR VPWR hold3552/X sky130_fd_sc_hd__clkbuf_2
Xhold3541 a_inputs_flat[24] VGND VGND VPWR VPWR hold3541/X sky130_fd_sc_hd__clkbuf_2
Xhold3530 hold3530/A VGND VGND VPWR VPWR hold3530/X sky130_fd_sc_hd__clkbuf_2
XFILLER_0_679 VGND VGND VPWR VPWR sky130_fd_sc_hd__decap_3
XFILLER_87_263 VGND VGND VPWR VPWR sky130_fd_sc_hd__fill_1
Xhold3585 hold3585/A VGND VGND VPWR VPWR hold3585/X sky130_fd_sc_hd__clkbuf_2
Xhold3574 hold3574/A VGND VGND VPWR VPWR hold3574/X sky130_fd_sc_hd__clkbuf_2
Xhold3563 hold3563/A VGND VGND VPWR VPWR hold3563/X sky130_fd_sc_hd__clkbuf_2
XFILLER_48_639 VGND VGND VPWR VPWR sky130_fd_sc_hd__fill_2
XFILLER_16_536 VGND VGND VPWR VPWR sky130_fd_sc_hd__decap_3
XFILLER_70_141 VGND VGND VPWR VPWR sky130_fd_sc_hd__fill_2
XTAP_TAPCELL_ROW_26_597 VGND VPWR sky130_fd_sc_hd__tapvpwrvgnd_1
Xg_row\[0\].g_col\[1\].pe_place1142 g_row\[0\].g_col\[1\].pe__2701_/Q VGND VGND VPWR
+ VPWR g_row\[0\].g_col\[1\].pe__2625_/B sky130_fd_sc_hd__buf_6
Xg_row\[0\].g_col\[1\].pe_place1131 g_row\[0\].g_col\[1\].pe__2726_/Q VGND VGND VPWR
+ VPWR g_row\[0\].g_col\[1\].pe__2045_/A sky130_fd_sc_hd__buf_6
Xg_row\[0\].g_col\[1\].pe_place1120 g_row\[0\].g_col\[1\].pe_hold3110/X VGND VGND
+ VPWR VPWR g_row\[0\].g_col\[1\].pe__2250_/A sky130_fd_sc_hd__buf_6
Xg_row\[0\].g_col\[1\].pe_place1164 g_row\[0\].g_col\[1\].pe__2690_/Q VGND VGND VPWR
+ VPWR g_row\[0\].g_col\[1\].pe__1801_/A sky130_fd_sc_hd__buf_6
Xg_row\[0\].g_col\[1\].pe_place1153 g_row\[0\].g_col\[1\].pe__2073_/B2 VGND VGND VPWR
+ VPWR g_row\[0\].g_col\[1\].pe__1749_/A2 sky130_fd_sc_hd__buf_6
XFILLER_8_757 VGND VGND VPWR VPWR sky130_fd_sc_hd__decap_3
Xg_row\[1\].g_col\[0\].pe__1710_ place1100/X g_row\[1\].g_col\[0\].pe__1732_/A2 g_row\[1\].g_col\[0\].pe__1732_/B1
+ place1102/X VGND VGND VPWR VPWR g_row\[1\].g_col\[0\].pe__1711_/B sky130_fd_sc_hd__a22o_2
Xg_row\[1\].g_col\[0\].pe__2690_ _294_/CLK g_row\[1\].g_col\[0\].pe__2690_/D VGND
+ VGND VPWR VPWR place1106/A sky130_fd_sc_hd__dfxtp_2
XTAP_TAPCELL_ROW_55_1038 VGND VPWR sky130_fd_sc_hd__tapvpwrvgnd_1
Xg_row\[1\].g_col\[0\].pe__1641_ g_row\[1\].g_col\[0\].pe__1749_/A1 place1087/X place1089/X
+ g_row\[1\].g_col\[0\].pe__1641_/B2 VGND VGND VPWR VPWR g_row\[1\].g_col\[0\].pe__1642_/B
+ sky130_fd_sc_hd__a22o_2
Xg_row\[1\].g_col\[0\].pe__1572_ g_row\[1\].g_col\[0\].pe__1749_/A1 hold1989/A place1080/X
+ g_row\[1\].g_col\[0\].pe__1641_/B2 VGND VGND VPWR VPWR g_row\[1\].g_col\[0\].pe__1573_/B
+ sky130_fd_sc_hd__a22o_2
Xg_row\[1\].g_col\[0\].pe_hold1825 g_row\[1\].g_col\[0\].pe__2758_/Q VGND VGND VPWR
+ VPWR g_row\[1\].g_col\[0\].pe__2528_/A1 sky130_fd_sc_hd__clkbuf_2
Xg_row\[1\].g_col\[0\].pe_hold1869 g_row\[1\].g_col\[0\].pe__2617_/X VGND VGND VPWR
+ VPWR g_row\[1\].g_col\[0\].pe__2697_/D sky130_fd_sc_hd__clkbuf_2
Xg_row\[1\].g_col\[0\].pe_hold1858 g_row\[1\].g_col\[0\].pe_hold2913/X VGND VGND VPWR
+ VPWR g_row\[1\].g_col\[0\].pe_hold2914/A sky130_fd_sc_hd__clkbuf_2
Xg_row\[0\].g_col\[0\].pe__1650_ g_row\[0\].g_col\[0\].pe__1650_/A g_row\[0\].g_col\[0\].pe__1650_/B
+ VGND VGND VPWR VPWR g_row\[0\].g_col\[0\].pe__1660_/B sky130_fd_sc_hd__xnor2_2
XFILLER_62_642 VGND VGND VPWR VPWR sky130_fd_sc_hd__fill_2
Xg_row\[0\].g_col\[0\].pe__1581_ g_row\[0\].g_col\[0\].pe__1523_/A g_row\[0\].g_col\[0\].pe__1523_/B
+ g_row\[0\].g_col\[0\].pe__1580_/X VGND VGND VPWR VPWR g_row\[0\].g_col\[0\].pe__1582_/B
+ sky130_fd_sc_hd__a21oi_2
Xg_row\[1\].g_col\[1\].pe__2140_ g_row\[1\].g_col\[1\].pe__2364_/A g_row\[1\].g_col\[1\].pe__2140_/B
+ VGND VGND VPWR VPWR g_row\[1\].g_col\[1\].pe__2174_/B sky130_fd_sc_hd__xnor2_2
Xg_row\[1\].g_col\[0\].pe__2124_ g_row\[1\].g_col\[0\].pe__2123_/B g_row\[1\].g_col\[0\].pe__2123_/C
+ g_row\[1\].g_col\[0\].pe__2165_/A VGND VGND VPWR VPWR g_row\[1\].g_col\[0\].pe__2128_/C
+ sky130_fd_sc_hd__a21o_2
Xg_row\[1\].g_col\[1\].pe__2071_ g_row\[1\].g_col\[1\].pe__2071_/A g_row\[1\].g_col\[1\].pe__2071_/B
+ VGND VGND VPWR VPWR g_row\[1\].g_col\[1\].pe__2078_/A sky130_fd_sc_hd__and2_2
XTAP_TAPCELL_ROW_45_884 VGND VPWR sky130_fd_sc_hd__tapvpwrvgnd_1
Xg_row\[1\].g_col\[0\].pe__2055_ g_row\[1\].g_col\[0\].pe__2055_/A g_row\[1\].g_col\[0\].pe__2055_/B
+ VGND VGND VPWR VPWR g_row\[1\].g_col\[0\].pe__2055_/Y sky130_fd_sc_hd__nor2_2
Xg_row\[0\].g_col\[0\].pe__2202_ g_row\[0\].g_col\[0\].pe__2202_/A g_row\[0\].g_col\[0\].pe__2202_/B
+ VGND VGND VPWR VPWR g_row\[0\].g_col\[0\].pe__2238_/A sky130_fd_sc_hd__nor2_2
XFILLER_30_583 VGND VGND VPWR VPWR sky130_fd_sc_hd__decap_3
Xg_row\[0\].g_col\[0\].pe__2133_ g_row\[0\].g_col\[0\].pe__2184_/C g_row\[0\].g_col\[0\].pe__2184_/B
+ g_row\[0\].g_col\[0\].pe__2222_/A VGND VGND VPWR VPWR g_row\[0\].g_col\[0\].pe__2135_/A
+ sky130_fd_sc_hd__a21bo_2
Xg_row\[0\].g_col\[0\].pe__2064_ g_row\[0\].g_col\[0\].pe__2335_/A g_row\[0\].g_col\[0\].pe__2064_/B
+ VGND VGND VPWR VPWR g_row\[0\].g_col\[0\].pe__2064_/Y sky130_fd_sc_hd__nor2_2
Xg_row\[1\].g_col\[1\].pe__1924_ g_row\[1\].g_col\[1\].pe__2094_/A g_row\[1\].g_col\[1\].pe__1924_/B
+ g_row\[1\].g_col\[1\].pe__1924_/C VGND VGND VPWR VPWR g_row\[1\].g_col\[1\].pe__1980_/B
+ sky130_fd_sc_hd__nor3_2
Xg_row\[0\].g_col\[1\].pe__2080_ g_row\[0\].g_col\[1\].pe__1449_/A g_row\[0\].g_col\[1\].pe__1449_/B
+ g_row\[0\].g_col\[1\].pe__1983_/Y VGND VGND VPWR VPWR g_row\[0\].g_col\[1\].pe__2081_/C
+ sky130_fd_sc_hd__a21o_2
Xg_row\[1\].g_col\[0\].pe__1908_ g_row\[1\].g_col\[0\].pe__1908_/A g_row\[1\].g_col\[0\].pe__1908_/B
+ VGND VGND VPWR VPWR g_row\[1\].g_col\[0\].pe__1935_/A sky130_fd_sc_hd__xor2_2
XFILLER_89_539 VGND VGND VPWR VPWR sky130_fd_sc_hd__decap_3
Xg_row\[1\].g_col\[1\].pe__1855_ g_row\[1\].g_col\[1\].pe__2075_/A g_row\[1\].g_col\[1\].pe__1855_/B
+ VGND VGND VPWR VPWR g_row\[1\].g_col\[1\].pe__1857_/B sky130_fd_sc_hd__xnor2_2
Xg_row\[1\].g_col\[1\].pe__1786_ g_row\[1\].g_col\[1\].pe__1796_/A g_row\[1\].g_col\[1\].pe__1796_/B
+ VGND VGND VPWR VPWR g_row\[1\].g_col\[1\].pe__1797_/A sky130_fd_sc_hd__nand2_2
XFILLER_85_701 VGND VGND VPWR VPWR sky130_fd_sc_hd__decap_3
XFILLER_29_105 VGND VGND VPWR VPWR sky130_fd_sc_hd__fill_2
XFILLER_85_723 VGND VGND VPWR VPWR sky130_fd_sc_hd__decap_3
Xg_row\[0\].g_col\[1\].pe__1933_ g_row\[0\].g_col\[1\].pe__1878_/A g_row\[0\].g_col\[1\].pe__1878_/B
+ g_row\[0\].g_col\[1\].pe__1932_/X VGND VGND VPWR VPWR g_row\[0\].g_col\[1\].pe__1999_/B
+ sky130_fd_sc_hd__a21oi_2
XFILLER_57_447 VGND VGND VPWR VPWR sky130_fd_sc_hd__fill_1
XFILLER_85_778 VGND VGND VPWR VPWR sky130_fd_sc_hd__decap_3
Xg_row\[0\].g_col\[0\].pe__1917_ g_row\[0\].g_col\[0\].pe__2045_/A g_row\[0\].g_col\[0\].pe__2045_/B
+ VGND VGND VPWR VPWR g_row\[0\].g_col\[0\].pe__2094_/B sky130_fd_sc_hd__or2_2
Xhold1435 hold3173/X VGND VGND VPWR VPWR hold3174/A sky130_fd_sc_hd__clkbuf_2
Xhold1446 hold2442/X VGND VGND VPWR VPWR hold2443/A sky130_fd_sc_hd__clkbuf_2
Xhold1457 hold3205/X VGND VGND VPWR VPWR hold3206/A sky130_fd_sc_hd__clkbuf_2
Xhold1468 hold3243/X VGND VGND VPWR VPWR hold3244/A sky130_fd_sc_hd__clkbuf_2
Xg_row\[0\].g_col\[0\].pe__1848_ g_row\[0\].g_col\[0\].pe__1606_/A g_row\[0\].g_col\[0\].pe__1848_/B
+ VGND VGND VPWR VPWR g_row\[0\].g_col\[0\].pe__1850_/A sky130_fd_sc_hd__and2b_2
Xhold1479 hold2514/X VGND VGND VPWR VPWR hold2515/A sky130_fd_sc_hd__clkbuf_2
Xg_row\[0\].g_col\[1\].pe__1864_ g_row\[0\].g_col\[1\].pe__1864_/A g_row\[0\].g_col\[1\].pe__1864_/B
+ VGND VGND VPWR VPWR g_row\[0\].g_col\[1\].pe__1899_/B sky130_fd_sc_hd__xnor2_2
Xg_row\[0\].g_col\[0\].pe__1779_ g_row\[0\].g_col\[0\].pe__1813_/A g_row\[0\].g_col\[0\].pe__1813_/B
+ VGND VGND VPWR VPWR g_row\[0\].g_col\[0\].pe__1779_/Y sky130_fd_sc_hd__nor2_2
Xg_row\[1\].g_col\[1\].pe__2338_ g_row\[1\].g_col\[1\].pe__2338_/A g_row\[1\].g_col\[1\].pe__2325_/A
+ VGND VGND VPWR VPWR g_row\[1\].g_col\[1\].pe__2352_/B sky130_fd_sc_hd__or2b_2
Xg_row\[0\].g_col\[1\].pe__1795_ g_row\[0\].g_col\[1\].pe__1795_/A g_row\[0\].g_col\[1\].pe__1795_/B
+ g_row\[0\].g_col\[1\].pe__1795_/C VGND VGND VPWR VPWR g_row\[0\].g_col\[1\].pe__1811_/B
+ sky130_fd_sc_hd__and3_2
Xg_row\[1\].g_col\[1\].pe__2269_ g_row\[1\].g_col\[1\].pe__2269_/A VGND VGND VPWR
+ VPWR g_row\[1\].g_col\[1\].pe__2432_/A sky130_fd_sc_hd__inv_2
XTAP_TAPCELL_ROW_23_556 VGND VPWR sky130_fd_sc_hd__tapvpwrvgnd_1
Xg_row\[0\].g_col\[1\].pe__2416_ g_row\[0\].g_col\[1\].pe__2421_/A1 g_row\[0\].g_col\[1\].pe__2747_/Q
+ g_row\[0\].g_col\[1\].pe__2436_/B VGND VGND VPWR VPWR g_row\[0\].g_col\[1\].pe__2434_/B
+ sky130_fd_sc_hd__a21oi_2
XFILLER_21_561 VGND VGND VPWR VPWR sky130_fd_sc_hd__decap_3
XFILLER_21_583 VGND VGND VPWR VPWR sky130_fd_sc_hd__fill_1
Xinput1312 hold3385/X VGND VGND VPWR VPWR hold3386/A sky130_fd_sc_hd__buf_2
Xinput1301 hold3448/X VGND VGND VPWR VPWR hold3449/A sky130_fd_sc_hd__buf_2
Xinput1345 hold3497/X VGND VGND VPWR VPWR hold3498/A sky130_fd_sc_hd__buf_2
Xinput1334 hold3196/X VGND VGND VPWR VPWR hold3197/A sky130_fd_sc_hd__buf_2
Xinput1323 hold3357/X VGND VGND VPWR VPWR hold3358/A sky130_fd_sc_hd__buf_2
Xg_row\[0\].g_col\[1\].pe__2347_ g_row\[0\].g_col\[1\].pe__2347_/A g_row\[0\].g_col\[1\].pe__2347_/B
+ VGND VGND VPWR VPWR g_row\[0\].g_col\[1\].pe__2368_/B sky130_fd_sc_hd__xor2_2
Xg_row\[0\].g_col\[1\].pe__2278_ g_row\[0\].g_col\[1\].pe__2625_/B g_row\[0\].g_col\[1\].pe__1558_/B
+ g_row\[0\].g_col\[1\].pe__2388_/B g_row\[0\].g_col\[1\].pe__2700_/Q VGND VGND VPWR
+ VPWR g_row\[0\].g_col\[1\].pe__2311_/A sky130_fd_sc_hd__a22o_2
XFILLER_0_421 VGND VGND VPWR VPWR sky130_fd_sc_hd__fill_1
Xg_row\[1\].g_col\[1\].pe_hold1955 g_row\[1\].g_col\[1\].pe_hold3103/X VGND VGND VPWR
+ VPWR g_row\[1\].g_col\[1\].pe__2729_/D sky130_fd_sc_hd__clkbuf_2
Xg_row\[1\].g_col\[1\].pe_hold1944 g_row\[1\].g_col\[1\].pe__2623_/X VGND VGND VPWR
+ VPWR g_row\[1\].g_col\[1\].pe__2624_/C1 sky130_fd_sc_hd__clkbuf_2
Xhold3360 hold3360/A VGND VGND VPWR VPWR hold3360/X sky130_fd_sc_hd__clkbuf_2
Xg_row\[1\].g_col\[1\].pe_hold1988 g_row\[1\].g_col\[1\].pe__2631_/X VGND VGND VPWR
+ VPWR g_row\[1\].g_col\[1\].pe__2703_/D sky130_fd_sc_hd__clkbuf_2
Xg_row\[1\].g_col\[1\].pe_hold1977 g_row\[1\].g_col\[1\].pe_hold2870/X VGND VGND VPWR
+ VPWR g_row\[1\].g_col\[1\].pe_hold2871/A sky130_fd_sc_hd__clkbuf_2
Xg_row\[1\].g_col\[1\].pe_hold1966 g_row\[1\].g_col\[1\].pe__2697_/Q VGND VGND VPWR
+ VPWR g_row\[1\].g_col\[1\].pe__2616_/B sky130_fd_sc_hd__clkbuf_2
XFILLER_76_745 VGND VGND VPWR VPWR sky130_fd_sc_hd__decap_3
Xhold3371 hold3371/A VGND VGND VPWR VPWR hold3371/X sky130_fd_sc_hd__clkbuf_2
Xhold3382 a_inputs_flat[4] VGND VGND VPWR VPWR hold3382/X sky130_fd_sc_hd__clkbuf_2
Xhold3393 hold3393/A VGND VGND VPWR VPWR hold3393/X sky130_fd_sc_hd__clkbuf_2
XFILLER_76_767 VGND VGND VPWR VPWR sky130_fd_sc_hd__fill_2
Xhold2670 _175_/Y VGND VGND VPWR VPWR hold2670/X sky130_fd_sc_hd__clkbuf_2
Xhold2681 hold3437/X VGND VGND VPWR VPWR _181_/B_N sky130_fd_sc_hd__clkbuf_2
Xhold2692 hold3484/X VGND VGND VPWR VPWR hold3485/A sky130_fd_sc_hd__clkbuf_2
XFILLER_91_726 VGND VGND VPWR VPWR sky130_fd_sc_hd__fill_2
XFILLER_16_300 VGND VGND VPWR VPWR sky130_fd_sc_hd__fill_2
XFILLER_28_193 VGND VGND VPWR VPWR sky130_fd_sc_hd__decap_3
XFILLER_29_694 VGND VGND VPWR VPWR sky130_fd_sc_hd__fill_1
XFILLER_44_620 VGND VGND VPWR VPWR sky130_fd_sc_hd__decap_3
XFILLER_16_377 VGND VGND VPWR VPWR sky130_fd_sc_hd__fill_2
XTAP_TAPCELL_ROW_42_843 VGND VPWR sky130_fd_sc_hd__tapvpwrvgnd_1
XFILLER_12_561 VGND VGND VPWR VPWR sky130_fd_sc_hd__fill_1
XFILLER_77_7 VGND VGND VPWR VPWR sky130_fd_sc_hd__fill_2
XANTENNA_4 a_inputs_flat[10] VGND VGND VPWR VPWR sky130_fd_sc_hd__diode_2
Xg_row\[1\].g_col\[0\].pe__2742_ clkbuf_leaf_59_clk/X g_row\[1\].g_col\[0\].pe__2742_/D
+ VGND VGND VPWR VPWR g_row\[1\].g_col\[0\].pe__2742_/Q sky130_fd_sc_hd__dfxtp_2
XFILLER_4_760 VGND VGND VPWR VPWR sky130_fd_sc_hd__decap_3
Xg_row\[1\].g_col\[0\].pe__2673_ hold3060/A hold1887/X hold2042/X hold2047/X VGND
+ VGND VPWR VPWR g_row\[1\].g_col\[0\].pe__2673_/X sky130_fd_sc_hd__or4_2
Xg_row\[1\].g_col\[1\].pe__1640_ g_row\[1\].g_col\[1\].pe__1640_/A g_row\[1\].g_col\[1\].pe__1640_/B
+ VGND VGND VPWR VPWR g_row\[1\].g_col\[1\].pe__1701_/A sky130_fd_sc_hd__xnor2_2
Xg_row\[1\].g_col\[0\].pe_hold3024 hold1876/X VGND VGND VPWR VPWR g_row\[1\].g_col\[0\].pe__2658_/A2
+ sky130_fd_sc_hd__clkbuf_2
Xg_row\[1\].g_col\[0\].pe_hold3013 g_row\[1\].g_col\[0\].pe__1403_/X VGND VGND VPWR
+ VPWR g_row\[1\].g_col\[0\].pe_hold3013/X sky130_fd_sc_hd__clkbuf_2
Xg_row\[1\].g_col\[0\].pe_hold3002 g_row\[1\].g_col\[0\].pe__2656_/X VGND VGND VPWR
+ VPWR g_row\[1\].g_col\[0\].pe_hold3002/X sky130_fd_sc_hd__clkbuf_2
Xg_row\[1\].g_col\[0\].pe__1624_ g_row\[1\].g_col\[0\].pe__2125_/C g_row\[1\].g_col\[0\].pe__1624_/B
+ VGND VGND VPWR VPWR g_row\[1\].g_col\[0\].pe__1625_/B sky130_fd_sc_hd__xor2_2
XFILLER_79_550 VGND VGND VPWR VPWR sky130_fd_sc_hd__fill_1
XFILLER_79_561 VGND VGND VPWR VPWR sky130_fd_sc_hd__fill_1
Xg_row\[1\].g_col\[0\].pe_hold3046 g_row\[1\].g_col\[0\].pe__2735_/Q VGND VGND VPWR
+ VPWR g_row\[1\].g_col\[0\].pe_hold3046/X sky130_fd_sc_hd__clkbuf_2
XFILLER_67_723 VGND VGND VPWR VPWR sky130_fd_sc_hd__decap_3
Xg_row\[1\].g_col\[1\].pe_place904 g_row\[1\].g_col\[1\].pe__2682_/B VGND VGND VPWR
+ VPWR g_row\[1\].g_col\[1\].pe__2686_/B sky130_fd_sc_hd__buf_6
Xg_row\[1\].g_col\[1\].pe__1571_ g_row\[1\].g_col\[1\].pe__1571_/A g_row\[1\].g_col\[1\].pe__1571_/B
+ VGND VGND VPWR VPWR g_row\[1\].g_col\[1\].pe__1583_/A sky130_fd_sc_hd__xor2_2
Xg_row\[1\].g_col\[0\].pe_hold3079 g_row\[1\].g_col\[0\].pe__2732_/Q VGND VGND VPWR
+ VPWR g_row\[1\].g_col\[0\].pe_hold3079/X sky130_fd_sc_hd__clkbuf_2
Xg_row\[1\].g_col\[0\].pe__1555_ g_row\[1\].g_col\[0\].pe__1555_/A g_row\[1\].g_col\[0\].pe__1555_/B
+ VGND VGND VPWR VPWR g_row\[1\].g_col\[0\].pe__1562_/B sky130_fd_sc_hd__and2_2
XFILLER_67_756 VGND VGND VPWR VPWR sky130_fd_sc_hd__fill_2
Xg_row\[0\].g_col\[0\].pe__2751_ clkbuf_leaf_25_clk/X g_row\[0\].g_col\[0\].pe__2751_/D
+ VGND VGND VPWR VPWR g_row\[0\].g_col\[0\].pe__2751_/Q sky130_fd_sc_hd__dfxtp_2
Xg_row\[1\].g_col\[0\].pe__1486_ g_row\[1\].g_col\[0\].pe__1730_/A g_row\[1\].g_col\[0\].pe__1486_/B
+ VGND VGND VPWR VPWR g_row\[1\].g_col\[0\].pe__1514_/B sky130_fd_sc_hd__xor2_2
XFILLER_66_266 VGND VGND VPWR VPWR sky130_fd_sc_hd__fill_2
XTAP_TAPCELL_ROW_1_218 VGND VPWR sky130_fd_sc_hd__tapvpwrvgnd_1
XTAP_TAPCELL_ROW_1_229 VGND VPWR sky130_fd_sc_hd__tapvpwrvgnd_1
XTAP_TAPCELL_ROW_68_1229 VGND VPWR sky130_fd_sc_hd__tapvpwrvgnd_1
Xg_row\[0\].g_col\[0\].pe__1702_ g_row\[0\].g_col\[0\].pe__1831_/A g_row\[0\].g_col\[0\].pe__1831_/B
+ g_row\[0\].g_col\[0\].pe__1827_/A g_row\[0\].g_col\[0\].pe__1827_/B VGND VGND VPWR
+ VPWR g_row\[0\].g_col\[0\].pe__1702_/X sky130_fd_sc_hd__o22a_2
Xg_row\[0\].g_col\[0\].pe__2682_ g_row\[0\].g_col\[0\].pe__2682_/A g_row\[0\].g_col\[0\].pe__2684_/B
+ VGND VGND VPWR VPWR g_row\[0\].g_col\[0\].pe__2682_/X sky130_fd_sc_hd__or2_2
XFILLER_81_225 VGND VGND VPWR VPWR sky130_fd_sc_hd__fill_2
Xg_row\[0\].g_col\[0\].pe__1633_ g_row\[0\].g_col\[0\].pe__1633_/A g_row\[0\].g_col\[0\].pe__1633_/B
+ VGND VGND VPWR VPWR g_row\[0\].g_col\[0\].pe__1845_/B sky130_fd_sc_hd__xor2_2
Xg_row\[0\].g_col\[1\].pe__1580_ g_row\[0\].g_col\[1\].pe__1580_/A g_row\[0\].g_col\[1\].pe__1580_/B
+ VGND VGND VPWR VPWR g_row\[0\].g_col\[1\].pe__1580_/X sky130_fd_sc_hd__and2_2
Xg_row\[1\].g_col\[1\].pe__2123_ g_row\[1\].g_col\[1\].pe__2165_/A g_row\[1\].g_col\[1\].pe__2123_/B
+ g_row\[1\].g_col\[1\].pe__2123_/C VGND VGND VPWR VPWR g_row\[1\].g_col\[1\].pe__2128_/B
+ sky130_fd_sc_hd__nand3_2
XFILLER_62_461 VGND VGND VPWR VPWR sky130_fd_sc_hd__fill_1
XTAP_TAPCELL_ROW_81_1418 VGND VPWR sky130_fd_sc_hd__tapvpwrvgnd_1
XTAP_TAPCELL_ROW_81_1429 VGND VPWR sky130_fd_sc_hd__tapvpwrvgnd_1
Xg_row\[0\].g_col\[0\].pe__1564_ place1205/A g_row\[0\].g_col\[0\].pe__2026_/B g_row\[0\].g_col\[0\].pe__1738_/B1
+ place1208/X VGND VGND VPWR VPWR g_row\[0\].g_col\[0\].pe__1565_/B sky130_fd_sc_hd__a22o_2
Xg_row\[1\].g_col\[0\].pe__2107_ g_row\[1\].g_col\[0\].pe__2107_/A g_row\[1\].g_col\[0\].pe__2107_/B
+ VGND VGND VPWR VPWR g_row\[1\].g_col\[0\].pe__2117_/B sky130_fd_sc_hd__xnor2_2
XFILLER_50_645 VGND VGND VPWR VPWR sky130_fd_sc_hd__decap_3
Xg_row\[0\].g_col\[0\].pe__1495_ g_row\[0\].g_col\[0\].pe__1864_/A g_row\[0\].g_col\[0\].pe__1495_/B
+ VGND VGND VPWR VPWR g_row\[0\].g_col\[0\].pe__1536_/B sky130_fd_sc_hd__xnor2_2
Xg_row\[1\].g_col\[1\].pe__2054_ g_row\[1\].g_col\[1\].pe__2054_/A g_row\[1\].g_col\[1\].pe__2054_/B
+ VGND VGND VPWR VPWR g_row\[1\].g_col\[1\].pe__2068_/A sky130_fd_sc_hd__nand2_2
Xg_row\[1\].g_col\[0\].pe__2038_ g_row\[1\].g_col\[0\].pe__2038_/A g_row\[1\].g_col\[0\].pe__2038_/B
+ g_row\[1\].g_col\[0\].pe__2038_/C VGND VGND VPWR VPWR g_row\[1\].g_col\[0\].pe__2048_/A
+ sky130_fd_sc_hd__nand3_2
XTAP_TAPCELL_ROW_20_504 VGND VPWR sky130_fd_sc_hd__tapvpwrvgnd_1
XTAP_TAPCELL_ROW_20_515 VGND VPWR sky130_fd_sc_hd__tapvpwrvgnd_1
Xg_row\[0\].g_col\[1\].pe__2201_ g_row\[0\].g_col\[1\].pe__2155_/B g_row\[0\].g_col\[1\].pe__2300_/A
+ g_row\[0\].g_col\[1\].pe__2299_/A VGND VGND VPWR VPWR g_row\[0\].g_col\[1\].pe__2233_/A
+ sky130_fd_sc_hd__a21o_2
Xg_row\[0\].g_col\[0\].pe__2116_ g_row\[0\].g_col\[0\].pe__2116_/A VGND VGND VPWR
+ VPWR ANTENNA_144/DIODE sky130_fd_sc_hd__inv_2
Xg_row\[0\].g_col\[1\].pe__2132_ g_row\[0\].g_col\[1\].pe__2132_/A g_row\[0\].g_col\[1\].pe__2132_/B
+ VGND VGND VPWR VPWR g_row\[0\].g_col\[1\].pe__2222_/A sky130_fd_sc_hd__xnor2_2
XFILLER_1_207 VGND VGND VPWR VPWR sky130_fd_sc_hd__decap_3
Xg_row\[0\].g_col\[0\].pe__2047_ g_row\[0\].g_col\[0\].pe__2047_/A g_row\[0\].g_col\[0\].pe__2047_/B
+ VGND VGND VPWR VPWR g_row\[0\].g_col\[0\].pe__2048_/C sky130_fd_sc_hd__xor2_2
Xplace1220 hold2363/X VGND VGND VPWR VPWR place1220/X sky130_fd_sc_hd__buf_6
Xg_row\[1\].g_col\[1\].pe__1907_ g_row\[1\].g_col\[1\].pe__1907_/A g_row\[1\].g_col\[1\].pe__1907_/B
+ VGND VGND VPWR VPWR g_row\[1\].g_col\[1\].pe__1908_/B sky130_fd_sc_hd__xor2_2
Xg_row\[0\].g_col\[1\].pe__2063_ g_row\[0\].g_col\[1\].pe__2157_/A g_row\[0\].g_col\[1\].pe__2061_/Y
+ g_row\[0\].g_col\[1\].pe__2062_/X g_row\[0\].g_col\[1\].pe__2063_/B1 g_row\[0\].g_col\[1\].pe__1950_/A
+ VGND VGND VPWR VPWR g_row\[0\].g_col\[1\].pe__2063_/Y sky130_fd_sc_hd__a32oi_2
Xplace1275 _205_/A VGND VGND VPWR VPWR _189_/A sky130_fd_sc_hd__buf_6
Xg_row\[1\].g_col\[1\].pe__1838_ g_row\[1\].g_col\[1\].pe__1838_/A place1233/X VGND
+ VGND VPWR VPWR g_row\[1\].g_col\[1\].pe__2010_/A sky130_fd_sc_hd__or2_2
Xg_row\[1\].g_col\[1\].pe__1769_ g_row\[1\].g_col\[1\].pe__1781_/A g_row\[1\].g_col\[1\].pe__1781_/B
+ VGND VGND VPWR VPWR g_row\[1\].g_col\[1\].pe__1793_/C sky130_fd_sc_hd__nand2_2
XFILLER_17_108 VGND VGND VPWR VPWR sky130_fd_sc_hd__decap_3
XFILLER_85_564 VGND VGND VPWR VPWR sky130_fd_sc_hd__decap_3
Xg_row\[0\].g_col\[1\].pe__1916_ g_row\[0\].g_col\[1\].pe__1916_/A g_row\[0\].g_col\[1\].pe__1916_/B
+ VGND VGND VPWR VPWR g_row\[0\].g_col\[1\].pe__1931_/A sky130_fd_sc_hd__xor2_2
XFILLER_73_737 VGND VGND VPWR VPWR sky130_fd_sc_hd__decap_3
XTAP_TAPCELL_ROW_28_626 VGND VPWR sky130_fd_sc_hd__tapvpwrvgnd_1
XTAP_TAPCELL_ROW_28_637 VGND VPWR sky130_fd_sc_hd__tapvpwrvgnd_1
Xg_row\[0\].g_col\[1\].pe__1847_ g_row\[0\].g_col\[1\].pe__1847_/A g_row\[0\].g_col\[1\].pe__1847_/B
+ VGND VGND VPWR VPWR g_row\[0\].g_col\[1\].pe__1888_/B sky130_fd_sc_hd__nor2_2
XFILLER_26_642 VGND VGND VPWR VPWR sky130_fd_sc_hd__fill_2
Xg_row\[0\].g_col\[1\].pe__1778_ g_row\[0\].g_col\[1\].pe__1778_/A g_row\[0\].g_col\[1\].pe__1816_/C
+ VGND VGND VPWR VPWR g_row\[0\].g_col\[1\].pe__1813_/B sky130_fd_sc_hd__xnor2_2
Xg_row\[1\].g_col\[1\].pe_hold1730 g_row\[1\].g_col\[1\].pe__2158_/X VGND VGND VPWR
+ VPWR g_row\[1\].g_col\[1\].pe__2159_/B sky130_fd_sc_hd__clkbuf_2
XFILLER_1_741 VGND VGND VPWR VPWR sky130_fd_sc_hd__fill_2
Xg_row\[1\].g_col\[1\].pe_hold1752 g_row\[1\].g_col\[1\].pe__2581_/X VGND VGND VPWR
+ VPWR g_row\[1\].g_col\[1\].pe__2582_/B sky130_fd_sc_hd__clkbuf_2
Xg_row\[1\].g_col\[1\].pe_hold1741 g_row\[1\].g_col\[1\].pe__2770_/Q VGND VGND VPWR
+ VPWR g_row\[1\].g_col\[1\].pe__2591_/A1 sky130_fd_sc_hd__clkbuf_2
XFILLER_49_701 VGND VGND VPWR VPWR sky130_fd_sc_hd__fill_1
Xg_row\[1\].g_col\[1\].pe_hold1796 g_row\[1\].g_col\[1\].pe_hold3063/X VGND VGND VPWR
+ VPWR g_row\[1\].g_col\[1\].pe__2702_/D sky130_fd_sc_hd__clkbuf_2
Xhold3190 hold3190/A VGND VGND VPWR VPWR hold3190/X sky130_fd_sc_hd__clkbuf_2
Xg_row\[1\].g_col\[0\].pe__1340_ g_row\[1\].g_col\[0\].pe__1340_/A VGND VGND VPWR
+ VPWR g_row\[1\].g_col\[0\].pe__2689_/A sky130_fd_sc_hd__inv_2
XFILLER_76_586 VGND VGND VPWR VPWR sky130_fd_sc_hd__fill_2
XTAP_TAPCELL_ROW_47_913 VGND VPWR sky130_fd_sc_hd__tapvpwrvgnd_1
XFILLER_17_620 VGND VGND VPWR VPWR sky130_fd_sc_hd__decap_3
XFILLER_29_480 VGND VGND VPWR VPWR sky130_fd_sc_hd__fill_1
XFILLER_91_545 VGND VGND VPWR VPWR sky130_fd_sc_hd__fill_2
XFILLER_16_130 VGND VGND VPWR VPWR sky130_fd_sc_hd__fill_1
XFILLER_16_141 VGND VGND VPWR VPWR sky130_fd_sc_hd__decap_3
XFILLER_17_664 VGND VGND VPWR VPWR sky130_fd_sc_hd__decap_3
XFILLER_44_461 VGND VGND VPWR VPWR sky130_fd_sc_hd__decap_3
XFILLER_44_483 VGND VGND VPWR VPWR sky130_fd_sc_hd__decap_3
Xg_row\[0\].g_col\[0\].pe_hold2911 g_row\[0\].g_col\[0\].pe_hold2911/A VGND VGND VPWR
+ VPWR g_row\[0\].g_col\[0\].pe__2608_/A2 sky130_fd_sc_hd__clkbuf_2
XFILLER_20_807 VGND VGND VPWR VPWR sky130_fd_sc_hd__fill_1
XFILLER_32_645 VGND VGND VPWR VPWR sky130_fd_sc_hd__decap_3
XTAP_TAPCELL_ROW_63_1148 VGND VPWR sky130_fd_sc_hd__tapvpwrvgnd_1
XTAP_TAPCELL_ROW_63_1159 VGND VPWR sky130_fd_sc_hd__tapvpwrvgnd_1
Xg_row\[0\].g_col\[0\].pe_hold2922 g_row\[0\].g_col\[0\].pe__2615_/X VGND VGND VPWR
+ VPWR g_row\[0\].g_col\[0\].pe_hold2922/X sky130_fd_sc_hd__clkbuf_2
Xg_row\[0\].g_col\[0\].pe_hold2944 g_row\[0\].g_col\[0\].pe__2677_/X VGND VGND VPWR
+ VPWR g_row\[0\].g_col\[0\].pe_hold2944/X sky130_fd_sc_hd__clkbuf_2
Xg_row\[0\].g_col\[0\].pe_hold2955 g_row\[0\].g_col\[0\].pe__2733_/Q VGND VGND VPWR
+ VPWR g_row\[0\].g_col\[0\].pe__1395_/A1 sky130_fd_sc_hd__clkbuf_2
XFILLER_32_689 VGND VGND VPWR VPWR sky130_fd_sc_hd__fill_2
Xg_row\[0\].g_col\[0\].pe_hold2977 g_row\[0\].g_col\[0\].pe__2670_/X VGND VGND VPWR
+ VPWR g_row\[0\].g_col\[0\].pe_hold2977/X sky130_fd_sc_hd__clkbuf_2
XFILLER_9_841 VGND VGND VPWR VPWR sky130_fd_sc_hd__fill_1
XFILLER_68_3 VGND VGND VPWR VPWR sky130_fd_sc_hd__fill_1
XTAP_TAPCELL_ROW_78_1380 VGND VPWR sky130_fd_sc_hd__tapvpwrvgnd_1
Xg_row\[1\].g_col\[1\].pe__2741_ clkload16/A g_row\[1\].g_col\[1\].pe__2741_/D VGND
+ VGND VPWR VPWR g_row\[1\].g_col\[1\].pe__2741_/Q sky130_fd_sc_hd__dfxtp_2
Xg_row\[1\].g_col\[0\].pe__2725_ clkbuf_leaf_44_clk/X g_row\[1\].g_col\[0\].pe__2725_/D
+ VGND VGND VPWR VPWR g_row\[1\].g_col\[0\].pe__2725_/Q sky130_fd_sc_hd__dfxtp_2
Xg_row\[1\].g_col\[1\].pe__2672_ hold1781/X hold1976/X hold2088/X g_row\[1\].g_col\[1\].pe__2672_/D
+ VGND VGND VPWR VPWR g_row\[1\].g_col\[1\].pe__2672_/X sky130_fd_sc_hd__or4_2
Xg_row\[1\].g_col\[0\].pe__2656_ g_row\[1\].g_col\[0\].pe__2670_/A1 g_row\[1\].g_col\[0\].pe__2656_/A2
+ g_row\[1\].g_col\[0\].pe__2679_/C1 g_row\[1\].g_col\[0\].pe__2656_/C1 VGND VGND
+ VPWR VPWR g_row\[1\].g_col\[0\].pe__2656_/X sky130_fd_sc_hd__o211a_2
XFILLER_86_328 VGND VGND VPWR VPWR sky130_fd_sc_hd__fill_1
XTAP_TAPCELL_ROW_91_1580 VGND VPWR sky130_fd_sc_hd__tapvpwrvgnd_1
Xg_row\[1\].g_col\[1\].pe__1623_ g_row\[1\].g_col\[1\].pe__2625_/B g_row\[1\].g_col\[1\].pe__1982_/B
+ g_row\[1\].g_col\[1\].pe__1424_/Y g_row\[1\].g_col\[1\].pe__1970_/A VGND VGND VPWR
+ VPWR g_row\[1\].g_col\[1\].pe__1624_/B sky130_fd_sc_hd__a22o_2
Xg_row\[1\].g_col\[0\].pe__2587_ g_row\[1\].g_col\[0\].pe__2587_/A1 g_row\[1\].g_col\[0\].pe__2591_/A2
+ g_row\[1\].g_col\[0\].pe__2591_/B1 g_row\[1\].g_col\[0\].pe__2586_/X VGND VGND VPWR
+ VPWR g_row\[1\].g_col\[0\].pe__2587_/X sky130_fd_sc_hd__a22o_2
Xg_row\[1\].g_col\[0\].pe__1607_ g_row\[1\].g_col\[0\].pe__1607_/A g_row\[1\].g_col\[0\].pe__1849_/B
+ VGND VGND VPWR VPWR g_row\[1\].g_col\[0\].pe__1633_/A sky130_fd_sc_hd__xor2_2
.ends
