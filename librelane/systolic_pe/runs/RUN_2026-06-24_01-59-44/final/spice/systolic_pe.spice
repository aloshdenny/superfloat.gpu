* NGSPICE file created from systolic_pe.ext - technology: sky130A

* Black-box entry subcircuit for sky130_fd_sc_hd__decap_3 abstract view
.subckt sky130_fd_sc_hd__decap_3 VGND VNB VPB VPWR
.ends

* Black-box entry subcircuit for sky130_fd_sc_hd__xor2_2 abstract view
.subckt sky130_fd_sc_hd__xor2_2 A B VGND VNB VPB VPWR X
.ends

* Black-box entry subcircuit for sky130_fd_sc_hd__a31o_2 abstract view
.subckt sky130_fd_sc_hd__a31o_2 A1 A2 A3 B1 VGND VNB VPB VPWR X
.ends

* Black-box entry subcircuit for sky130_fd_sc_hd__tapvpwrvgnd_1 abstract view
.subckt sky130_fd_sc_hd__tapvpwrvgnd_1 VGND VPWR
.ends

* Black-box entry subcircuit for sky130_fd_sc_hd__fill_1 abstract view
.subckt sky130_fd_sc_hd__fill_1 VGND VNB VPB VPWR
.ends

* Black-box entry subcircuit for sky130_fd_sc_hd__fill_2 abstract view
.subckt sky130_fd_sc_hd__fill_2 VGND VNB VPB VPWR
.ends

* Black-box entry subcircuit for sky130_fd_sc_hd__a22o_2 abstract view
.subckt sky130_fd_sc_hd__a22o_2 A1 A2 B1 B2 VGND VNB VPB VPWR X
.ends

* Black-box entry subcircuit for sky130_fd_sc_hd__dfxtp_2 abstract view
.subckt sky130_fd_sc_hd__dfxtp_2 CLK D VGND VNB VPB VPWR Q
.ends

* Black-box entry subcircuit for sky130_fd_sc_hd__nor2_2 abstract view
.subckt sky130_fd_sc_hd__nor2_2 A B VGND VNB VPB VPWR Y
.ends

* Black-box entry subcircuit for sky130_fd_sc_hd__and3b_2 abstract view
.subckt sky130_fd_sc_hd__and3b_2 A_N B C VGND VNB VPB VPWR X
.ends

* Black-box entry subcircuit for sky130_fd_sc_hd__o211a_2 abstract view
.subckt sky130_fd_sc_hd__o211a_2 A1 A2 B1 C1 VGND VNB VPB VPWR X
.ends

* Black-box entry subcircuit for sky130_fd_sc_hd__o21a_2 abstract view
.subckt sky130_fd_sc_hd__o21a_2 A1 A2 B1 VGND VNB VPB VPWR X
.ends

* Black-box entry subcircuit for sky130_fd_sc_hd__nand2_2 abstract view
.subckt sky130_fd_sc_hd__nand2_2 A B VGND VNB VPB VPWR Y
.ends

* Black-box entry subcircuit for sky130_fd_sc_hd__clkbuf_8 abstract view
.subckt sky130_fd_sc_hd__clkbuf_8 A VGND VNB VPB VPWR X
.ends

* Black-box entry subcircuit for sky130_fd_sc_hd__buf_2 abstract view
.subckt sky130_fd_sc_hd__buf_2 A VGND VNB VPB VPWR X
.ends

* Black-box entry subcircuit for sky130_fd_sc_hd__or4_2 abstract view
.subckt sky130_fd_sc_hd__or4_2 A B C D VGND VNB VPB VPWR X
.ends

* Black-box entry subcircuit for sky130_fd_sc_hd__and2_2 abstract view
.subckt sky130_fd_sc_hd__and2_2 A B VGND VNB VPB VPWR X
.ends

* Black-box entry subcircuit for sky130_fd_sc_hd__a21o_2 abstract view
.subckt sky130_fd_sc_hd__a21o_2 A1 A2 B1 VGND VNB VPB VPWR X
.ends

* Black-box entry subcircuit for sky130_fd_sc_hd__buf_8 abstract view
.subckt sky130_fd_sc_hd__buf_8 A VGND VNB VPB VPWR X
.ends

* Black-box entry subcircuit for sky130_fd_sc_hd__or2_2 abstract view
.subckt sky130_fd_sc_hd__or2_2 A B VGND VNB VPB VPWR X
.ends

* Black-box entry subcircuit for sky130_fd_sc_hd__or3_2 abstract view
.subckt sky130_fd_sc_hd__or3_2 A B C VGND VNB VPB VPWR X
.ends

* Black-box entry subcircuit for sky130_fd_sc_hd__a221o_2 abstract view
.subckt sky130_fd_sc_hd__a221o_2 A1 A2 B1 B2 C1 VGND VNB VPB VPWR X
.ends

* Black-box entry subcircuit for sky130_fd_sc_hd__diode_2 abstract view
.subckt sky130_fd_sc_hd__diode_2 DIODE VGND VNB VPB VPWR
.ends

* Black-box entry subcircuit for sky130_fd_sc_hd__xnor2_2 abstract view
.subckt sky130_fd_sc_hd__xnor2_2 A B VGND VNB VPB VPWR Y
.ends

* Black-box entry subcircuit for sky130_fd_sc_hd__clkbuf_2 abstract view
.subckt sky130_fd_sc_hd__clkbuf_2 A VGND VNB VPB VPWR X
.ends

* Black-box entry subcircuit for sky130_fd_sc_hd__a32o_2 abstract view
.subckt sky130_fd_sc_hd__a32o_2 A1 A2 A3 B1 B2 VGND VNB VPB VPWR X
.ends

* Black-box entry subcircuit for sky130_fd_sc_hd__nand3_2 abstract view
.subckt sky130_fd_sc_hd__nand3_2 A B C VGND VNB VPB VPWR Y
.ends

* Black-box entry subcircuit for sky130_fd_sc_hd__buf_1 abstract view
.subckt sky130_fd_sc_hd__buf_1 A VGND VNB VPB VPWR X
.ends

* Black-box entry subcircuit for sky130_fd_sc_hd__clkbuf_1 abstract view
.subckt sky130_fd_sc_hd__clkbuf_1 A VGND VNB VPB VPWR X
.ends

* Black-box entry subcircuit for sky130_fd_sc_hd__a21oi_2 abstract view
.subckt sky130_fd_sc_hd__a21oi_2 A1 A2 B1 VGND VNB VPB VPWR Y
.ends

* Black-box entry subcircuit for sky130_fd_sc_hd__and3_2 abstract view
.subckt sky130_fd_sc_hd__and3_2 A B C VGND VNB VPB VPWR X
.ends

* Black-box entry subcircuit for sky130_fd_sc_hd__nor2b_2 abstract view
.subckt sky130_fd_sc_hd__nor2b_2 A B_N VGND VNB VPB VPWR Y
.ends

* Black-box entry subcircuit for sky130_fd_sc_hd__o21ba_2 abstract view
.subckt sky130_fd_sc_hd__o21ba_2 A1 A2 B1_N VGND VNB VPB VPWR X
.ends

* Black-box entry subcircuit for sky130_fd_sc_hd__o311a_2 abstract view
.subckt sky130_fd_sc_hd__o311a_2 A1 A2 A3 B1 C1 VGND VNB VPB VPWR X
.ends

* Black-box entry subcircuit for sky130_fd_sc_hd__o41a_2 abstract view
.subckt sky130_fd_sc_hd__o41a_2 A1 A2 A3 A4 B1 VGND VNB VPB VPWR X
.ends

* Black-box entry subcircuit for sky130_fd_sc_hd__or3b_2 abstract view
.subckt sky130_fd_sc_hd__or3b_2 A B C_N VGND VNB VPB VPWR X
.ends

* Black-box entry subcircuit for sky130_fd_sc_hd__and2b_2 abstract view
.subckt sky130_fd_sc_hd__and2b_2 A_N B VGND VNB VPB VPWR X
.ends

* Black-box entry subcircuit for sky130_fd_sc_hd__o32a_2 abstract view
.subckt sky130_fd_sc_hd__o32a_2 A1 A2 A3 B1 B2 VGND VNB VPB VPWR X
.ends

* Black-box entry subcircuit for sky130_fd_sc_hd__o21ai_2 abstract view
.subckt sky130_fd_sc_hd__o21ai_2 A1 A2 B1 VGND VNB VPB VPWR Y
.ends

* Black-box entry subcircuit for sky130_fd_sc_hd__nor3_2 abstract view
.subckt sky130_fd_sc_hd__nor3_2 A B C VGND VNB VPB VPWR Y
.ends

* Black-box entry subcircuit for sky130_fd_sc_hd__inv_2 abstract view
.subckt sky130_fd_sc_hd__inv_2 A VGND VNB VPB VPWR Y
.ends

* Black-box entry subcircuit for sky130_fd_sc_hd__a21o_4 abstract view
.subckt sky130_fd_sc_hd__a21o_4 A1 A2 B1 VGND VNB VPB VPWR X
.ends

* Black-box entry subcircuit for sky130_fd_sc_hd__nand2b_2 abstract view
.subckt sky130_fd_sc_hd__nand2b_2 A_N B VGND VNB VPB VPWR Y
.ends

* Black-box entry subcircuit for sky130_fd_sc_hd__or2b_2 abstract view
.subckt sky130_fd_sc_hd__or2b_2 A B_N VGND VNB VPB VPWR X
.ends

* Black-box entry subcircuit for sky130_fd_sc_hd__clkbuf_4 abstract view
.subckt sky130_fd_sc_hd__clkbuf_4 A VGND VNB VPB VPWR X
.ends

* Black-box entry subcircuit for sky130_fd_sc_hd__o22a_2 abstract view
.subckt sky130_fd_sc_hd__o22a_2 A1 A2 B1 B2 VGND VNB VPB VPWR X
.ends

* Black-box entry subcircuit for sky130_fd_sc_hd__a21boi_2 abstract view
.subckt sky130_fd_sc_hd__a21boi_2 A1 A2 B1_N VGND VNB VPB VPWR Y
.ends

* Black-box entry subcircuit for sky130_fd_sc_hd__o2bb2a_2 abstract view
.subckt sky130_fd_sc_hd__o2bb2a_2 A1_N A2_N B1 B2 VGND VNB VPB VPWR X
.ends

* Black-box entry subcircuit for sky130_fd_sc_hd__a2111o_2 abstract view
.subckt sky130_fd_sc_hd__a2111o_2 A1 A2 B1 C1 D1 VGND VNB VPB VPWR X
.ends

* Black-box entry subcircuit for sky130_fd_sc_hd__inv_6 abstract view
.subckt sky130_fd_sc_hd__inv_6 A VGND VNB VPB VPWR Y
.ends

* Black-box entry subcircuit for sky130_fd_sc_hd__o21bai_2 abstract view
.subckt sky130_fd_sc_hd__o21bai_2 A1 A2 B1_N VGND VNB VPB VPWR Y
.ends

* Black-box entry subcircuit for sky130_fd_sc_hd__and4b_2 abstract view
.subckt sky130_fd_sc_hd__and4b_2 A_N B C D VGND VNB VPB VPWR X
.ends

* Black-box entry subcircuit for sky130_fd_sc_hd__clkbuf_16 abstract view
.subckt sky130_fd_sc_hd__clkbuf_16 A VGND VNB VPB VPWR X
.ends

* Black-box entry subcircuit for sky130_fd_sc_hd__o21ai_4 abstract view
.subckt sky130_fd_sc_hd__o21ai_4 A1 A2 B1 VGND VNB VPB VPWR Y
.ends

* Black-box entry subcircuit for sky130_fd_sc_hd__and4_4 abstract view
.subckt sky130_fd_sc_hd__and4_4 A B C D VGND VNB VPB VPWR X
.ends

* Black-box entry subcircuit for sky130_fd_sc_hd__and2_4 abstract view
.subckt sky130_fd_sc_hd__and2_4 A B VGND VNB VPB VPWR X
.ends

* Black-box entry subcircuit for sky130_fd_sc_hd__nand4_2 abstract view
.subckt sky130_fd_sc_hd__nand4_2 A B C D VGND VNB VPB VPWR Y
.ends

* Black-box entry subcircuit for sky130_fd_sc_hd__o31a_2 abstract view
.subckt sky130_fd_sc_hd__o31a_2 A1 A2 A3 B1 VGND VNB VPB VPWR X
.ends

* Black-box entry subcircuit for sky130_fd_sc_hd__conb_1 abstract view
.subckt sky130_fd_sc_hd__conb_1 VGND VNB VPB VPWR HI LO
.ends

* Black-box entry subcircuit for sky130_fd_sc_hd__and4bb_2 abstract view
.subckt sky130_fd_sc_hd__and4bb_2 A_N B_N C D VGND VNB VPB VPWR X
.ends

* Black-box entry subcircuit for sky130_fd_sc_hd__a211oi_2 abstract view
.subckt sky130_fd_sc_hd__a211oi_2 A1 A2 B1 C1 VGND VNB VPB VPWR Y
.ends

* Black-box entry subcircuit for sky130_fd_sc_hd__o211ai_2 abstract view
.subckt sky130_fd_sc_hd__o211ai_2 A1 A2 B1 C1 VGND VNB VPB VPWR Y
.ends

* Black-box entry subcircuit for sky130_fd_sc_hd__a211o_2 abstract view
.subckt sky130_fd_sc_hd__a211o_2 A1 A2 B1 C1 VGND VNB VPB VPWR X
.ends

* Black-box entry subcircuit for sky130_fd_sc_hd__xor2_4 abstract view
.subckt sky130_fd_sc_hd__xor2_4 A B VGND VNB VPB VPWR X
.ends

* Black-box entry subcircuit for sky130_fd_sc_hd__or4_4 abstract view
.subckt sky130_fd_sc_hd__or4_4 A B C D VGND VNB VPB VPWR X
.ends

* Black-box entry subcircuit for sky130_fd_sc_hd__a21oi_4 abstract view
.subckt sky130_fd_sc_hd__a21oi_4 A1 A2 B1 VGND VNB VPB VPWR Y
.ends

* Black-box entry subcircuit for sky130_fd_sc_hd__or3b_4 abstract view
.subckt sky130_fd_sc_hd__or3b_4 A B C_N VGND VNB VPB VPWR X
.ends

* Black-box entry subcircuit for sky130_fd_sc_hd__or2_4 abstract view
.subckt sky130_fd_sc_hd__or2_4 A B VGND VNB VPB VPWR X
.ends

* Black-box entry subcircuit for sky130_fd_sc_hd__a41o_2 abstract view
.subckt sky130_fd_sc_hd__a41o_2 A1 A2 A3 A4 B1 VGND VNB VPB VPWR X
.ends

* Black-box entry subcircuit for sky130_fd_sc_hd__o21a_4 abstract view
.subckt sky130_fd_sc_hd__o21a_4 A1 A2 B1 VGND VNB VPB VPWR X
.ends

* Black-box entry subcircuit for sky130_fd_sc_hd__o31ai_2 abstract view
.subckt sky130_fd_sc_hd__o31ai_2 A1 A2 A3 B1 VGND VNB VPB VPWR Y
.ends

* Black-box entry subcircuit for sky130_fd_sc_hd__a311o_2 abstract view
.subckt sky130_fd_sc_hd__a311o_2 A1 A2 A3 B1 C1 VGND VNB VPB VPWR X
.ends

* Black-box entry subcircuit for sky130_fd_sc_hd__buf_6 abstract view
.subckt sky130_fd_sc_hd__buf_6 A VGND VNB VPB VPWR X
.ends

* Black-box entry subcircuit for sky130_fd_sc_hd__inv_4 abstract view
.subckt sky130_fd_sc_hd__inv_4 A VGND VNB VPB VPWR Y
.ends

* Black-box entry subcircuit for sky130_fd_sc_hd__buf_4 abstract view
.subckt sky130_fd_sc_hd__buf_4 A VGND VNB VPB VPWR X
.ends

* Black-box entry subcircuit for sky130_fd_sc_hd__fa_1 abstract view
.subckt sky130_fd_sc_hd__fa_1 A B CIN VGND VNB VPB VPWR COUT SUM
.ends

* Black-box entry subcircuit for sky130_fd_sc_hd__a21bo_2 abstract view
.subckt sky130_fd_sc_hd__a21bo_2 A1 A2 B1_N VGND VNB VPB VPWR X
.ends

* Black-box entry subcircuit for sky130_fd_sc_hd__nand4bb_2 abstract view
.subckt sky130_fd_sc_hd__nand4bb_2 A_N B_N C D VGND VNB VPB VPWR Y
.ends

* Black-box entry subcircuit for sky130_fd_sc_hd__and4_2 abstract view
.subckt sky130_fd_sc_hd__and4_2 A B C D VGND VNB VPB VPWR X
.ends

* Black-box entry subcircuit for sky130_fd_sc_hd__mux2_2 abstract view
.subckt sky130_fd_sc_hd__mux2_2 A0 A1 S VGND VNB VPB VPWR X
.ends

* Black-box entry subcircuit for sky130_fd_sc_hd__nand3b_2 abstract view
.subckt sky130_fd_sc_hd__nand3b_2 A_N B C VGND VNB VPB VPWR Y
.ends

.subckt systolic_pe VGND VPWR a_in[0] a_in[10] a_in[11] a_in[12] a_in[13] a_in[14]
+ a_in[15] a_in[1] a_in[2] a_in[3] a_in[4] a_in[5] a_in[6] a_in[7] a_in[8] a_in[9]
+ a_out[0] a_out[10] a_out[11] a_out[12] a_out[13] a_out[14] a_out[15] a_out[1] a_out[2]
+ a_out[3] a_out[4] a_out[5] a_out[6] a_out[7] a_out[8] a_out[9] acc_out[0] acc_out[10]
+ acc_out[11] acc_out[12] acc_out[13] acc_out[14] acc_out[15] acc_out[1] acc_out[2]
+ acc_out[3] acc_out[4] acc_out[5] acc_out[6] acc_out[7] acc_out[8] acc_out[9] b_in[0]
+ b_in[10] b_in[11] b_in[12] b_in[13] b_in[14] b_in[15] b_in[1] b_in[2] b_in[3] b_in[4]
+ b_in[5] b_in[6] b_in[7] b_in[8] b_in[9] b_out[0] b_out[10] b_out[11] b_out[12] b_out[13]
+ b_out[14] b_out[15] b_out[1] b_out[2] b_out[3] b_out[4] b_out[5] b_out[6] b_out[7]
+ b_out[8] b_out[9] clear_acc clk compute_enable enable load_weight reset
XFILLER_39_266 VGND VGND VPWR VPWR sky130_fd_sc_hd__decap_3
XFILLER_54_269 VGND VGND VPWR VPWR sky130_fd_sc_hd__decap_3
X_2106_ _2106_/A _2106_/B VGND VGND VPWR VPWR _2110_/A sky130_fd_sc_hd__xor2_2
X_2037_ _1998_/Y _1993_/Y _2070_/B _1792_/X VGND VGND VPWR VPWR _2037_/X sky130_fd_sc_hd__a31o_2
XFILLER_22_133 VGND VGND VPWR VPWR sky130_fd_sc_hd__decap_3
XFILLER_22_155 VGND VGND VPWR VPWR sky130_fd_sc_hd__decap_3
XFILLER_52_18 VGND VGND VPWR VPWR sky130_fd_sc_hd__decap_3
XFILLER_52_29 VGND VGND VPWR VPWR sky130_fd_sc_hd__decap_3
XTAP_TAPCELL_ROW_52_426 VGND VPWR sky130_fd_sc_hd__tapvpwrvgnd_1
XTAP_TAPCELL_ROW_60_470 VGND VPWR sky130_fd_sc_hd__tapvpwrvgnd_1
XFILLER_13_100 VGND VGND VPWR VPWR sky130_fd_sc_hd__fill_1
XFILLER_13_111 VGND VGND VPWR VPWR sky130_fd_sc_hd__fill_1
XFILLER_26_96 VGND VGND VPWR VPWR sky130_fd_sc_hd__fill_2
XFILLER_45_225 VGND VGND VPWR VPWR sky130_fd_sc_hd__decap_3
XFILLER_60_239 VGND VGND VPWR VPWR sky130_fd_sc_hd__decap_3
XFILLER_13_177 VGND VGND VPWR VPWR sky130_fd_sc_hd__fill_2
XTAP_TAPCELL_ROW_8_181 VGND VPWR sky130_fd_sc_hd__tapvpwrvgnd_1
XFILLER_36_247 VGND VGND VPWR VPWR sky130_fd_sc_hd__decap_3
XFILLER_8_192 VGND VGND VPWR VPWR sky130_fd_sc_hd__decap_3
X_1606_ _1606_/A1 _1697_/B _1677_/B1 _1700_/A2 VGND VGND VPWR VPWR _1607_/B sky130_fd_sc_hd__a22o_2
X_2655_ clkload1/A _2655_/D VGND VGND VPWR VPWR _2655_/Q sky130_fd_sc_hd__dfxtp_2
X_1468_ _2667_/Q _2295_/A VGND VGND VPWR VPWR _1469_/B sky130_fd_sc_hd__nor2_2
X_1537_ _2668_/Q _2667_/Q _2295_/A VGND VGND VPWR VPWR _1537_/X sky130_fd_sc_hd__and3b_2
X_2586_ _2588_/A1 _1349_/A _2602_/B1 _2585_/X VGND VGND VPWR VPWR _2586_/X sky130_fd_sc_hd__o211a_2
XFILLER_27_225 VGND VGND VPWR VPWR sky130_fd_sc_hd__fill_2
XFILLER_42_206 VGND VGND VPWR VPWR sky130_fd_sc_hd__decap_3
XFILLER_12_10 VGND VGND VPWR VPWR sky130_fd_sc_hd__fill_1
XFILLER_50_261 VGND VGND VPWR VPWR sky130_fd_sc_hd__decap_3
XFILLER_18_203 VGND VGND VPWR VPWR sky130_fd_sc_hd__decap_3
XFILLER_37_73 VGND VGND VPWR VPWR sky130_fd_sc_hd__fill_2
XFILLER_33_239 VGND VGND VPWR VPWR sky130_fd_sc_hd__decap_3
XFILLER_53_50 VGND VGND VPWR VPWR sky130_fd_sc_hd__decap_3
XTAP_TAPCELL_ROW_11_197 VGND VPWR sky130_fd_sc_hd__tapvpwrvgnd_1
X_2440_ _2440_/A _2440_/B VGND VGND VPWR VPWR _2523_/A sky130_fd_sc_hd__xor2_2
XFILLER_56_309 VGND VGND VPWR VPWR sky130_fd_sc_hd__decap_3
X_1322_ _2695_/Q _1321_/B _2708_/A VGND VGND VPWR VPWR _1323_/B sky130_fd_sc_hd__o21a_2
X_2371_ _2676_/Q _2371_/B VGND VGND VPWR VPWR _2372_/C sky130_fd_sc_hd__nand2_2
XFILLER_24_217 VGND VGND VPWR VPWR sky130_fd_sc_hd__decap_3
XTAP_TAPCELL_ROW_19_242 VGND VPWR sky130_fd_sc_hd__tapvpwrvgnd_1
XFILLER_32_283 VGND VGND VPWR VPWR sky130_fd_sc_hd__decap_3
Xclkbuf_4_12_0_clk clkbuf_0_clk/X VGND VGND VPWR VPWR _2703_/CLK sky130_fd_sc_hd__clkbuf_8
XFILLER_59_103 VGND VGND VPWR VPWR sky130_fd_sc_hd__fill_1
X_2707_ _2707_/A VGND VGND VPWR VPWR _2707_/X sky130_fd_sc_hd__buf_2
X_2638_ clkload9/A _2638_/D VGND VGND VPWR VPWR _2638_/Q sky130_fd_sc_hd__dfxtp_2
X_2569_ _2569_/A _2569_/B _2569_/C _2569_/D VGND VGND VPWR VPWR _2569_/X sky130_fd_sc_hd__or4_2
XFILLER_59_169 VGND VGND VPWR VPWR sky130_fd_sc_hd__decap_3
XFILLER_30_209 VGND VGND VPWR VPWR sky130_fd_sc_hd__decap_3
XFILLER_23_294 VGND VGND VPWR VPWR sky130_fd_sc_hd__decap_3
XFILLER_23_86 VGND VGND VPWR VPWR sky130_fd_sc_hd__fill_2
XFILLER_2_176 VGND VGND VPWR VPWR sky130_fd_sc_hd__fill_2
XFILLER_0_57 VGND VGND VPWR VPWR sky130_fd_sc_hd__fill_2
XFILLER_64_82 VGND VGND VPWR VPWR sky130_fd_sc_hd__fill_2
XTAP_TAPCELL_ROW_16_223 VGND VPWR sky130_fd_sc_hd__tapvpwrvgnd_1
XFILLER_14_250 VGND VGND VPWR VPWR sky130_fd_sc_hd__fill_2
XFILLER_9_55 VGND VGND VPWR VPWR sky130_fd_sc_hd__fill_1
XFILLER_9_99 VGND VGND VPWR VPWR sky130_fd_sc_hd__decap_3
X_1940_ _1940_/A _1940_/B VGND VGND VPWR VPWR _1954_/B sky130_fd_sc_hd__xor2_2
X_1871_ _1871_/A _1871_/B VGND VGND VPWR VPWR _1885_/A sky130_fd_sc_hd__xor2_2
XFILLER_50_3 VGND VGND VPWR VPWR sky130_fd_sc_hd__fill_2
X_2423_ _2423_/A _2423_/B VGND VGND VPWR VPWR _2480_/B sky130_fd_sc_hd__nor2_2
X_2354_ _2354_/A _2354_/B VGND VGND VPWR VPWR _2355_/B sky130_fd_sc_hd__and2_2
X_2285_ _2284_/A _2284_/C _2284_/B VGND VGND VPWR VPWR _2285_/X sky130_fd_sc_hd__a21o_2
XFILLER_52_312 VGND VGND VPWR VPWR sky130_fd_sc_hd__decap_3
XFILLER_64_150 VGND VGND VPWR VPWR sky130_fd_sc_hd__decap_3
XFILLER_64_172 VGND VGND VPWR VPWR sky130_fd_sc_hd__decap_3
XFILLER_64_194 VGND VGND VPWR VPWR sky130_fd_sc_hd__fill_2
XFILLER_20_242 VGND VGND VPWR VPWR sky130_fd_sc_hd__decap_3
XFILLER_20_253 VGND VGND VPWR VPWR sky130_fd_sc_hd__fill_1
XFILLER_60_29 VGND VGND VPWR VPWR sky130_fd_sc_hd__fill_1
XTAP_TAPCELL_ROW_22_259 VGND VPWR sky130_fd_sc_hd__tapvpwrvgnd_1
XFILLER_47_106 VGND VGND VPWR VPWR sky130_fd_sc_hd__decap_3
XFILLER_11_242 VGND VGND VPWR VPWR sky130_fd_sc_hd__decap_3
XFILLER_34_85 VGND VGND VPWR VPWR sky130_fd_sc_hd__fill_1
XFILLER_7_268 VGND VGND VPWR VPWR sky130_fd_sc_hd__decap_3
XFILLER_38_106 VGND VGND VPWR VPWR sky130_fd_sc_hd__fill_2
XFILLER_38_139 VGND VGND VPWR VPWR sky130_fd_sc_hd__fill_1
XFILLER_59_60 VGND VGND VPWR VPWR sky130_fd_sc_hd__decap_3
X_2070_ _2070_/A _2070_/B VGND VGND VPWR VPWR _2071_/C sky130_fd_sc_hd__nor2_2
XFILLER_46_183 VGND VGND VPWR VPWR sky130_fd_sc_hd__fill_1
XFILLER_61_153 VGND VGND VPWR VPWR sky130_fd_sc_hd__decap_3
Xmax_cap400 _1826_/A VGND VGND VPWR VPWR _1772_/A sky130_fd_sc_hd__buf_8
X_1923_ _1923_/A _1923_/B VGND VGND VPWR VPWR _1932_/A sky130_fd_sc_hd__xor2_2
X_1854_ _1908_/B2 _1555_/B _2095_/B1 _1854_/B2 VGND VGND VPWR VPWR _1858_/A sky130_fd_sc_hd__a22o_2
X_1785_ _1785_/A _1785_/B VGND VGND VPWR VPWR _1785_/X sky130_fd_sc_hd__or2_2
X_2406_ _2699_/Q _2406_/B VGND VGND VPWR VPWR _2407_/B sky130_fd_sc_hd__or2_2
XFILLER_25_301 VGND VGND VPWR VPWR sky130_fd_sc_hd__decap_3
XFILLER_29_106 VGND VGND VPWR VPWR sky130_fd_sc_hd__decap_3
XFILLER_29_128 VGND VGND VPWR VPWR sky130_fd_sc_hd__fill_1
XFILLER_29_139 VGND VGND VPWR VPWR sky130_fd_sc_hd__fill_2
XFILLER_37_150 VGND VGND VPWR VPWR sky130_fd_sc_hd__decap_3
X_2337_ _2678_/Q _2677_/Q _2372_/B VGND VGND VPWR VPWR _2360_/B sky130_fd_sc_hd__or3_2
X_2268_ _2292_/A _2292_/B VGND VGND VPWR VPWR _2270_/B sky130_fd_sc_hd__xor2_2
X_2199_ _2665_/Q _2198_/X _2197_/C _2666_/Q _2197_/B VGND VGND VPWR VPWR _2199_/X
+ sky130_fd_sc_hd__a221o_2
XFILLER_40_315 VGND VGND VPWR VPWR sky130_fd_sc_hd__decap_3
XFILLER_52_164 VGND VGND VPWR VPWR sky130_fd_sc_hd__decap_3
XFILLER_29_63 VGND VGND VPWR VPWR sky130_fd_sc_hd__fill_1
Xinput312 hold629/X VGND VGND VPWR VPWR hold630/A sky130_fd_sc_hd__buf_2
Xinput323 hold665/X VGND VGND VPWR VPWR hold666/A sky130_fd_sc_hd__buf_2
Xinput334 hold512/X VGND VGND VPWR VPWR hold513/A sky130_fd_sc_hd__buf_2
Xinput345 hold407/X VGND VGND VPWR VPWR hold408/A sky130_fd_sc_hd__buf_2
XFILLER_28_194 VGND VGND VPWR VPWR sky130_fd_sc_hd__fill_2
XFILLER_31_304 VGND VGND VPWR VPWR sky130_fd_sc_hd__decap_3
XFILLER_43_186 VGND VGND VPWR VPWR sky130_fd_sc_hd__decap_3
XTAP_TAPCELL_ROW_58_454 VGND VPWR sky130_fd_sc_hd__tapvpwrvgnd_1
XFILLER_6_34 VGND VGND VPWR VPWR sky130_fd_sc_hd__fill_2
XTAP_TAPCELL_ROW_41_365 VGND VPWR sky130_fd_sc_hd__tapvpwrvgnd_1
XANTENNA_5 hold550/A VGND VGND VPWR VPWR sky130_fd_sc_hd__diode_2
XFILLER_3_271 VGND VGND VPWR VPWR sky130_fd_sc_hd__decap_3
X_1570_ _1570_/A _1570_/B VGND VGND VPWR VPWR _1777_/A sky130_fd_sc_hd__xnor2_2
X_2122_ _2124_/A _2197_/B VGND VGND VPWR VPWR _2125_/D sky130_fd_sc_hd__or2_2
X_2053_ _2102_/A _2102_/B VGND VGND VPWR VPWR _2063_/A sky130_fd_sc_hd__xnor2_2
XFILLER_34_164 VGND VGND VPWR VPWR sky130_fd_sc_hd__decap_3
XFILLER_34_197 VGND VGND VPWR VPWR sky130_fd_sc_hd__decap_3
Xhold511 b_in[3] VGND VGND VPWR VPWR hold511/X sky130_fd_sc_hd__clkbuf_2
Xhold522 hold674/X VGND VGND VPWR VPWR hold522/X sky130_fd_sc_hd__clkbuf_2
Xhold533 _2604_/A VGND VGND VPWR VPWR _1365_/A sky130_fd_sc_hd__clkbuf_2
Xhold544 hold544/A VGND VGND VPWR VPWR hold544/X sky130_fd_sc_hd__clkbuf_2
Xhold500 b_in[2] VGND VGND VPWR VPWR hold500/X sky130_fd_sc_hd__clkbuf_2
X_1906_ _1811_/A _1811_/B _1861_/B _1860_/B _1860_/A VGND VGND VPWR VPWR _1940_/A
+ sky130_fd_sc_hd__a32o_2
X_1837_ _1837_/A _1837_/B VGND VGND VPWR VPWR _1840_/A sky130_fd_sc_hd__xor2_2
X_1768_ _1768_/A _1976_/D _1768_/C VGND VGND VPWR VPWR _1831_/A sky130_fd_sc_hd__nand3_2
XFILLER_57_201 VGND VGND VPWR VPWR sky130_fd_sc_hd__decap_3
XFILLER_57_234 VGND VGND VPWR VPWR sky130_fd_sc_hd__decap_3
Xhold555 hold555/A VGND VGND VPWR VPWR hold555/X sky130_fd_sc_hd__clkbuf_2
Xhold566 b_in[11] VGND VGND VPWR VPWR hold566/X sky130_fd_sc_hd__clkbuf_2
Xhold577 hold577/A VGND VGND VPWR VPWR hold577/X sky130_fd_sc_hd__clkbuf_2
Xhold588 hold588/A VGND VGND VPWR VPWR hold588/X sky130_fd_sc_hd__clkbuf_2
Xhold599 hold604/X VGND VGND VPWR VPWR hold605/A sky130_fd_sc_hd__clkbuf_2
X_1699_ _1699_/A _1699_/B VGND VGND VPWR VPWR _1721_/A sky130_fd_sc_hd__xnor2_2
XFILLER_40_101 VGND VGND VPWR VPWR sky130_fd_sc_hd__fill_1
XFILLER_40_189 VGND VGND VPWR VPWR sky130_fd_sc_hd__fill_2
XFILLER_0_274 VGND VGND VPWR VPWR sky130_fd_sc_hd__decap_3
XFILLER_48_278 VGND VGND VPWR VPWR sky130_fd_sc_hd__decap_3
XFILLER_56_50 VGND VGND VPWR VPWR sky130_fd_sc_hd__decap_3
XFILLER_63_237 VGND VGND VPWR VPWR sky130_fd_sc_hd__decap_3
Xplace204 _1538_/X VGND VGND VPWR VPWR _2009_/B1 sky130_fd_sc_hd__buf_1
Xplace259 _2124_/A VGND VGND VPWR VPWR _1976_/D sky130_fd_sc_hd__buf_1
Xplace248 _1484_/A VGND VGND VPWR VPWR _1829_/A sky130_fd_sc_hd__clkbuf_1
Xplace237 _2614_/A VGND VGND VPWR VPWR _1570_/A sky130_fd_sc_hd__clkbuf_1
Xplace226 _2197_/B VGND VGND VPWR VPWR _2020_/A sky130_fd_sc_hd__clkbuf_1
Xplace215 _1792_/X VGND VGND VPWR VPWR _2286_/B sky130_fd_sc_hd__buf_1
X_1622_ _1622_/A _1622_/B VGND VGND VPWR VPWR _1622_/Y sky130_fd_sc_hd__xnor2_2
X_2671_ _2689_/CLK _2671_/D VGND VGND VPWR VPWR _2671_/Q sky130_fd_sc_hd__dfxtp_2
XFILLER_39_223 VGND VGND VPWR VPWR sky130_fd_sc_hd__fill_1
X_1484_ _1484_/A _1484_/B VGND VGND VPWR VPWR _1610_/B sky130_fd_sc_hd__xor2_2
X_1553_ _1854_/B2 _1474_/B _2009_/B1 _1807_/B2 VGND VGND VPWR VPWR _1554_/B sky130_fd_sc_hd__a22o_2
XFILLER_54_248 VGND VGND VPWR VPWR sky130_fd_sc_hd__decap_3
X_2105_ _2054_/A _2054_/B _2062_/B _2061_/B _2061_/A VGND VGND VPWR VPWR _2106_/B
+ sky130_fd_sc_hd__a32o_2
X_2036_ _1998_/Y _1993_/Y _2070_/B VGND VGND VPWR VPWR _2036_/Y sky130_fd_sc_hd__a21oi_2
XFILLER_10_318 VGND VGND VPWR VPWR sky130_fd_sc_hd__fill_2
XFILLER_22_178 VGND VGND VPWR VPWR sky130_fd_sc_hd__decap_3
XFILLER_62_292 VGND VGND VPWR VPWR sky130_fd_sc_hd__fill_1
XFILLER_13_156 VGND VGND VPWR VPWR sky130_fd_sc_hd__decap_3
XFILLER_3_57 VGND VGND VPWR VPWR sky130_fd_sc_hd__fill_2
XFILLER_3_68 VGND VGND VPWR VPWR sky130_fd_sc_hd__fill_1
XTAP_TAPCELL_ROW_8_182 VGND VPWR sky130_fd_sc_hd__tapvpwrvgnd_1
X_1605_ _1608_/A _1608_/B VGND VGND VPWR VPWR _1637_/A sky130_fd_sc_hd__xor2_2
X_2654_ clkload5/A _2654_/D VGND VGND VPWR VPWR _2654_/Q sky130_fd_sc_hd__dfxtp_2
X_2585_ _2587_/A _2644_/Q VGND VGND VPWR VPWR _2585_/X sky130_fd_sc_hd__or2_2
X_1467_ _2667_/Q _2666_/Q VGND VGND VPWR VPWR _1469_/A sky130_fd_sc_hd__and2_2
XFILLER_50_251 VGND VGND VPWR VPWR sky130_fd_sc_hd__fill_1
XPHY_EDGE_ROW_19_Left_84 VGND VGND VPWR VPWR sky130_fd_sc_hd__decap_3
X_2019_ _2633_/Q _2019_/A2 _2019_/A3 _1416_/X _2265_/B2 VGND VGND VPWR VPWR _2020_/B
+ sky130_fd_sc_hd__a32o_2
XFILLER_50_273 VGND VGND VPWR VPWR sky130_fd_sc_hd__fill_1
XFILLER_2_303 VGND VGND VPWR VPWR sky130_fd_sc_hd__decap_3
XFILLER_37_41 VGND VGND VPWR VPWR sky130_fd_sc_hd__decap_3
XTAP_TAPCELL_ROW_5_163 VGND VPWR sky130_fd_sc_hd__tapvpwrvgnd_1
XFILLER_41_295 VGND VGND VPWR VPWR sky130_fd_sc_hd__decap_3
XFILLER_45_6 VGND VGND VPWR VPWR sky130_fd_sc_hd__decap_3
XTAP_TAPCELL_ROW_11_198 VGND VPWR sky130_fd_sc_hd__tapvpwrvgnd_1
X_1321_ _2695_/Q _1321_/B VGND VGND VPWR VPWR _1321_/X sky130_fd_sc_hd__xor2_2
X_2370_ _2694_/Q _2370_/B VGND VGND VPWR VPWR _2486_/A sky130_fd_sc_hd__xor2_2
XFILLER_17_281 VGND VGND VPWR VPWR sky130_fd_sc_hd__decap_3
XTAP_TAPCELL_ROW_19_243 VGND VPWR sky130_fd_sc_hd__tapvpwrvgnd_1
X_2706_ _2706_/A VGND VGND VPWR VPWR _2706_/X sky130_fd_sc_hd__buf_2
XFILLER_58_29 VGND VGND VPWR VPWR sky130_fd_sc_hd__fill_2
XPHY_EDGE_ROW_12_Right_12 VGND VGND VPWR VPWR sky130_fd_sc_hd__decap_3
X_1519_ _1519_/A _1519_/B VGND VGND VPWR VPWR _1520_/B sky130_fd_sc_hd__xor2_2
X_2637_ clkload4/A _2637_/D VGND VGND VPWR VPWR _2706_/A sky130_fd_sc_hd__dfxtp_2
X_2568_ _2568_/A _2568_/B _2568_/C _2568_/D VGND VGND VPWR VPWR _2568_/X sky130_fd_sc_hd__or4_2
XFILLER_15_207 VGND VGND VPWR VPWR sky130_fd_sc_hd__fill_2
XPHY_EDGE_ROW_21_Right_21 VGND VGND VPWR VPWR sky130_fd_sc_hd__decap_3
XPHY_EDGE_ROW_4_Left_69 VGND VGND VPWR VPWR sky130_fd_sc_hd__decap_3
XFILLER_23_76 VGND VGND VPWR VPWR sky130_fd_sc_hd__fill_1
XPHY_EDGE_ROW_30_Right_30 VGND VGND VPWR VPWR sky130_fd_sc_hd__decap_3
XFILLER_61_302 VGND VGND VPWR VPWR sky130_fd_sc_hd__decap_3
XFILLER_64_50 VGND VGND VPWR VPWR sky130_fd_sc_hd__decap_3
XFILLER_64_94 VGND VGND VPWR VPWR sky130_fd_sc_hd__decap_3
XTAP_TAPCELL_ROW_16_224 VGND VPWR sky130_fd_sc_hd__tapvpwrvgnd_1
XFILLER_14_295 VGND VGND VPWR VPWR sky130_fd_sc_hd__decap_3
X_1870_ _2023_/A _1870_/B VGND VGND VPWR VPWR _1871_/B sky130_fd_sc_hd__xnor2_2
X_2422_ _2422_/A _2422_/B VGND VGND VPWR VPWR _2491_/B sky130_fd_sc_hd__nand2_2
X_2353_ _2699_/Q _2406_/B VGND VGND VPWR VPWR _2512_/B sky130_fd_sc_hd__nand2_2
XFILLER_56_107 VGND VGND VPWR VPWR sky130_fd_sc_hd__decap_3
X_2284_ _2284_/A _2284_/B _2284_/C VGND VGND VPWR VPWR _2286_/A sky130_fd_sc_hd__and3_2
XFILLER_64_162 VGND VGND VPWR VPWR sky130_fd_sc_hd__decap_3
XFILLER_20_265 VGND VGND VPWR VPWR sky130_fd_sc_hd__decap_3
X_1999_ _1999_/A _1991_/A VGND VGND VPWR VPWR _2035_/A sky130_fd_sc_hd__nor2b_2
XFILLER_18_43 VGND VGND VPWR VPWR sky130_fd_sc_hd__fill_1
XFILLER_43_313 VGND VGND VPWR VPWR sky130_fd_sc_hd__decap_3
XFILLER_47_129 VGND VGND VPWR VPWR sky130_fd_sc_hd__decap_3
XFILLER_11_221 VGND VGND VPWR VPWR sky130_fd_sc_hd__decap_3
XFILLER_11_254 VGND VGND VPWR VPWR sky130_fd_sc_hd__fill_2
XFILLER_34_64 VGND VGND VPWR VPWR sky130_fd_sc_hd__decap_3
XFILLER_7_225 VGND VGND VPWR VPWR sky130_fd_sc_hd__decap_3
XFILLER_50_85 VGND VGND VPWR VPWR sky130_fd_sc_hd__fill_1
XFILLER_38_129 VGND VGND VPWR VPWR sky130_fd_sc_hd__fill_1
Xclkbuf_4_11_0_clk clkbuf_0_clk/X VGND VGND VPWR VPWR clkload9/A sky130_fd_sc_hd__clkbuf_8
XFILLER_46_195 VGND VGND VPWR VPWR sky130_fd_sc_hd__fill_1
XFILLER_61_165 VGND VGND VPWR VPWR sky130_fd_sc_hd__decap_3
XFILLER_61_176 VGND VGND VPWR VPWR sky130_fd_sc_hd__fill_1
XFILLER_61_198 VGND VGND VPWR VPWR sky130_fd_sc_hd__decap_3
X_1922_ _2023_/A _1922_/B VGND VGND VPWR VPWR _1923_/B sky130_fd_sc_hd__xnor2_2
X_1853_ _1824_/A _1824_/B _1821_/A VGND VGND VPWR VPWR _1860_/A sky130_fd_sc_hd__a21o_2
X_1784_ _1784_/A _1784_/B VGND VGND VPWR VPWR _1801_/B sky130_fd_sc_hd__xor2_2
X_2405_ _2420_/A _2438_/A _2421_/A VGND VGND VPWR VPWR _2418_/B sky130_fd_sc_hd__o21ba_2
X_2336_ _2676_/Q _2371_/B VGND VGND VPWR VPWR _2372_/B sky130_fd_sc_hd__or2_2
XFILLER_52_132 VGND VGND VPWR VPWR sky130_fd_sc_hd__decap_3
XTAP_TAPCELL_ROW_35_330 VGND VPWR sky130_fd_sc_hd__tapvpwrvgnd_1
X_2267_ _2313_/A _1537_/X _2266_/X _2668_/Q VGND VGND VPWR VPWR _2292_/B sky130_fd_sc_hd__a22o_2
X_2198_ _2313_/A _2274_/A VGND VGND VPWR VPWR _2198_/X sky130_fd_sc_hd__and2_2
XFILLER_40_305 VGND VGND VPWR VPWR sky130_fd_sc_hd__decap_3
XFILLER_52_176 VGND VGND VPWR VPWR sky130_fd_sc_hd__decap_3
XFILLER_20_55 VGND VGND VPWR VPWR sky130_fd_sc_hd__fill_1
XFILLER_4_206 VGND VGND VPWR VPWR sky130_fd_sc_hd__decap_3
XFILLER_29_97 VGND VGND VPWR VPWR sky130_fd_sc_hd__decap_3
XTAP_TAPCELL_ROW_58_455 VGND VPWR sky130_fd_sc_hd__tapvpwrvgnd_1
Xinput313 hold637/X VGND VGND VPWR VPWR hold638/A sky130_fd_sc_hd__buf_2
Xinput324 hold661/X VGND VGND VPWR VPWR hold662/A sky130_fd_sc_hd__buf_2
Xinput335 hold571/X VGND VGND VPWR VPWR hold572/A sky130_fd_sc_hd__buf_2
XFILLER_28_162 VGND VGND VPWR VPWR sky130_fd_sc_hd__fill_1
XFILLER_43_143 VGND VGND VPWR VPWR sky130_fd_sc_hd__decap_3
XFILLER_45_30 VGND VGND VPWR VPWR sky130_fd_sc_hd__decap_3
XANTENNA_6 b_in[14] VGND VGND VPWR VPWR sky130_fd_sc_hd__diode_2
XFILLER_61_40 VGND VGND VPWR VPWR sky130_fd_sc_hd__fill_1
XPHY_EDGE_ROW_7_Left_72 VGND VGND VPWR VPWR sky130_fd_sc_hd__decap_3
X_2121_ _2081_/Y _2120_/X _2326_/A VGND VGND VPWR VPWR _2678_/D sky130_fd_sc_hd__a21oi_2
X_2052_ _2015_/Y _2025_/B _2016_/A VGND VGND VPWR VPWR _2102_/B sky130_fd_sc_hd__a21oi_2
XFILLER_34_176 VGND VGND VPWR VPWR sky130_fd_sc_hd__decap_3
XTAP_TAPCELL_ROW_32_311 VGND VPWR sky130_fd_sc_hd__tapvpwrvgnd_1
X_1905_ _1893_/A _1893_/B _1904_/X VGND VGND VPWR VPWR _1941_/A sky130_fd_sc_hd__a21oi_2
XPHY_EDGE_ROW_6_Right_6 VGND VGND VPWR VPWR sky130_fd_sc_hd__decap_3
Xhold512 hold512/A VGND VGND VPWR VPWR hold512/X sky130_fd_sc_hd__clkbuf_2
Xhold523 _2570_/X VGND VGND VPWR VPWR hold523/X sky130_fd_sc_hd__clkbuf_2
Xhold534 _1365_/X VGND VGND VPWR VPWR hold534/X sky130_fd_sc_hd__clkbuf_2
Xhold545 hold545/A VGND VGND VPWR VPWR hold545/X sky130_fd_sc_hd__clkbuf_2
Xhold556 hold556/A VGND VGND VPWR VPWR hold556/X sky130_fd_sc_hd__clkbuf_2
Xhold567 hold567/A VGND VGND VPWR VPWR hold567/X sky130_fd_sc_hd__clkbuf_2
Xhold578 _2606_/D VGND VGND VPWR VPWR _1349_/A sky130_fd_sc_hd__clkbuf_2
Xhold501 hold501/A VGND VGND VPWR VPWR hold501/X sky130_fd_sc_hd__clkbuf_2
X_1836_ _1890_/A _1890_/B VGND VGND VPWR VPWR _1837_/B sky130_fd_sc_hd__xnor2_2
X_1767_ _1767_/A _1767_/B VGND VGND VPWR VPWR _1780_/A sky130_fd_sc_hd__nor2_2
X_1698_ _1706_/A _1698_/B VGND VGND VPWR VPWR _1699_/B sky130_fd_sc_hd__xnor2_2
XFILLER_57_213 VGND VGND VPWR VPWR sky130_fd_sc_hd__decap_3
Xhold589 _2603_/B VGND VGND VPWR VPWR _1355_/A sky130_fd_sc_hd__clkbuf_2
X_2319_ _2304_/Y _2309_/X _2317_/Y _2318_/Y hold601/X VGND VGND VPWR VPWR _2319_/X
+ sky130_fd_sc_hd__o311a_2
XFILLER_15_55 VGND VGND VPWR VPWR sky130_fd_sc_hd__fill_1
XFILLER_31_76 VGND VGND VPWR VPWR sky130_fd_sc_hd__decap_3
XFILLER_0_231 VGND VGND VPWR VPWR sky130_fd_sc_hd__decap_3
XFILLER_0_253 VGND VGND VPWR VPWR sky130_fd_sc_hd__decap_3
XPHY_EDGE_ROW_33_Left_98 VGND VGND VPWR VPWR sky130_fd_sc_hd__decap_3
XFILLER_0_297 VGND VGND VPWR VPWR sky130_fd_sc_hd__decap_3
XFILLER_56_62 VGND VGND VPWR VPWR sky130_fd_sc_hd__decap_3
XFILLER_63_249 VGND VGND VPWR VPWR sky130_fd_sc_hd__decap_3
Xplace205 _2096_/A2 VGND VGND VPWR VPWR _1474_/B sky130_fd_sc_hd__buf_1
Xplace227 _1411_/B VGND VGND VPWR VPWR _2017_/A3 sky130_fd_sc_hd__buf_1
Xplace216 _2010_/A VGND VGND VPWR VPWR _2059_/A sky130_fd_sc_hd__clkbuf_1
XPHY_EDGE_ROW_59_Right_59 VGND VGND VPWR VPWR sky130_fd_sc_hd__decap_3
Xplace249 _1484_/A VGND VGND VPWR VPWR _1678_/A sky130_fd_sc_hd__clkbuf_1
Xplace238 _2614_/A VGND VGND VPWR VPWR _1701_/A sky130_fd_sc_hd__clkbuf_1
X_1552_ _1529_/A _1529_/B _1551_/X VGND VGND VPWR VPWR _1747_/A sky130_fd_sc_hd__a21o_2
X_1621_ _1621_/A _1739_/B VGND VGND VPWR VPWR _1622_/B sky130_fd_sc_hd__xnor2_2
X_2670_ _2696_/CLK _2670_/D VGND VGND VPWR VPWR _2670_/Q sky130_fd_sc_hd__dfxtp_2
XFILLER_39_257 VGND VGND VPWR VPWR sky130_fd_sc_hd__decap_3
X_1483_ _1524_/A1 _1697_/B _1677_/B1 _1606_/A1 VGND VGND VPWR VPWR _1484_/B sky130_fd_sc_hd__a22o_2
X_2104_ _2146_/A _2146_/B VGND VGND VPWR VPWR _2106_/A sky130_fd_sc_hd__xnor2_2
XFILLER_39_279 VGND VGND VPWR VPWR sky130_fd_sc_hd__fill_1
XFILLER_62_271 VGND VGND VPWR VPWR sky130_fd_sc_hd__decap_3
X_2035_ _2035_/A _2035_/B VGND VGND VPWR VPWR _2070_/B sky130_fd_sc_hd__xnor2_2
XFILLER_22_168 VGND VGND VPWR VPWR sky130_fd_sc_hd__decap_3
X_1819_ _1820_/A _1820_/B VGND VGND VPWR VPWR _1821_/A sky130_fd_sc_hd__and2_2
XFILLER_45_216 VGND VGND VPWR VPWR sky130_fd_sc_hd__decap_3
XFILLER_45_249 VGND VGND VPWR VPWR sky130_fd_sc_hd__fill_1
XFILLER_42_97 VGND VGND VPWR VPWR sky130_fd_sc_hd__decap_3
XTAP_TAPCELL_ROW_8_183 VGND VPWR sky130_fd_sc_hd__tapvpwrvgnd_1
XFILLER_51_219 VGND VGND VPWR VPWR sky130_fd_sc_hd__decap_3
X_1604_ _1604_/A _1604_/B VGND VGND VPWR VPWR _1608_/B sky130_fd_sc_hd__xor2_2
X_2653_ clkload5/A _2653_/D VGND VGND VPWR VPWR _2653_/Q sky130_fd_sc_hd__dfxtp_2
X_2584_ _2588_/A1 hold659/X _2602_/B1 _2583_/X VGND VGND VPWR VPWR _2584_/X sky130_fd_sc_hd__o211a_2
X_1397_ _1601_/A _1397_/B VGND VGND VPWR VPWR _1437_/A sky130_fd_sc_hd__xnor2_2
X_1466_ _1466_/A _1507_/B VGND VGND VPWR VPWR _1477_/A sky130_fd_sc_hd__xnor2_2
X_2018_ _2018_/A _2018_/B VGND VGND VPWR VPWR _2055_/A sky130_fd_sc_hd__xor2_2
XFILLER_12_34 VGND VGND VPWR VPWR sky130_fd_sc_hd__fill_2
XFILLER_2_315 VGND VGND VPWR VPWR sky130_fd_sc_hd__decap_3
XTAP_TAPCELL_ROW_5_164 VGND VPWR sky130_fd_sc_hd__tapvpwrvgnd_1
XFILLER_18_216 VGND VGND VPWR VPWR sky130_fd_sc_hd__fill_2
XFILLER_18_238 VGND VGND VPWR VPWR sky130_fd_sc_hd__decap_3
XFILLER_37_20 VGND VGND VPWR VPWR sky130_fd_sc_hd__fill_1
XFILLER_37_31 VGND VGND VPWR VPWR sky130_fd_sc_hd__decap_3
XFILLER_41_252 VGND VGND VPWR VPWR sky130_fd_sc_hd__fill_2
XFILLER_5_197 VGND VGND VPWR VPWR sky130_fd_sc_hd__fill_1
XTAP_TAPCELL_ROW_11_199 VGND VPWR sky130_fd_sc_hd__tapvpwrvgnd_1
X_1320_ _2703_/Q _2694_/Q _1319_/B VGND VGND VPWR VPWR _1321_/B sky130_fd_sc_hd__a21o_2
XFILLER_32_274 VGND VGND VPWR VPWR sky130_fd_sc_hd__decap_3
XPHY_EDGE_ROW_20_Left_85 VGND VGND VPWR VPWR sky130_fd_sc_hd__decap_3
XTAP_TAPCELL_ROW_19_244 VGND VPWR sky130_fd_sc_hd__tapvpwrvgnd_1
X_2636_ clkload3/A _2636_/D VGND VGND VPWR VPWR _2636_/Q sky130_fd_sc_hd__dfxtp_2
X_1518_ _2631_/Q _1386_/X _1390_/X _2630_/Q VGND VGND VPWR VPWR _1519_/B sky130_fd_sc_hd__a22o_2
X_2567_ _2567_/A _2567_/B _2567_/C _2567_/D VGND VGND VPWR VPWR _2567_/X sky130_fd_sc_hd__or4_2
X_2498_ _2498_/A _2498_/B VGND VGND VPWR VPWR _2696_/D sky130_fd_sc_hd__and2_2
XFILLER_15_219 VGND VGND VPWR VPWR sky130_fd_sc_hd__decap_3
XFILLER_46_300 VGND VGND VPWR VPWR sky130_fd_sc_hd__fill_1
XFILLER_48_41 VGND VGND VPWR VPWR sky130_fd_sc_hd__decap_3
XFILLER_48_63 VGND VGND VPWR VPWR sky130_fd_sc_hd__decap_3
XFILLER_48_85 VGND VGND VPWR VPWR sky130_fd_sc_hd__decap_3
XFILLER_58_182 VGND VGND VPWR VPWR sky130_fd_sc_hd__fill_1
XFILLER_14_230 VGND VGND VPWR VPWR sky130_fd_sc_hd__decap_3
XFILLER_61_314 VGND VGND VPWR VPWR sky130_fd_sc_hd__decap_3
XFILLER_64_73 VGND VGND VPWR VPWR sky130_fd_sc_hd__decap_3
XTAP_TAPCELL_ROW_16_225 VGND VPWR sky130_fd_sc_hd__tapvpwrvgnd_1
XFILLER_36_3 VGND VGND VPWR VPWR sky130_fd_sc_hd__fill_1
X_2421_ _2421_/A _2421_/B VGND VGND VPWR VPWR _2439_/B sky130_fd_sc_hd__xnor2_2
X_2352_ _2682_/Q _2352_/B VGND VGND VPWR VPWR _2406_/B sky130_fd_sc_hd__xnor2_2
X_2283_ _2251_/A _2220_/A _2251_/B VGND VGND VPWR VPWR _2284_/C sky130_fd_sc_hd__a21o_2
XFILLER_56_119 VGND VGND VPWR VPWR sky130_fd_sc_hd__decap_3
XFILLER_64_141 VGND VGND VPWR VPWR sky130_fd_sc_hd__decap_3
XTAP_TAPCELL_ROW_47_394 VGND VPWR sky130_fd_sc_hd__tapvpwrvgnd_1
X_2619_ hold514/X _2614_/B _2618_/X _2619_/C1 VGND VGND VPWR VPWR _2619_/X sky130_fd_sc_hd__o211a_2
X_1998_ _1998_/A _1998_/B VGND VGND VPWR VPWR _1998_/Y sky130_fd_sc_hd__nand2_2
XFILLER_28_300 VGND VGND VPWR VPWR sky130_fd_sc_hd__decap_3
XFILLER_34_32 VGND VGND VPWR VPWR sky130_fd_sc_hd__decap_3
XFILLER_11_200 VGND VGND VPWR VPWR sky130_fd_sc_hd__decap_3
XFILLER_50_75 VGND VGND VPWR VPWR sky130_fd_sc_hd__decap_3
XFILLER_7_237 VGND VGND VPWR VPWR sky130_fd_sc_hd__decap_3
XFILLER_7_259 VGND VGND VPWR VPWR sky130_fd_sc_hd__decap_3
XFILLER_59_73 VGND VGND VPWR VPWR sky130_fd_sc_hd__decap_3
XFILLER_34_303 VGND VGND VPWR VPWR sky130_fd_sc_hd__fill_1
XFILLER_46_141 VGND VGND VPWR VPWR sky130_fd_sc_hd__decap_3
XFILLER_46_174 VGND VGND VPWR VPWR sky130_fd_sc_hd__decap_3
XFILLER_61_144 VGND VGND VPWR VPWR sky130_fd_sc_hd__decap_3
X_1921_ _2630_/Q _1494_/B _1921_/B1 _1921_/B2 VGND VGND VPWR VPWR _1922_/B sky130_fd_sc_hd__a22o_2
X_1852_ _1754_/A _1754_/B _1814_/B _1813_/B _1813_/A VGND VGND VPWR VPWR _1893_/A
+ sky130_fd_sc_hd__a32o_2
X_1783_ _1838_/A _1838_/B VGND VGND VPWR VPWR _1784_/B sky130_fd_sc_hd__xnor2_2
XFILLER_29_119 VGND VGND VPWR VPWR sky130_fd_sc_hd__decap_3
X_2404_ _2418_/A _2404_/B VGND VGND VPWR VPWR _2421_/A sky130_fd_sc_hd__or2_2
X_2335_ _2675_/Q _2674_/Q _2673_/Q _2382_/B _2368_/A VGND VGND VPWR VPWR _2371_/B
+ sky130_fd_sc_hd__o41a_2
X_2266_ _2667_/Q _2295_/A _2313_/A VGND VGND VPWR VPWR _2266_/X sky130_fd_sc_hd__or3b_2
XFILLER_37_196 VGND VGND VPWR VPWR sky130_fd_sc_hd__decap_3
XFILLER_52_111 VGND VGND VPWR VPWR sky130_fd_sc_hd__fill_2
XFILLER_52_144 VGND VGND VPWR VPWR sky130_fd_sc_hd__fill_2
XFILLER_52_155 VGND VGND VPWR VPWR sky130_fd_sc_hd__decap_3
XTAP_TAPCELL_ROW_35_331 VGND VPWR sky130_fd_sc_hd__tapvpwrvgnd_1
X_2197_ _2295_/A _2197_/B _2197_/C VGND VGND VPWR VPWR _2240_/A sky130_fd_sc_hd__and3_2
XFILLER_52_188 VGND VGND VPWR VPWR sky130_fd_sc_hd__fill_1
XPHY_EDGE_ROW_42_Left_107 VGND VGND VPWR VPWR sky130_fd_sc_hd__decap_3
XFILLER_16_303 VGND VGND VPWR VPWR sky130_fd_sc_hd__fill_1
XFILLER_28_141 VGND VGND VPWR VPWR sky130_fd_sc_hd__fill_2
XTAP_TAPCELL_ROW_58_456 VGND VPWR sky130_fd_sc_hd__tapvpwrvgnd_1
Xinput314 hold617/X VGND VGND VPWR VPWR hold618/A sky130_fd_sc_hd__buf_2
Xinput325 hold517/X VGND VGND VPWR VPWR hold518/A sky130_fd_sc_hd__buf_2
Xinput336 hold657/X VGND VGND VPWR VPWR hold658/A sky130_fd_sc_hd__buf_2
XFILLER_43_166 VGND VGND VPWR VPWR sky130_fd_sc_hd__fill_2
XFILLER_45_42 VGND VGND VPWR VPWR sky130_fd_sc_hd__decap_3
XPHY_EDGE_ROW_51_Left_116 VGND VGND VPWR VPWR sky130_fd_sc_hd__decap_3
XANTENNA_7 b_in[12] VGND VGND VPWR VPWR sky130_fd_sc_hd__diode_2
XFILLER_61_96 VGND VGND VPWR VPWR sky130_fd_sc_hd__decap_3
XFILLER_3_262 VGND VGND VPWR VPWR sky130_fd_sc_hd__decap_3
XPHY_EDGE_ROW_60_Left_125 VGND VGND VPWR VPWR sky130_fd_sc_hd__decap_3
X_2120_ _2114_/A _2222_/B _2119_/X VGND VGND VPWR VPWR _2120_/X sky130_fd_sc_hd__a21o_2
XFILLER_19_185 VGND VGND VPWR VPWR sky130_fd_sc_hd__decap_3
XFILLER_34_155 VGND VGND VPWR VPWR sky130_fd_sc_hd__fill_1
X_2051_ _2051_/A _2051_/B VGND VGND VPWR VPWR _2102_/A sky130_fd_sc_hd__xor2_2
XFILLER_22_317 VGND VGND VPWR VPWR sky130_fd_sc_hd__decap_3
XFILLER_34_188 VGND VGND VPWR VPWR sky130_fd_sc_hd__decap_3
XTAP_TAPCELL_ROW_32_312 VGND VPWR sky130_fd_sc_hd__tapvpwrvgnd_1
X_1904_ _1892_/B _1904_/B VGND VGND VPWR VPWR _1904_/X sky130_fd_sc_hd__and2b_2
X_1835_ _1767_/A _1767_/B _1780_/B _1779_/B _1779_/A VGND VGND VPWR VPWR _1890_/B
+ sky130_fd_sc_hd__o32a_2
Xhold502 hold502/A VGND VGND VPWR VPWR hold502/X sky130_fd_sc_hd__clkbuf_2
Xhold513 hold513/A VGND VGND VPWR VPWR hold513/X sky130_fd_sc_hd__clkbuf_2
Xhold524 _2572_/X VGND VGND VPWR VPWR _2637_/D sky130_fd_sc_hd__clkbuf_2
Xhold535 _1366_/X VGND VGND VPWR VPWR _2668_/D sky130_fd_sc_hd__clkbuf_2
Xhold546 _2603_/D VGND VGND VPWR VPWR _1359_/A sky130_fd_sc_hd__clkbuf_2
Xhold557 _2604_/B VGND VGND VPWR VPWR _1363_/A sky130_fd_sc_hd__clkbuf_2
Xhold568 hold568/A VGND VGND VPWR VPWR hold568/X sky130_fd_sc_hd__clkbuf_2
Xhold579 _1351_/X VGND VGND VPWR VPWR _2661_/D sky130_fd_sc_hd__clkbuf_2
X_1766_ _1766_/A _1766_/B VGND VGND VPWR VPWR _1767_/B sky130_fd_sc_hd__nor2_2
X_1697_ _1697_/A _1697_/B VGND VGND VPWR VPWR _1698_/B sky130_fd_sc_hd__nand2_2
XFILLER_57_225 VGND VGND VPWR VPWR sky130_fd_sc_hd__decap_3
X_2318_ _2304_/Y _2309_/X _2317_/Y VGND VGND VPWR VPWR _2318_/Y sky130_fd_sc_hd__o21ai_2
X_2249_ _2249_/A _2249_/B _2249_/C VGND VGND VPWR VPWR _2250_/B sky130_fd_sc_hd__nor3_2
XFILLER_15_67 VGND VGND VPWR VPWR sky130_fd_sc_hd__fill_1
XFILLER_25_155 VGND VGND VPWR VPWR sky130_fd_sc_hd__fill_1
XFILLER_25_166 VGND VGND VPWR VPWR sky130_fd_sc_hd__fill_2
XFILLER_40_114 VGND VGND VPWR VPWR sky130_fd_sc_hd__fill_2
XFILLER_40_125 VGND VGND VPWR VPWR sky130_fd_sc_hd__fill_2
XFILLER_31_55 VGND VGND VPWR VPWR sky130_fd_sc_hd__fill_1
XFILLER_31_88 VGND VGND VPWR VPWR sky130_fd_sc_hd__decap_3
Xclkbuf_4_10_0_clk clkbuf_0_clk/X VGND VGND VPWR VPWR clkload8/A sky130_fd_sc_hd__clkbuf_8
XFILLER_0_265 VGND VGND VPWR VPWR sky130_fd_sc_hd__decap_3
XFILLER_16_144 VGND VGND VPWR VPWR sky130_fd_sc_hd__decap_3
XFILLER_16_166 VGND VGND VPWR VPWR sky130_fd_sc_hd__fill_2
XFILLER_48_247 VGND VGND VPWR VPWR sky130_fd_sc_hd__decap_3
XFILLER_56_41 VGND VGND VPWR VPWR sky130_fd_sc_hd__decap_3
XFILLER_63_228 VGND VGND VPWR VPWR sky130_fd_sc_hd__decap_3
Xplace206 _1469_/Y VGND VGND VPWR VPWR _2096_/A2 sky130_fd_sc_hd__buf_1
Xplace239 _1370_/Y VGND VGND VPWR VPWR _1948_/A sky130_fd_sc_hd__buf_1
Xplace228 _1411_/A VGND VGND VPWR VPWR _2017_/A2 sky130_fd_sc_hd__buf_1
Xplace217 _2010_/A VGND VGND VPWR VPWR _1962_/A sky130_fd_sc_hd__clkbuf_1
XFILLER_31_169 VGND VGND VPWR VPWR sky130_fd_sc_hd__fill_1
X_1482_ _1485_/A _1485_/B VGND VGND VPWR VPWR _1610_/A sky130_fd_sc_hd__xor2_2
X_1551_ _1551_/A _1551_/B VGND VGND VPWR VPWR _1551_/X sky130_fd_sc_hd__and2_2
X_1620_ _1620_/A _1620_/B VGND VGND VPWR VPWR _1739_/B sky130_fd_sc_hd__xnor2_2
XFILLER_39_269 VGND VGND VPWR VPWR sky130_fd_sc_hd__fill_1
X_2103_ _2063_/A _2063_/B _2102_/Y VGND VGND VPWR VPWR _2146_/B sky130_fd_sc_hd__o21ba_2
XFILLER_22_136 VGND VGND VPWR VPWR sky130_fd_sc_hd__decap_3
XFILLER_22_158 VGND VGND VPWR VPWR sky130_fd_sc_hd__fill_1
XFILLER_62_250 VGND VGND VPWR VPWR sky130_fd_sc_hd__fill_2
X_2034_ _2040_/A _2040_/B VGND VGND VPWR VPWR _2035_/B sky130_fd_sc_hd__xor2_2
XFILLER_10_309 VGND VGND VPWR VPWR sky130_fd_sc_hd__fill_1
X_1818_ _1919_/A _1818_/B VGND VGND VPWR VPWR _1820_/B sky130_fd_sc_hd__xnor2_2
X_1749_ _1807_/B2 _1555_/B _2095_/B1 _1555_/A VGND VGND VPWR VPWR _1754_/A sky130_fd_sc_hd__a22o_2
XFILLER_45_228 VGND VGND VPWR VPWR sky130_fd_sc_hd__decap_3
XFILLER_42_21 VGND VGND VPWR VPWR sky130_fd_sc_hd__decap_3
XTAP_TAPCELL_ROW_8_184 VGND VPWR sky130_fd_sc_hd__tapvpwrvgnd_1
XFILLER_44_283 VGND VGND VPWR VPWR sky130_fd_sc_hd__decap_3
XFILLER_8_195 VGND VGND VPWR VPWR sky130_fd_sc_hd__fill_1
X_2652_ clkload5/A _2652_/D VGND VGND VPWR VPWR _2652_/Q sky130_fd_sc_hd__dfxtp_2
X_1465_ _1465_/A _1465_/B VGND VGND VPWR VPWR _1507_/B sky130_fd_sc_hd__xor2_2
X_1534_ _2668_/Q VGND VGND VPWR VPWR _2010_/A sky130_fd_sc_hd__inv_2
X_1603_ _2627_/Q _1603_/A2 _1702_/A3 _1702_/B1 _1646_/A2 VGND VGND VPWR VPWR _1604_/B
+ sky130_fd_sc_hd__a32o_2
X_2583_ _2583_/A _2643_/Q VGND VGND VPWR VPWR _2583_/X sky130_fd_sc_hd__or2_2
XFILLER_42_209 VGND VGND VPWR VPWR sky130_fd_sc_hd__decap_3
X_1396_ _2655_/Q _1916_/A1 _2632_/Q _1768_/C VGND VGND VPWR VPWR _1397_/B sky130_fd_sc_hd__a22o_2
X_2017_ _2635_/Q _2017_/A2 _2017_/A3 _1407_/X _2124_/A VGND VGND VPWR VPWR _2018_/B
+ sky130_fd_sc_hd__a32o_2
XFILLER_10_139 VGND VGND VPWR VPWR sky130_fd_sc_hd__fill_1
XFILLER_35_250 VGND VGND VPWR VPWR sky130_fd_sc_hd__decap_3
XFILLER_35_272 VGND VGND VPWR VPWR sky130_fd_sc_hd__decap_3
XFILLER_50_264 VGND VGND VPWR VPWR sky130_fd_sc_hd__decap_3
XFILLER_18_206 VGND VGND VPWR VPWR sky130_fd_sc_hd__decap_3
XTAP_TAPCELL_ROW_5_165 VGND VPWR sky130_fd_sc_hd__tapvpwrvgnd_1
XFILLER_37_54 VGND VGND VPWR VPWR sky130_fd_sc_hd__fill_2
XFILLER_41_231 VGND VGND VPWR VPWR sky130_fd_sc_hd__decap_3
XFILLER_53_31 VGND VGND VPWR VPWR sky130_fd_sc_hd__decap_3
XFILLER_53_53 VGND VGND VPWR VPWR sky130_fd_sc_hd__decap_3
XTAP_TAPCELL_ROW_28_289 VGND VPWR sky130_fd_sc_hd__tapvpwrvgnd_1
XFILLER_17_261 VGND VGND VPWR VPWR sky130_fd_sc_hd__decap_3
XFILLER_17_272 VGND VGND VPWR VPWR sky130_fd_sc_hd__decap_3
XFILLER_32_242 VGND VGND VPWR VPWR sky130_fd_sc_hd__decap_3
XFILLER_32_253 VGND VGND VPWR VPWR sky130_fd_sc_hd__decap_3
XFILLER_32_286 VGND VGND VPWR VPWR sky130_fd_sc_hd__decap_3
X_2635_ clkload3/A _2635_/D VGND VGND VPWR VPWR _2635_/Q sky130_fd_sc_hd__dfxtp_2
X_1517_ _1577_/A _1577_/B VGND VGND VPWR VPWR _1520_/A sky130_fd_sc_hd__xor2_2
X_2566_ _2566_/A _2566_/B _2566_/C _2566_/D VGND VGND VPWR VPWR _2567_/D sky130_fd_sc_hd__or4_2
X_2497_ _2696_/Q _2524_/A2 _2524_/B1 _2496_/X VGND VGND VPWR VPWR _2498_/B sky130_fd_sc_hd__a22o_2
XTAP_TAPCELL_ROW_2_146 VGND VPWR sky130_fd_sc_hd__tapvpwrvgnd_1
X_1379_ _2657_/Q _1768_/A _2658_/Q VGND VGND VPWR VPWR _1379_/X sky130_fd_sc_hd__a21o_4
XFILLER_48_20 VGND VGND VPWR VPWR sky130_fd_sc_hd__decap_3
XFILLER_14_220 VGND VGND VPWR VPWR sky130_fd_sc_hd__fill_1
XFILLER_14_242 VGND VGND VPWR VPWR sky130_fd_sc_hd__decap_3
XFILLER_64_41 VGND VGND VPWR VPWR sky130_fd_sc_hd__decap_3
XFILLER_64_85 VGND VGND VPWR VPWR sky130_fd_sc_hd__decap_3
XTAP_TAPCELL_ROW_16_226 VGND VPWR sky130_fd_sc_hd__tapvpwrvgnd_1
XTAP_TAPCELL_ROW_24_270 VGND VPWR sky130_fd_sc_hd__tapvpwrvgnd_1
X_2420_ _2420_/A _2438_/A VGND VGND VPWR VPWR _2421_/B sky130_fd_sc_hd__nor2_2
X_2351_ _2354_/A _2351_/B VGND VGND VPWR VPWR _2352_/B sky130_fd_sc_hd__and2_2
X_2282_ _2282_/A _2282_/B VGND VGND VPWR VPWR _2284_/B sky130_fd_sc_hd__nand2_2
XFILLER_52_315 VGND VGND VPWR VPWR sky130_fd_sc_hd__decap_3
XFILLER_64_131 VGND VGND VPWR VPWR sky130_fd_sc_hd__decap_3
XFILLER_64_153 VGND VGND VPWR VPWR sky130_fd_sc_hd__decap_3
XFILLER_64_175 VGND VGND VPWR VPWR sky130_fd_sc_hd__decap_3
XFILLER_64_197 VGND VGND VPWR VPWR sky130_fd_sc_hd__decap_3
XTAP_TAPCELL_ROW_47_395 VGND VPWR sky130_fd_sc_hd__tapvpwrvgnd_1
XFILLER_20_245 VGND VGND VPWR VPWR sky130_fd_sc_hd__decap_3
X_2618_ _2618_/A _2618_/B VGND VGND VPWR VPWR _2618_/X sky130_fd_sc_hd__or2_2
X_2549_ _2575_/A _2629_/Q VGND VGND VPWR VPWR _2549_/X sky130_fd_sc_hd__or2_2
XFILLER_28_312 VGND VGND VPWR VPWR sky130_fd_sc_hd__decap_3
XFILLER_47_109 VGND VGND VPWR VPWR sky130_fd_sc_hd__decap_3
XFILLER_55_131 VGND VGND VPWR VPWR sky130_fd_sc_hd__decap_3
XFILLER_55_153 VGND VGND VPWR VPWR sky130_fd_sc_hd__fill_1
XTAP_TAPCELL_ROW_13_207 VGND VPWR sky130_fd_sc_hd__tapvpwrvgnd_1
XFILLER_11_245 VGND VGND VPWR VPWR sky130_fd_sc_hd__decap_3
XFILLER_34_99 VGND VGND VPWR VPWR sky130_fd_sc_hd__fill_2
XTAP_TAPCELL_ROW_21_251 VGND VPWR sky130_fd_sc_hd__tapvpwrvgnd_1
XFILLER_19_301 VGND VGND VPWR VPWR sky130_fd_sc_hd__fill_1
XFILLER_46_131 VGND VGND VPWR VPWR sky130_fd_sc_hd__decap_3
XFILLER_46_197 VGND VGND VPWR VPWR sky130_fd_sc_hd__decap_3
XFILLER_61_156 VGND VGND VPWR VPWR sky130_fd_sc_hd__fill_1
X_1920_ _1958_/A _1958_/B VGND VGND VPWR VPWR _1923_/A sky130_fd_sc_hd__xor2_2
X_1851_ _1841_/A _1851_/B VGND VGND VPWR VPWR _1895_/B sky130_fd_sc_hd__nand2b_2
X_2403_ _2698_/Q _2403_/B VGND VGND VPWR VPWR _2404_/B sky130_fd_sc_hd__nor2_2
X_1782_ _1580_/A _1580_/B _1781_/X VGND VGND VPWR VPWR _1838_/B sky130_fd_sc_hd__a21oi_2
XFILLER_29_109 VGND VGND VPWR VPWR sky130_fd_sc_hd__decap_3
X_2334_ _2672_/Q _2671_/Q _2686_/Q VGND VGND VPWR VPWR _2382_/B sky130_fd_sc_hd__o21ba_2
X_2265_ _2561_/B _2290_/A2 _2313_/B _2265_/B2 VGND VGND VPWR VPWR _2292_/A sky130_fd_sc_hd__a22o_2
X_2196_ _2665_/Q _2196_/B _2313_/A VGND VGND VPWR VPWR _2197_/C sky130_fd_sc_hd__or3b_2
XFILLER_25_304 VGND VGND VPWR VPWR sky130_fd_sc_hd__decap_3
XFILLER_40_318 VGND VGND VPWR VPWR sky130_fd_sc_hd__fill_2
XFILLER_52_167 VGND VGND VPWR VPWR sky130_fd_sc_hd__decap_3
XTAP_TAPCELL_ROW_35_332 VGND VPWR sky130_fd_sc_hd__tapvpwrvgnd_1
Xinput315 hold673/X VGND VGND VPWR VPWR hold674/A sky130_fd_sc_hd__buf_2
Xinput326 hold544/X VGND VGND VPWR VPWR hold545/A sky130_fd_sc_hd__buf_2
XFILLER_28_197 VGND VGND VPWR VPWR sky130_fd_sc_hd__decap_3
XFILLER_29_55 VGND VGND VPWR VPWR sky130_fd_sc_hd__fill_1
XFILLER_43_134 VGND VGND VPWR VPWR sky130_fd_sc_hd__decap_3
XFILLER_45_21 VGND VGND VPWR VPWR sky130_fd_sc_hd__decap_3
XTAP_TAPCELL_ROW_58_457 VGND VPWR sky130_fd_sc_hd__tapvpwrvgnd_1
Xinput337 hold576/X VGND VGND VPWR VPWR hold577/A sky130_fd_sc_hd__buf_2
XFILLER_43_189 VGND VGND VPWR VPWR sky130_fd_sc_hd__fill_2
XFILLER_61_53 VGND VGND VPWR VPWR sky130_fd_sc_hd__decap_3
XANTENNA_8 load_weight VGND VGND VPWR VPWR sky130_fd_sc_hd__diode_2
XFILLER_6_48 VGND VGND VPWR VPWR sky130_fd_sc_hd__fill_1
XFILLER_3_274 VGND VGND VPWR VPWR sky130_fd_sc_hd__decap_3
X_2050_ _2274_/A _2050_/B VGND VGND VPWR VPWR _2051_/B sky130_fd_sc_hd__xnor2_2
XFILLER_19_142 VGND VGND VPWR VPWR sky130_fd_sc_hd__decap_3
XFILLER_19_197 VGND VGND VPWR VPWR sky130_fd_sc_hd__decap_3
XFILLER_22_307 VGND VGND VPWR VPWR sky130_fd_sc_hd__fill_1
XFILLER_34_167 VGND VGND VPWR VPWR sky130_fd_sc_hd__decap_3
XTAP_TAPCELL_ROW_32_313 VGND VPWR sky130_fd_sc_hd__tapvpwrvgnd_1
X_1903_ _2230_/A _1903_/B VGND VGND VPWR VPWR _2673_/D sky130_fd_sc_hd__nor2_2
X_1834_ _1834_/A _1834_/B VGND VGND VPWR VPWR _1890_/A sky130_fd_sc_hd__xnor2_2
X_1765_ _1766_/A _1766_/B VGND VGND VPWR VPWR _1767_/A sky130_fd_sc_hd__and2_2
Xhold503 _2605_/D VGND VGND VPWR VPWR hold503/X sky130_fd_sc_hd__clkbuf_2
Xhold514 _2605_/C VGND VGND VPWR VPWR hold514/X sky130_fd_sc_hd__clkbuf_2
Xhold525 hold536/X VGND VGND VPWR VPWR hold537/A sky130_fd_sc_hd__clkbuf_2
Xhold536 b_in[15] VGND VGND VPWR VPWR hold536/X sky130_fd_sc_hd__clkbuf_2
Xhold547 _1359_/X VGND VGND VPWR VPWR hold547/X sky130_fd_sc_hd__clkbuf_2
Xhold558 b_in[14] VGND VGND VPWR VPWR hold558/X sky130_fd_sc_hd__clkbuf_2
Xhold569 _2603_/C VGND VGND VPWR VPWR _1361_/A sky130_fd_sc_hd__clkbuf_2
X_1696_ _1718_/A _1718_/B VGND VGND VPWR VPWR _1699_/A sky130_fd_sc_hd__xor2_2
XFILLER_57_204 VGND VGND VPWR VPWR sky130_fd_sc_hd__decap_3
XFILLER_57_237 VGND VGND VPWR VPWR sky130_fd_sc_hd__decap_3
XTAP_TAPCELL_ROW_55_438 VGND VPWR sky130_fd_sc_hd__tapvpwrvgnd_1
X_2317_ _2317_/A _2317_/B VGND VGND VPWR VPWR _2317_/Y sky130_fd_sc_hd__xnor2_2
X_2248_ _2249_/A _2249_/B _2249_/C VGND VGND VPWR VPWR _2289_/A sky130_fd_sc_hd__o21a_2
X_2179_ _2193_/B _2179_/B VGND VGND VPWR VPWR _2181_/A sky130_fd_sc_hd__xor2_2
XFILLER_13_318 VGND VGND VPWR VPWR sky130_fd_sc_hd__fill_2
XFILLER_15_57 VGND VGND VPWR VPWR sky130_fd_sc_hd__fill_2
XTAP_TAPCELL_ROW_63_482 VGND VPWR sky130_fd_sc_hd__tapvpwrvgnd_1
XFILLER_31_34 VGND VGND VPWR VPWR sky130_fd_sc_hd__fill_1
XFILLER_0_222 VGND VGND VPWR VPWR sky130_fd_sc_hd__fill_2
XFILLER_0_277 VGND VGND VPWR VPWR sky130_fd_sc_hd__decap_3
XFILLER_0_288 VGND VGND VPWR VPWR sky130_fd_sc_hd__decap_3
XFILLER_48_204 VGND VGND VPWR VPWR sky130_fd_sc_hd__decap_3
XFILLER_48_259 VGND VGND VPWR VPWR sky130_fd_sc_hd__decap_3
XFILLER_56_53 VGND VGND VPWR VPWR sky130_fd_sc_hd__decap_3
Xplace207 _1430_/Y VGND VGND VPWR VPWR _1921_/B1 sky130_fd_sc_hd__buf_1
Xplace229 _1670_/B VGND VGND VPWR VPWR _1916_/B1 sky130_fd_sc_hd__buf_1
Xplace218 _2086_/A2 VGND VGND VPWR VPWR _1494_/B sky130_fd_sc_hd__buf_1
XFILLER_31_126 VGND VGND VPWR VPWR sky130_fd_sc_hd__decap_3
X_1481_ _1604_/A _1481_/B VGND VGND VPWR VPWR _1485_/B sky130_fd_sc_hd__xor2_2
X_1550_ _2668_/Q _1532_/B _1543_/B _1549_/X VGND VGND VPWR VPWR _1588_/A sky130_fd_sc_hd__a31o_2
XFILLER_11_3 VGND VGND VPWR VPWR sky130_fd_sc_hd__fill_2
XFILLER_47_270 VGND VGND VPWR VPWR sky130_fd_sc_hd__fill_2
X_2102_ _2102_/A _2102_/B VGND VGND VPWR VPWR _2102_/Y sky130_fd_sc_hd__nor2_2
X_2033_ _2033_/A _2033_/B VGND VGND VPWR VPWR _2040_/B sky130_fd_sc_hd__xor2_2
XFILLER_62_262 VGND VGND VPWR VPWR sky130_fd_sc_hd__decap_3
X_1817_ _1921_/B2 _2019_/A2 _2019_/A3 _1416_/X _2630_/Q VGND VGND VPWR VPWR _1818_/B
+ sky130_fd_sc_hd__a32o_2
X_1748_ _1568_/A _1568_/B _1565_/A VGND VGND VPWR VPWR _1756_/A sky130_fd_sc_hd__a21o_2
X_1679_ _1679_/A _1679_/B VGND VGND VPWR VPWR _1679_/X sky130_fd_sc_hd__and2_2
XFILLER_53_240 VGND VGND VPWR VPWR sky130_fd_sc_hd__decap_3
XFILLER_29_281 VGND VGND VPWR VPWR sky130_fd_sc_hd__decap_3
XFILLER_44_251 VGND VGND VPWR VPWR sky130_fd_sc_hd__fill_1
X_2651_ clkload3/A _2651_/D VGND VGND VPWR VPWR _2651_/Q sky130_fd_sc_hd__dfxtp_2
X_2582_ _2588_/A1 _1340_/A _2602_/B1 _2581_/X VGND VGND VPWR VPWR _2582_/X sky130_fd_sc_hd__o211a_2
X_1395_ _1487_/A _1487_/B _1394_/X VGND VGND VPWR VPWR _1435_/A sky130_fd_sc_hd__a21oi_2
X_1464_ _1464_/A _1464_/B VGND VGND VPWR VPWR _1465_/B sky130_fd_sc_hd__xor2_2
X_1533_ _1464_/A _1464_/B _1460_/A VGND VGND VPWR VPWR _1549_/A sky130_fd_sc_hd__a21o_2
X_2016_ _2016_/A _2015_/Y VGND VGND VPWR VPWR _2025_/A sky130_fd_sc_hd__or2b_2
XFILLER_50_287 VGND VGND VPWR VPWR sky130_fd_sc_hd__decap_3
XFILLER_50_298 VGND VGND VPWR VPWR sky130_fd_sc_hd__fill_2
XFILLER_2_306 VGND VGND VPWR VPWR sky130_fd_sc_hd__fill_2
XFILLER_37_44 VGND VGND VPWR VPWR sky130_fd_sc_hd__fill_1
XTAP_TAPCELL_ROW_5_166 VGND VPWR sky130_fd_sc_hd__tapvpwrvgnd_1
XFILLER_41_298 VGND VGND VPWR VPWR sky130_fd_sc_hd__decap_3
XFILLER_53_98 VGND VGND VPWR VPWR sky130_fd_sc_hd__decap_3
XFILLER_45_9 VGND VGND VPWR VPWR sky130_fd_sc_hd__decap_3
XFILLER_17_284 VGND VGND VPWR VPWR sky130_fd_sc_hd__decap_3
XTAP_TAPCELL_ROW_10_190 VGND VPWR sky130_fd_sc_hd__tapvpwrvgnd_1
X_1516_ _1604_/A _1516_/B VGND VGND VPWR VPWR _1577_/B sky130_fd_sc_hd__xor2_2
X_2703_ _2703_/CLK _2703_/D VGND VGND VPWR VPWR _2703_/Q sky130_fd_sc_hd__dfxtp_2
X_2634_ clkload4/A _2634_/D VGND VGND VPWR VPWR _2634_/Q sky130_fd_sc_hd__dfxtp_2
XTAP_TAPCELL_ROW_2_147 VGND VPWR sky130_fd_sc_hd__tapvpwrvgnd_1
X_1378_ _1601_/A _1378_/B VGND VGND VPWR VPWR _1394_/A sky130_fd_sc_hd__xnor2_2
X_1447_ _1509_/A _1509_/B VGND VGND VPWR VPWR _1465_/A sky130_fd_sc_hd__xor2_2
X_2496_ _2496_/A _2523_/B VGND VGND VPWR VPWR _2496_/X sky130_fd_sc_hd__or2_2
XFILLER_48_32 VGND VGND VPWR VPWR sky130_fd_sc_hd__decap_3
XFILLER_61_305 VGND VGND VPWR VPWR sky130_fd_sc_hd__decap_3
XFILLER_64_53 VGND VGND VPWR VPWR sky130_fd_sc_hd__decap_3
XFILLER_64_97 VGND VGND VPWR VPWR sky130_fd_sc_hd__decap_3
XFILLER_9_37 VGND VGND VPWR VPWR sky130_fd_sc_hd__fill_1
XTAP_TAPCELL_ROW_16_227 VGND VPWR sky130_fd_sc_hd__tapvpwrvgnd_1
XTAP_TAPCELL_ROW_24_271 VGND VPWR sky130_fd_sc_hd__tapvpwrvgnd_1
Xfanout80 _2587_/A VGND VGND VPWR VPWR _2583_/A sky130_fd_sc_hd__buf_1
X_2350_ _2683_/Q _2350_/B VGND VGND VPWR VPWR _2409_/B sky130_fd_sc_hd__xnor2_2
X_2281_ _2289_/A _2289_/B VGND VGND VPWR VPWR _2282_/B sky130_fd_sc_hd__or2_2
XFILLER_64_165 VGND VGND VPWR VPWR sky130_fd_sc_hd__decap_3
XTAP_TAPCELL_ROW_47_396 VGND VPWR sky130_fd_sc_hd__tapvpwrvgnd_1
XFILLER_20_235 VGND VGND VPWR VPWR sky130_fd_sc_hd__fill_1
XFILLER_20_268 VGND VGND VPWR VPWR sky130_fd_sc_hd__decap_3
XFILLER_9_291 VGND VGND VPWR VPWR sky130_fd_sc_hd__decap_3
X_1996_ _2528_/A _1996_/B VGND VGND VPWR VPWR _2675_/D sky130_fd_sc_hd__and2_2
X_2617_ hold503/X _2614_/B _2616_/X _2619_/C1 VGND VGND VPWR VPWR _2617_/X sky130_fd_sc_hd__o211a_2
X_2548_ _2588_/A1 hold651/X _2550_/B1 _2547_/X VGND VGND VPWR VPWR _2548_/X sky130_fd_sc_hd__o211a_2
XFILLER_43_316 VGND VGND VPWR VPWR sky130_fd_sc_hd__decap_3
X_2479_ _2480_/A _2480_/B VGND VGND VPWR VPWR _2481_/A sky130_fd_sc_hd__nor2_2
XFILLER_34_67 VGND VGND VPWR VPWR sky130_fd_sc_hd__fill_1
XTAP_TAPCELL_ROW_13_208 VGND VPWR sky130_fd_sc_hd__tapvpwrvgnd_1
XFILLER_50_44 VGND VGND VPWR VPWR sky130_fd_sc_hd__decap_3
XFILLER_50_66 VGND VGND VPWR VPWR sky130_fd_sc_hd__decap_3
XFILLER_7_206 VGND VGND VPWR VPWR sky130_fd_sc_hd__decap_3
XFILLER_7_228 VGND VGND VPWR VPWR sky130_fd_sc_hd__decap_3
XTAP_TAPCELL_ROW_21_252 VGND VPWR sky130_fd_sc_hd__tapvpwrvgnd_1
Xclkload0 clkload0/A VGND VGND VPWR VPWR clkload0/X sky130_fd_sc_hd__clkbuf_4
XFILLER_59_42 VGND VGND VPWR VPWR sky130_fd_sc_hd__decap_3
XFILLER_61_113 VGND VGND VPWR VPWR sky130_fd_sc_hd__decap_3
XFILLER_61_124 VGND VGND VPWR VPWR sky130_fd_sc_hd__fill_1
XTAP_TAPCELL_ROW_44_377 VGND VPWR sky130_fd_sc_hd__tapvpwrvgnd_1
X_1850_ _1850_/A _1840_/A VGND VGND VPWR VPWR _1895_/A sky130_fd_sc_hd__or2b_2
X_1781_ _1579_/B _1781_/B VGND VGND VPWR VPWR _1781_/X sky130_fd_sc_hd__and2b_2
XFILLER_41_3 VGND VGND VPWR VPWR sky130_fd_sc_hd__decap_3
X_2402_ _2437_/B _2437_/C _2437_/A VGND VGND VPWR VPWR _2438_/A sky130_fd_sc_hd__a21oi_2
X_2333_ _2707_/A _2333_/B VGND VGND VPWR VPWR _2424_/B sky130_fd_sc_hd__and2_2
XFILLER_37_121 VGND VGND VPWR VPWR sky130_fd_sc_hd__decap_3
X_2264_ _2264_/A _2264_/B VGND VGND VPWR VPWR _2272_/A sky130_fd_sc_hd__and2_2
X_2195_ _2195_/A _2195_/B VGND VGND VPWR VPWR _2210_/A sky130_fd_sc_hd__nor2_2
XFILLER_1_93 VGND VGND VPWR VPWR sky130_fd_sc_hd__fill_1
XFILLER_52_135 VGND VGND VPWR VPWR sky130_fd_sc_hd__decap_3
XFILLER_52_179 VGND VGND VPWR VPWR sky130_fd_sc_hd__decap_3
XFILLER_4_209 VGND VGND VPWR VPWR sky130_fd_sc_hd__fill_2
X_1979_ _1979_/A _1979_/B VGND VGND VPWR VPWR _1980_/B sky130_fd_sc_hd__or2_2
Xinput316 hold621/X VGND VGND VPWR VPWR hold622/A sky130_fd_sc_hd__buf_2
Xinput327 hold567/X VGND VGND VPWR VPWR hold568/A sky130_fd_sc_hd__buf_2
Xinput338 hold581/X VGND VGND VPWR VPWR hold582/A sky130_fd_sc_hd__buf_2
XFILLER_43_113 VGND VGND VPWR VPWR sky130_fd_sc_hd__fill_2
XFILLER_43_146 VGND VGND VPWR VPWR sky130_fd_sc_hd__decap_3
XFILLER_45_33 VGND VGND VPWR VPWR sky130_fd_sc_hd__decap_3
XTAP_TAPCELL_ROW_58_458 VGND VPWR sky130_fd_sc_hd__tapvpwrvgnd_1
XFILLER_61_76 VGND VGND VPWR VPWR sky130_fd_sc_hd__fill_1
XANTENNA_9 _2648_/D VGND VGND VPWR VPWR sky130_fd_sc_hd__diode_2
XFILLER_3_220 VGND VGND VPWR VPWR sky130_fd_sc_hd__decap_3
XFILLER_3_231 VGND VGND VPWR VPWR sky130_fd_sc_hd__decap_3
XFILLER_13_7 VGND VGND VPWR VPWR sky130_fd_sc_hd__fill_1
XFILLER_19_165 VGND VGND VPWR VPWR sky130_fd_sc_hd__decap_3
XFILLER_42_190 VGND VGND VPWR VPWR sky130_fd_sc_hd__decap_3
XTAP_TAPCELL_ROW_32_314 VGND VPWR sky130_fd_sc_hd__tapvpwrvgnd_1
X_1902_ _2591_/A _2382_/A _1946_/A _1901_/X VGND VGND VPWR VPWR _1903_/B sky130_fd_sc_hd__o22a_2
Xhold504 _2617_/X VGND VGND VPWR VPWR _2657_/D sky130_fd_sc_hd__clkbuf_2
Xhold515 _2619_/X VGND VGND VPWR VPWR _2658_/D sky130_fd_sc_hd__clkbuf_2
Xhold526 hold538/X VGND VGND VPWR VPWR hold526/X sky130_fd_sc_hd__clkbuf_2
X_1833_ _1886_/B _1833_/B VGND VGND VPWR VPWR _1834_/B sky130_fd_sc_hd__xnor2_2
X_1764_ _1764_/A _1764_/B VGND VGND VPWR VPWR _1766_/B sky130_fd_sc_hd__xnor2_2
XFILLER_57_216 VGND VGND VPWR VPWR sky130_fd_sc_hd__decap_3
Xhold537 hold537/A VGND VGND VPWR VPWR hold537/X sky130_fd_sc_hd__clkbuf_2
Xhold548 _1360_/X VGND VGND VPWR VPWR _2665_/D sky130_fd_sc_hd__clkbuf_2
Xhold559 hold559/A VGND VGND VPWR VPWR hold559/X sky130_fd_sc_hd__clkbuf_2
X_2316_ _2316_/A _2316_/B VGND VGND VPWR VPWR _2317_/B sky130_fd_sc_hd__xnor2_2
X_1695_ _1772_/A _1695_/B VGND VGND VPWR VPWR _1718_/B sky130_fd_sc_hd__xor2_2
XFILLER_25_113 VGND VGND VPWR VPWR sky130_fd_sc_hd__fill_2
XTAP_TAPCELL_ROW_55_439 VGND VPWR sky130_fd_sc_hd__tapvpwrvgnd_1
X_2247_ _2247_/A _2261_/A VGND VGND VPWR VPWR _2249_/C sky130_fd_sc_hd__xnor2_2
X_2178_ _2140_/A _2140_/B _2177_/Y VGND VGND VPWR VPWR _2179_/B sky130_fd_sc_hd__o21ba_2
XTAP_TAPCELL_ROW_63_483 VGND VPWR sky130_fd_sc_hd__tapvpwrvgnd_1
XFILLER_0_212 VGND VGND VPWR VPWR sky130_fd_sc_hd__decap_3
XFILLER_31_57 VGND VGND VPWR VPWR sky130_fd_sc_hd__decap_3
XFILLER_31_79 VGND VGND VPWR VPWR sky130_fd_sc_hd__decap_3
XFILLER_0_256 VGND VGND VPWR VPWR sky130_fd_sc_hd__decap_3
XFILLER_56_21 VGND VGND VPWR VPWR sky130_fd_sc_hd__fill_1
XFILLER_56_32 VGND VGND VPWR VPWR sky130_fd_sc_hd__decap_3
XFILLER_56_65 VGND VGND VPWR VPWR sky130_fd_sc_hd__fill_1
XFILLER_16_102 VGND VGND VPWR VPWR sky130_fd_sc_hd__fill_1
XFILLER_56_282 VGND VGND VPWR VPWR sky130_fd_sc_hd__decap_3
XFILLER_56_98 VGND VGND VPWR VPWR sky130_fd_sc_hd__decap_3
XPHY_EDGE_ROW_19_Right_19 VGND VGND VPWR VPWR sky130_fd_sc_hd__decap_3
Xplace208 _1390_/X VGND VGND VPWR VPWR _1677_/B1 sky130_fd_sc_hd__buf_1
Xplace219 _1426_/X VGND VGND VPWR VPWR _2086_/A2 sky130_fd_sc_hd__buf_1
XPHY_EDGE_ROW_28_Right_28 VGND VGND VPWR VPWR sky130_fd_sc_hd__decap_3
X_1480_ _1646_/A2 _1603_/A2 _1380_/Y _1709_/B _1628_/A2 VGND VGND VPWR VPWR _1481_/B
+ sky130_fd_sc_hd__a32o_2
XFILLER_47_260 VGND VGND VPWR VPWR sky130_fd_sc_hd__decap_3
XFILLER_62_241 VGND VGND VPWR VPWR sky130_fd_sc_hd__decap_3
XPHY_EDGE_ROW_37_Right_37 VGND VGND VPWR VPWR sky130_fd_sc_hd__decap_3
X_2101_ _2101_/A _2101_/B VGND VGND VPWR VPWR _2146_/A sky130_fd_sc_hd__xnor2_2
X_2032_ _2032_/A _2032_/B VGND VGND VPWR VPWR _2033_/B sky130_fd_sc_hd__nor2_2
XFILLER_15_190 VGND VGND VPWR VPWR sky130_fd_sc_hd__fill_1
XFILLER_62_274 VGND VGND VPWR VPWR sky130_fd_sc_hd__fill_1
XPHY_EDGE_ROW_46_Right_46 VGND VGND VPWR VPWR sky130_fd_sc_hd__decap_3
X_1816_ _1816_/A _1816_/B VGND VGND VPWR VPWR _1820_/A sky130_fd_sc_hd__xor2_2
X_1747_ _1747_/A _1804_/A _1747_/C VGND VGND VPWR VPWR _1802_/A sky130_fd_sc_hd__and3_2
X_1678_ _1678_/A _1678_/B VGND VGND VPWR VPWR _1716_/B sky130_fd_sc_hd__xor2_2
XPHY_EDGE_ROW_55_Right_55 VGND VGND VPWR VPWR sky130_fd_sc_hd__decap_3
XFILLER_13_138 VGND VGND VPWR VPWR sky130_fd_sc_hd__fill_2
XFILLER_45_219 VGND VGND VPWR VPWR sky130_fd_sc_hd__decap_3
XFILLER_53_252 VGND VGND VPWR VPWR sky130_fd_sc_hd__decap_3
XTAP_TAPCELL_ROW_51_420 VGND VPWR sky130_fd_sc_hd__tapvpwrvgnd_1
XFILLER_42_67 VGND VGND VPWR VPWR sky130_fd_sc_hd__decap_3
XFILLER_5_304 VGND VGND VPWR VPWR sky130_fd_sc_hd__decap_3
XPHY_EDGE_ROW_39_Left_104 VGND VGND VPWR VPWR sky130_fd_sc_hd__decap_3
XPHY_EDGE_ROW_64_Right_64 VGND VGND VPWR VPWR sky130_fd_sc_hd__decap_3
XFILLER_29_271 VGND VGND VPWR VPWR sky130_fd_sc_hd__fill_2
XPHY_EDGE_ROW_48_Left_113 VGND VGND VPWR VPWR sky130_fd_sc_hd__decap_3
XFILLER_12_182 VGND VGND VPWR VPWR sky130_fd_sc_hd__fill_1
XPHY_EDGE_ROW_57_Left_122 VGND VGND VPWR VPWR sky130_fd_sc_hd__decap_3
X_1532_ _2668_/Q _1532_/B VGND VGND VPWR VPWR _1543_/A sky130_fd_sc_hd__nand2_2
X_1601_ _1601_/A _1601_/B VGND VGND VPWR VPWR _1608_/A sky130_fd_sc_hd__xnor2_2
X_2650_ clkload5/A _2650_/D VGND VGND VPWR VPWR _2650_/Q sky130_fd_sc_hd__dfxtp_2
X_2581_ _2583_/A _2642_/Q VGND VGND VPWR VPWR _2581_/X sky130_fd_sc_hd__or2_2
X_1394_ _1394_/A _1394_/B VGND VGND VPWR VPWR _1394_/X sky130_fd_sc_hd__and2_2
X_1463_ _1598_/A _1463_/B VGND VGND VPWR VPWR _1464_/B sky130_fd_sc_hd__xnor2_2
XFILLER_35_241 VGND VGND VPWR VPWR sky130_fd_sc_hd__decap_3
XFILLER_35_263 VGND VGND VPWR VPWR sky130_fd_sc_hd__decap_3
X_2015_ _2015_/A _2015_/B _2015_/C VGND VGND VPWR VPWR _2015_/Y sky130_fd_sc_hd__nand3_2
XFILLER_2_318 VGND VGND VPWR VPWR sky130_fd_sc_hd__fill_2
XFILLER_37_34 VGND VGND VPWR VPWR sky130_fd_sc_hd__decap_3
XTAP_TAPCELL_ROW_5_167 VGND VPWR sky130_fd_sc_hd__tapvpwrvgnd_1
XFILLER_41_222 VGND VGND VPWR VPWR sky130_fd_sc_hd__fill_2
XFILLER_53_22 VGND VGND VPWR VPWR sky130_fd_sc_hd__decap_3
XFILLER_32_277 VGND VGND VPWR VPWR sky130_fd_sc_hd__decap_3
X_2702_ _2702_/CLK _2702_/D VGND VGND VPWR VPWR _2702_/Q sky130_fd_sc_hd__dfxtp_2
XFILLER_59_119 VGND VGND VPWR VPWR sky130_fd_sc_hd__decap_3
XTAP_TAPCELL_ROW_10_191 VGND VPWR sky130_fd_sc_hd__tapvpwrvgnd_1
X_1515_ _2632_/Q _1603_/A2 _1380_/Y _1709_/B _1916_/A1 VGND VGND VPWR VPWR _1516_/B
+ sky130_fd_sc_hd__a32o_2
X_2633_ clkload4/A _2633_/D VGND VGND VPWR VPWR _2633_/Q sky130_fd_sc_hd__dfxtp_2
X_2564_ _2592_/A1 hold619/X _2572_/C1 _2563_/X VGND VGND VPWR VPWR _2564_/X sky130_fd_sc_hd__o211a_2
XFILLER_55_303 VGND VGND VPWR VPWR sky130_fd_sc_hd__decap_3
XTAP_TAPCELL_ROW_2_148 VGND VPWR sky130_fd_sc_hd__tapvpwrvgnd_1
X_1377_ _1727_/A _2632_/Q _1478_/A2 _1727_/B VGND VGND VPWR VPWR _1378_/B sky130_fd_sc_hd__a22o_2
X_1446_ _1446_/A _1446_/B VGND VGND VPWR VPWR _1509_/B sky130_fd_sc_hd__xnor2_2
XFILLER_23_69 VGND VGND VPWR VPWR sky130_fd_sc_hd__fill_2
XFILLER_48_11 VGND VGND VPWR VPWR sky130_fd_sc_hd__decap_3
XFILLER_48_44 VGND VGND VPWR VPWR sky130_fd_sc_hd__decap_3
XFILLER_48_66 VGND VGND VPWR VPWR sky130_fd_sc_hd__decap_3
XFILLER_58_141 VGND VGND VPWR VPWR sky130_fd_sc_hd__fill_2
XFILLER_14_200 VGND VGND VPWR VPWR sky130_fd_sc_hd__decap_3
XFILLER_48_88 VGND VGND VPWR VPWR sky130_fd_sc_hd__decap_3
XFILLER_61_317 VGND VGND VPWR VPWR sky130_fd_sc_hd__decap_3
XFILLER_64_21 VGND VGND VPWR VPWR sky130_fd_sc_hd__decap_3
XFILLER_64_32 VGND VGND VPWR VPWR sky130_fd_sc_hd__decap_3
XFILLER_64_76 VGND VGND VPWR VPWR sky130_fd_sc_hd__decap_3
XTAP_TAPCELL_ROW_16_228 VGND VPWR sky130_fd_sc_hd__tapvpwrvgnd_1
XFILLER_14_233 VGND VGND VPWR VPWR sky130_fd_sc_hd__decap_3
XTAP_TAPCELL_ROW_24_272 VGND VPWR sky130_fd_sc_hd__tapvpwrvgnd_1
Xfanout81 _2591_/A VGND VGND VPWR VPWR _2587_/A sky130_fd_sc_hd__buf_1
XPHY_EDGE_ROW_24_Left_89 VGND VGND VPWR VPWR sky130_fd_sc_hd__decap_3
XFILLER_49_174 VGND VGND VPWR VPWR sky130_fd_sc_hd__decap_3
XFILLER_49_185 VGND VGND VPWR VPWR sky130_fd_sc_hd__fill_2
XFILLER_64_100 VGND VGND VPWR VPWR sky130_fd_sc_hd__decap_3
XFILLER_64_122 VGND VGND VPWR VPWR sky130_fd_sc_hd__fill_1
X_2280_ _2289_/A _2289_/B VGND VGND VPWR VPWR _2282_/A sky130_fd_sc_hd__nand2_2
XFILLER_52_306 VGND VGND VPWR VPWR sky130_fd_sc_hd__fill_2
XFILLER_64_144 VGND VGND VPWR VPWR sky130_fd_sc_hd__fill_1
XTAP_TAPCELL_ROW_47_397 VGND VPWR sky130_fd_sc_hd__tapvpwrvgnd_1
XFILLER_9_281 VGND VGND VPWR VPWR sky130_fd_sc_hd__decap_3
X_2616_ _2657_/Q _2618_/B VGND VGND VPWR VPWR _2616_/X sky130_fd_sc_hd__or2_2
X_1995_ _1948_/A _1993_/Y _1994_/X _2675_/Q _1792_/A VGND VGND VPWR VPWR _1996_/B
+ sky130_fd_sc_hd__a32o_2
X_1429_ _2665_/Q _2196_/B _2666_/Q VGND VGND VPWR VPWR _1430_/B sky130_fd_sc_hd__o21a_2
X_2547_ _2579_/A _2628_/Q VGND VGND VPWR VPWR _2547_/X sky130_fd_sc_hd__or2_2
X_2478_ _2478_/A _2478_/B VGND VGND VPWR VPWR _2480_/A sky130_fd_sc_hd__nor2_2
XFILLER_28_303 VGND VGND VPWR VPWR sky130_fd_sc_hd__decap_3
XFILLER_55_100 VGND VGND VPWR VPWR sky130_fd_sc_hd__decap_3
XFILLER_55_122 VGND VGND VPWR VPWR sky130_fd_sc_hd__decap_3
XFILLER_11_203 VGND VGND VPWR VPWR sky130_fd_sc_hd__decap_3
XFILLER_11_225 VGND VGND VPWR VPWR sky130_fd_sc_hd__decap_3
XTAP_TAPCELL_ROW_13_209 VGND VPWR sky130_fd_sc_hd__tapvpwrvgnd_1
XTAP_TAPCELL_ROW_21_253 VGND VPWR sky130_fd_sc_hd__tapvpwrvgnd_1
Xclkload1 clkload1/A VGND VGND VPWR VPWR clkload1/X sky130_fd_sc_hd__clkbuf_4
XFILLER_50_56 VGND VGND VPWR VPWR sky130_fd_sc_hd__fill_1
XFILLER_50_78 VGND VGND VPWR VPWR sky130_fd_sc_hd__decap_3
XFILLER_59_21 VGND VGND VPWR VPWR sky130_fd_sc_hd__decap_3
XFILLER_59_76 VGND VGND VPWR VPWR sky130_fd_sc_hd__fill_2
XFILLER_46_144 VGND VGND VPWR VPWR sky130_fd_sc_hd__decap_3
XFILLER_46_177 VGND VGND VPWR VPWR sky130_fd_sc_hd__decap_3
XFILLER_61_147 VGND VGND VPWR VPWR sky130_fd_sc_hd__decap_3
XTAP_TAPCELL_ROW_44_378 VGND VPWR sky130_fd_sc_hd__tapvpwrvgnd_1
XFILLER_6_262 VGND VGND VPWR VPWR sky130_fd_sc_hd__decap_3
X_1780_ _1780_/A _1780_/B VGND VGND VPWR VPWR _1838_/A sky130_fd_sc_hd__xor2_2
X_2401_ _2420_/A _2401_/B VGND VGND VPWR VPWR _2437_/A sky130_fd_sc_hd__or2_2
X_2332_ _2707_/A _2333_/B VGND VGND VPWR VPWR _2452_/A sky130_fd_sc_hd__nor2_2
XFILLER_37_111 VGND VGND VPWR VPWR sky130_fd_sc_hd__fill_1
XFILLER_37_166 VGND VGND VPWR VPWR sky130_fd_sc_hd__fill_2
X_2263_ _2242_/A _2242_/B _2241_/A VGND VGND VPWR VPWR _2300_/A sky130_fd_sc_hd__a21oi_2
X_2194_ _2181_/A _2194_/B VGND VGND VPWR VPWR _2216_/B sky130_fd_sc_hd__and2b_2
XFILLER_40_309 VGND VGND VPWR VPWR sky130_fd_sc_hd__decap_3
XFILLER_52_158 VGND VGND VPWR VPWR sky130_fd_sc_hd__decap_3
X_1978_ _1979_/A _1979_/B VGND VGND VPWR VPWR _2015_/C sky130_fd_sc_hd__nand2_2
XFILLER_29_13 VGND VGND VPWR VPWR sky130_fd_sc_hd__fill_1
XFILLER_29_57 VGND VGND VPWR VPWR sky130_fd_sc_hd__decap_3
Xinput317 hold609/X VGND VGND VPWR VPWR hold610/A sky130_fd_sc_hd__buf_2
Xinput328 hold555/X VGND VGND VPWR VPWR hold556/A sky130_fd_sc_hd__buf_2
Xinput339 hold587/X VGND VGND VPWR VPWR hold588/A sky130_fd_sc_hd__buf_2
XFILLER_16_317 VGND VGND VPWR VPWR sky130_fd_sc_hd__decap_3
XFILLER_43_169 VGND VGND VPWR VPWR sky130_fd_sc_hd__decap_3
XFILLER_45_12 VGND VGND VPWR VPWR sky130_fd_sc_hd__decap_3
XFILLER_45_45 VGND VGND VPWR VPWR sky130_fd_sc_hd__fill_2
XTAP_TAPCELL_ROW_58_459 VGND VPWR sky130_fd_sc_hd__tapvpwrvgnd_1
XFILLER_61_99 VGND VGND VPWR VPWR sky130_fd_sc_hd__fill_2
XFILLER_3_265 VGND VGND VPWR VPWR sky130_fd_sc_hd__decap_3
XFILLER_19_111 VGND VGND VPWR VPWR sky130_fd_sc_hd__fill_1
XFILLER_19_122 VGND VGND VPWR VPWR sky130_fd_sc_hd__fill_1
XFILLER_19_188 VGND VGND VPWR VPWR sky130_fd_sc_hd__fill_2
XFILLER_22_309 VGND VGND VPWR VPWR sky130_fd_sc_hd__fill_1
XFILLER_34_136 VGND VGND VPWR VPWR sky130_fd_sc_hd__decap_3
XTAP_TAPCELL_ROW_32_315 VGND VPWR sky130_fd_sc_hd__tapvpwrvgnd_1
X_1901_ _1900_/A _1900_/B _1792_/X VGND VGND VPWR VPWR _1901_/X sky130_fd_sc_hd__a21o_2
X_1832_ _1776_/A _1776_/B _1831_/X VGND VGND VPWR VPWR _1833_/B sky130_fd_sc_hd__a21oi_2
Xhold505 hold668/X VGND VGND VPWR VPWR hold669/A sky130_fd_sc_hd__clkbuf_2
Xhold516 b_in[0] VGND VGND VPWR VPWR hold516/X sky130_fd_sc_hd__clkbuf_2
Xhold527 hold539/X VGND VGND VPWR VPWR _2608_/B sky130_fd_sc_hd__clkbuf_2
Xhold538 hold538/A VGND VGND VPWR VPWR hold538/X sky130_fd_sc_hd__clkbuf_2
Xhold549 hold675/X VGND VGND VPWR VPWR hold676/A sky130_fd_sc_hd__clkbuf_2
X_1763_ _2008_/B2 _2086_/A2 _1921_/B1 _1960_/B2 VGND VGND VPWR VPWR _1764_/B sky130_fd_sc_hd__a22o_2
X_1694_ _1728_/A2 _1379_/X _1702_/A3 _1702_/B1 _1700_/B1 VGND VGND VPWR VPWR _1695_/B
+ sky130_fd_sc_hd__a32o_2
XFILLER_57_228 VGND VGND VPWR VPWR sky130_fd_sc_hd__decap_3
XPHY_EDGE_ROW_27_Left_92 VGND VGND VPWR VPWR sky130_fd_sc_hd__decap_3
X_2315_ _2315_/A _2315_/B VGND VGND VPWR VPWR _2316_/B sky130_fd_sc_hd__xnor2_2
X_2246_ _2207_/A _2207_/B _2245_/X VGND VGND VPWR VPWR _2261_/A sky130_fd_sc_hd__a21oi_2
XFILLER_25_169 VGND VGND VPWR VPWR sky130_fd_sc_hd__decap_3
XPHY_EDGE_ROW_11_Left_76 VGND VGND VPWR VPWR sky130_fd_sc_hd__decap_3
X_2177_ _2177_/A _2177_/B VGND VGND VPWR VPWR _2177_/Y sky130_fd_sc_hd__nor2_2
XTAP_TAPCELL_ROW_63_484 VGND VPWR sky130_fd_sc_hd__tapvpwrvgnd_1
XFILLER_0_268 VGND VGND VPWR VPWR sky130_fd_sc_hd__decap_3
XFILLER_56_44 VGND VGND VPWR VPWR sky130_fd_sc_hd__decap_3
Xplace209 _2095_/A2 VGND VGND VPWR VPWR _1555_/B sky130_fd_sc_hd__buf_1
XFILLER_16_147 VGND VGND VPWR VPWR sky130_fd_sc_hd__decap_3
XFILLER_24_191 VGND VGND VPWR VPWR sky130_fd_sc_hd__decap_3
XFILLER_39_206 VGND VGND VPWR VPWR sky130_fd_sc_hd__decap_3
XFILLER_39_217 VGND VGND VPWR VPWR sky130_fd_sc_hd__decap_3
X_2100_ _2100_/A _2100_/B VGND VGND VPWR VPWR _2101_/B sky130_fd_sc_hd__xor2_2
XFILLER_62_253 VGND VGND VPWR VPWR sky130_fd_sc_hd__decap_3
X_2031_ _2031_/A _2031_/B _2031_/C VGND VGND VPWR VPWR _2032_/B sky130_fd_sc_hd__nor3_2
XFILLER_22_139 VGND VGND VPWR VPWR sky130_fd_sc_hd__fill_1
XFILLER_30_150 VGND VGND VPWR VPWR sky130_fd_sc_hd__decap_3
XTAP_TAPCELL_ROW_60_465 VGND VPWR sky130_fd_sc_hd__tapvpwrvgnd_1
X_1815_ _2631_/Q _2017_/A2 _2017_/A3 _1916_/B1 _2022_/A1 VGND VGND VPWR VPWR _1816_/B
+ sky130_fd_sc_hd__a32o_2
X_1746_ _1588_/A _1588_/B _1745_/Y VGND VGND VPWR VPWR _1800_/A sky130_fd_sc_hd__a21boi_2
X_1677_ _1728_/A2 _1697_/B _1677_/B1 _1697_/A VGND VGND VPWR VPWR _1678_/B sky130_fd_sc_hd__a22o_2
X_2229_ _2259_/A _2681_/Q _2286_/B _2228_/Y VGND VGND VPWR VPWR _2230_/B sky130_fd_sc_hd__o2bb2a_2
XFILLER_42_24 VGND VGND VPWR VPWR sky130_fd_sc_hd__decap_3
XFILLER_53_231 VGND VGND VPWR VPWR sky130_fd_sc_hd__decap_3
XFILLER_44_242 VGND VGND VPWR VPWR sky130_fd_sc_hd__decap_3
XFILLER_44_286 VGND VGND VPWR VPWR sky130_fd_sc_hd__fill_2
X_1462_ _1854_/B2 _1494_/B _1921_/B1 _1807_/B2 VGND VGND VPWR VPWR _1463_/B sky130_fd_sc_hd__a22o_2
X_1531_ _1585_/A _1585_/B VGND VGND VPWR VPWR _1544_/A sky130_fd_sc_hd__xor2_2
X_1600_ _1727_/A _1600_/A2 _1628_/A2 _1727_/B VGND VGND VPWR VPWR _1601_/B sky130_fd_sc_hd__a22o_2
X_2580_ _2580_/A1 hold514/X _2580_/B1 _2579_/X VGND VGND VPWR VPWR _2580_/X sky130_fd_sc_hd__o211a_2
X_1393_ _1484_/A _1393_/B VGND VGND VPWR VPWR _1487_/B sky130_fd_sc_hd__xor2_2
XFILLER_35_253 VGND VGND VPWR VPWR sky130_fd_sc_hd__decap_3
XFILLER_35_275 VGND VGND VPWR VPWR sky130_fd_sc_hd__fill_2
XFILLER_50_245 VGND VGND VPWR VPWR sky130_fd_sc_hd__decap_3
XFILLER_50_267 VGND VGND VPWR VPWR sky130_fd_sc_hd__decap_3
X_2014_ _2015_/B _2015_/C _2015_/A VGND VGND VPWR VPWR _2016_/A sky130_fd_sc_hd__a21oi_2
XFILLER_58_312 VGND VGND VPWR VPWR sky130_fd_sc_hd__decap_3
X_1729_ _1712_/A _1711_/B _1724_/C _1728_/X _1701_/A VGND VGND VPWR VPWR _1729_/X
+ sky130_fd_sc_hd__a2111o_2
XFILLER_26_220 VGND VGND VPWR VPWR sky130_fd_sc_hd__decap_3
XFILLER_26_253 VGND VGND VPWR VPWR sky130_fd_sc_hd__fill_1
XFILLER_37_57 VGND VGND VPWR VPWR sky130_fd_sc_hd__decap_3
XFILLER_41_234 VGND VGND VPWR VPWR sky130_fd_sc_hd__decap_3
XFILLER_53_34 VGND VGND VPWR VPWR sky130_fd_sc_hd__fill_2
XFILLER_53_45 VGND VGND VPWR VPWR sky130_fd_sc_hd__fill_2
XFILLER_5_113 VGND VGND VPWR VPWR sky130_fd_sc_hd__fill_1
XFILLER_49_301 VGND VGND VPWR VPWR sky130_fd_sc_hd__fill_2
XFILLER_17_231 VGND VGND VPWR VPWR sky130_fd_sc_hd__decap_3
XFILLER_17_264 VGND VGND VPWR VPWR sky130_fd_sc_hd__decap_3
XFILLER_17_275 VGND VGND VPWR VPWR sky130_fd_sc_hd__decap_3
XFILLER_17_297 VGND VGND VPWR VPWR sky130_fd_sc_hd__decap_3
XFILLER_32_256 VGND VGND VPWR VPWR sky130_fd_sc_hd__fill_1
XFILLER_32_289 VGND VGND VPWR VPWR sky130_fd_sc_hd__fill_1
XFILLER_64_3 VGND VGND VPWR VPWR sky130_fd_sc_hd__decap_3
X_2701_ _2702_/CLK _2701_/D VGND VGND VPWR VPWR _2701_/Q sky130_fd_sc_hd__dfxtp_2
X_2632_ clkload4/A _2632_/D VGND VGND VPWR VPWR _2632_/Q sky130_fd_sc_hd__dfxtp_2
XTAP_TAPCELL_ROW_10_192 VGND VPWR sky130_fd_sc_hd__tapvpwrvgnd_1
X_1445_ _1519_/A _1445_/B VGND VGND VPWR VPWR _1446_/B sky130_fd_sc_hd__xor2_2
X_1514_ _1601_/A _1514_/B VGND VGND VPWR VPWR _1577_/A sky130_fd_sc_hd__xnor2_2
X_2563_ _2608_/A _2636_/Q VGND VGND VPWR VPWR _2563_/X sky130_fd_sc_hd__or2_2
X_2494_ _2498_/A _2494_/B VGND VGND VPWR VPWR _2695_/D sky130_fd_sc_hd__and2_2
XFILLER_55_315 VGND VGND VPWR VPWR sky130_fd_sc_hd__decap_3
XTAP_TAPCELL_ROW_2_149 VGND VPWR sky130_fd_sc_hd__tapvpwrvgnd_1
X_1376_ _1768_/A VGND VGND VPWR VPWR _2614_/A sky130_fd_sc_hd__inv_6
XFILLER_2_116 VGND VGND VPWR VPWR sky130_fd_sc_hd__fill_2
XFILLER_2_149 VGND VGND VPWR VPWR sky130_fd_sc_hd__fill_1
XFILLER_48_23 VGND VGND VPWR VPWR sky130_fd_sc_hd__decap_3
XFILLER_58_131 VGND VGND VPWR VPWR sky130_fd_sc_hd__decap_3
XFILLER_14_245 VGND VGND VPWR VPWR sky130_fd_sc_hd__fill_1
XFILLER_64_44 VGND VGND VPWR VPWR sky130_fd_sc_hd__decap_3
XFILLER_64_88 VGND VGND VPWR VPWR sky130_fd_sc_hd__decap_3
XFILLER_14_289 VGND VGND VPWR VPWR sky130_fd_sc_hd__decap_3
Xfanout82 _2575_/A VGND VGND VPWR VPWR _2579_/A sky130_fd_sc_hd__buf_1
XFILLER_1_182 VGND VGND VPWR VPWR sky130_fd_sc_hd__fill_1
XFILLER_49_164 VGND VGND VPWR VPWR sky130_fd_sc_hd__decap_3
XFILLER_64_134 VGND VGND VPWR VPWR sky130_fd_sc_hd__decap_3
XFILLER_64_156 VGND VGND VPWR VPWR sky130_fd_sc_hd__decap_3
XFILLER_20_215 VGND VGND VPWR VPWR sky130_fd_sc_hd__fill_2
XFILLER_20_248 VGND VGND VPWR VPWR sky130_fd_sc_hd__decap_3
XFILLER_52_318 VGND VGND VPWR VPWR sky130_fd_sc_hd__fill_2
XFILLER_64_178 VGND VGND VPWR VPWR sky130_fd_sc_hd__decap_3
XTAP_TAPCELL_ROW_47_398 VGND VPWR sky130_fd_sc_hd__tapvpwrvgnd_1
X_1994_ _1994_/A _1994_/B _2070_/A VGND VGND VPWR VPWR _1994_/X sky130_fd_sc_hd__or3b_2
XFILLER_20_259 VGND VGND VPWR VPWR sky130_fd_sc_hd__decap_3
X_2615_ hold498/X _2614_/B _2614_/Y _2619_/C1 VGND VGND VPWR VPWR _2615_/X sky130_fd_sc_hd__o211a_2
XFILLER_28_315 VGND VGND VPWR VPWR sky130_fd_sc_hd__fill_1
X_1428_ _2665_/Q _2196_/B _2666_/Q VGND VGND VPWR VPWR _1430_/A sky130_fd_sc_hd__a21oi_2
X_2546_ _2588_/A1 hold627/X _2550_/B1 _2545_/X VGND VGND VPWR VPWR _2546_/X sky130_fd_sc_hd__o211a_2
XFILLER_55_134 VGND VGND VPWR VPWR sky130_fd_sc_hd__decap_3
X_1359_ _1359_/A _1367_/B VGND VGND VPWR VPWR _1359_/X sky130_fd_sc_hd__or2_2
XFILLER_11_259 VGND VGND VPWR VPWR sky130_fd_sc_hd__decap_3
XFILLER_34_47 VGND VGND VPWR VPWR sky130_fd_sc_hd__decap_3
XFILLER_50_13 VGND VGND VPWR VPWR sky130_fd_sc_hd__fill_2
XTAP_TAPCELL_ROW_21_254 VGND VPWR sky130_fd_sc_hd__tapvpwrvgnd_1
Xclkload2 clkload2/A VGND VGND VPWR VPWR clkload2/X sky130_fd_sc_hd__clkbuf_4
XFILLER_46_134 VGND VGND VPWR VPWR sky130_fd_sc_hd__decap_3
XFILLER_46_189 VGND VGND VPWR VPWR sky130_fd_sc_hd__decap_3
XTAP_TAPCELL_ROW_44_379 VGND VPWR sky130_fd_sc_hd__tapvpwrvgnd_1
X_2400_ _2697_/Q _2400_/B VGND VGND VPWR VPWR _2401_/B sky130_fd_sc_hd__nor2_2
XFILLER_27_3 VGND VGND VPWR VPWR sky130_fd_sc_hd__fill_1
X_2262_ _2244_/A _2260_/Y _2261_/X VGND VGND VPWR VPWR _2278_/B sky130_fd_sc_hd__o21a_2
XFILLER_52_126 VGND VGND VPWR VPWR sky130_fd_sc_hd__decap_3
X_2193_ _2179_/B _2193_/B VGND VGND VPWR VPWR _2216_/A sky130_fd_sc_hd__and2b_2
XFILLER_60_192 VGND VGND VPWR VPWR sky130_fd_sc_hd__decap_3
X_1977_ _2015_/A _1975_/X _1976_/X VGND VGND VPWR VPWR _1979_/B sky130_fd_sc_hd__a21o_2
XFILLER_28_123 VGND VGND VPWR VPWR sky130_fd_sc_hd__decap_3
Xinput318 hold633/X VGND VGND VPWR VPWR hold634/A sky130_fd_sc_hd__buf_2
Xinput329 hold531/X VGND VGND VPWR VPWR hold532/A sky130_fd_sc_hd__buf_2
XFILLER_43_137 VGND VGND VPWR VPWR sky130_fd_sc_hd__decap_3
XFILLER_45_24 VGND VGND VPWR VPWR sky130_fd_sc_hd__decap_3
XFILLER_45_57 VGND VGND VPWR VPWR sky130_fd_sc_hd__fill_2
XFILLER_51_181 VGND VGND VPWR VPWR sky130_fd_sc_hd__decap_3
XFILLER_61_34 VGND VGND VPWR VPWR sky130_fd_sc_hd__decap_3
XFILLER_3_277 VGND VGND VPWR VPWR sky130_fd_sc_hd__decap_3
XTAP_TAPCELL_ROW_49_405 VGND VPWR sky130_fd_sc_hd__tapvpwrvgnd_1
XFILLER_19_145 VGND VGND VPWR VPWR sky130_fd_sc_hd__fill_1
XFILLER_34_126 VGND VGND VPWR VPWR sky130_fd_sc_hd__fill_2
XFILLER_59_281 VGND VGND VPWR VPWR sky130_fd_sc_hd__decap_3
XFILLER_59_292 VGND VGND VPWR VPWR sky130_fd_sc_hd__decap_3
XTAP_TAPCELL_ROW_32_316 VGND VPWR sky130_fd_sc_hd__tapvpwrvgnd_1
XTAP_TAPCELL_ROW_40_360 VGND VPWR sky130_fd_sc_hd__tapvpwrvgnd_1
X_1900_ _1900_/A _1900_/B VGND VGND VPWR VPWR _1946_/A sky130_fd_sc_hd__nor2_2
X_1831_ _1831_/A _1831_/B _1831_/C VGND VGND VPWR VPWR _1831_/X sky130_fd_sc_hd__and3_2
Xhold506 hold670/X VGND VGND VPWR VPWR _2566_/D sky130_fd_sc_hd__clkbuf_2
Xhold517 hold517/A VGND VGND VPWR VPWR hold517/X sky130_fd_sc_hd__clkbuf_2
Xhold528 _2608_/Y VGND VGND VPWR VPWR hold528/X sky130_fd_sc_hd__clkbuf_2
Xhold539 _2607_/Y VGND VGND VPWR VPWR hold539/X sky130_fd_sc_hd__clkbuf_2
X_1762_ _1762_/A _1762_/B VGND VGND VPWR VPWR _1766_/A sky130_fd_sc_hd__xor2_2
X_1693_ _1701_/A _1693_/B VGND VGND VPWR VPWR _1718_/A sky130_fd_sc_hd__xnor2_2
XFILLER_57_207 VGND VGND VPWR VPWR sky130_fd_sc_hd__decap_3
X_2314_ _2291_/A _2291_/B _2294_/B VGND VGND VPWR VPWR _2315_/B sky130_fd_sc_hd__o21a_2
X_2245_ _2206_/A _2245_/B VGND VGND VPWR VPWR _2245_/X sky130_fd_sc_hd__and2b_2
X_2176_ _2176_/A VGND VGND VPWR VPWR _2177_/A sky130_fd_sc_hd__inv_2
XFILLER_33_181 VGND VGND VPWR VPWR sky130_fd_sc_hd__decap_3
XTAP_TAPCELL_ROW_63_485 VGND VPWR sky130_fd_sc_hd__tapvpwrvgnd_1
XFILLER_0_225 VGND VGND VPWR VPWR sky130_fd_sc_hd__decap_3
XFILLER_0_247 VGND VGND VPWR VPWR sky130_fd_sc_hd__decap_3
XFILLER_48_207 VGND VGND VPWR VPWR sky130_fd_sc_hd__decap_3
XPHY_EDGE_ROW_1_Right_1 VGND VGND VPWR VPWR sky130_fd_sc_hd__decap_3
XFILLER_56_251 VGND VGND VPWR VPWR sky130_fd_sc_hd__fill_1
XFILLER_56_56 VGND VGND VPWR VPWR sky130_fd_sc_hd__decap_3
X_2030_ _2031_/A _2031_/B _2031_/C VGND VGND VPWR VPWR _2032_/A sky130_fd_sc_hd__o21a_2
XFILLER_22_107 VGND VGND VPWR VPWR sky130_fd_sc_hd__decap_3
XFILLER_47_251 VGND VGND VPWR VPWR sky130_fd_sc_hd__decap_3
XFILLER_62_232 VGND VGND VPWR VPWR sky130_fd_sc_hd__decap_3
XFILLER_62_265 VGND VGND VPWR VPWR sky130_fd_sc_hd__decap_3
XFILLER_15_181 VGND VGND VPWR VPWR sky130_fd_sc_hd__decap_3
XFILLER_30_184 VGND VGND VPWR VPWR sky130_fd_sc_hd__fill_1
XTAP_TAPCELL_ROW_60_466 VGND VPWR sky130_fd_sc_hd__tapvpwrvgnd_1
X_1814_ _1814_/A _1814_/B VGND VGND VPWR VPWR _1837_/A sky130_fd_sc_hd__xor2_2
X_1745_ _1745_/A _1745_/B VGND VGND VPWR VPWR _1745_/Y sky130_fd_sc_hd__nand2_2
X_1676_ _1679_/A _1679_/B VGND VGND VPWR VPWR _1716_/A sky130_fd_sc_hd__xor2_2
XFILLER_38_251 VGND VGND VPWR VPWR sky130_fd_sc_hd__fill_1
X_2228_ _2255_/A _2228_/B VGND VGND VPWR VPWR _2228_/Y sky130_fd_sc_hd__xnor2_2
XFILLER_21_162 VGND VGND VPWR VPWR sky130_fd_sc_hd__decap_3
XFILLER_53_243 VGND VGND VPWR VPWR sky130_fd_sc_hd__decap_3
XFILLER_29_284 VGND VGND VPWR VPWR sky130_fd_sc_hd__decap_3
XFILLER_29_295 VGND VGND VPWR VPWR sky130_fd_sc_hd__decap_3
XFILLER_44_232 VGND VGND VPWR VPWR sky130_fd_sc_hd__fill_2
XFILLER_32_80 VGND VGND VPWR VPWR sky130_fd_sc_hd__decap_3
X_1392_ _1646_/A2 _1697_/B _1677_/B1 _1524_/A1 VGND VGND VPWR VPWR _1393_/B sky130_fd_sc_hd__a22o_2
X_1530_ _1530_/A _1530_/B VGND VGND VPWR VPWR _1585_/B sky130_fd_sc_hd__xnor2_2
XFILLER_35_221 VGND VGND VPWR VPWR sky130_fd_sc_hd__decap_3
X_2013_ _2013_/A _2013_/B VGND VGND VPWR VPWR _2029_/A sky130_fd_sc_hd__xnor2_2
XFILLER_35_232 VGND VGND VPWR VPWR sky130_fd_sc_hd__fill_2
XFILLER_50_235 VGND VGND VPWR VPWR sky130_fd_sc_hd__decap_3
XFILLER_2_309 VGND VGND VPWR VPWR sky130_fd_sc_hd__decap_3
X_1728_ _1727_/A _1728_/A2 _1697_/A _1727_/X _1712_/Y VGND VGND VPWR VPWR _1728_/X
+ sky130_fd_sc_hd__a221o_2
X_1659_ _1671_/A _1659_/B VGND VGND VPWR VPWR _1685_/B sky130_fd_sc_hd__xor2_2
XFILLER_26_298 VGND VGND VPWR VPWR sky130_fd_sc_hd__decap_3
XFILLER_41_213 VGND VGND VPWR VPWR sky130_fd_sc_hd__fill_2
XFILLER_53_79 VGND VGND VPWR VPWR sky130_fd_sc_hd__decap_3
XFILLER_5_169 VGND VGND VPWR VPWR sky130_fd_sc_hd__fill_2
XFILLER_43_90 VGND VGND VPWR VPWR sky130_fd_sc_hd__decap_3
XTAP_TAPCELL_ROW_10_193 VGND VPWR sky130_fd_sc_hd__tapvpwrvgnd_1
X_2700_ _2702_/CLK _2700_/D VGND VGND VPWR VPWR _2700_/Q sky130_fd_sc_hd__dfxtp_2
X_2631_ clkload6/A _2631_/D VGND VGND VPWR VPWR _2631_/Q sky130_fd_sc_hd__dfxtp_2
X_2562_ _2308_/A hold639/X _2572_/C1 _2561_/X VGND VGND VPWR VPWR _2562_/X sky130_fd_sc_hd__o211a_2
X_1375_ _2671_/Q VGND VGND VPWR VPWR _2333_/B sky130_fd_sc_hd__inv_2
X_1444_ _1600_/A2 _1386_/X _1677_/B1 _1628_/A2 VGND VGND VPWR VPWR _1445_/B sky130_fd_sc_hd__a22o_2
X_1513_ _2655_/Q _1926_/A1 _1877_/A1 _1768_/C VGND VGND VPWR VPWR _1514_/B sky130_fd_sc_hd__a22o_2
X_2493_ _2695_/Q _2524_/A2 _2524_/B1 _2492_/X VGND VGND VPWR VPWR _2494_/B sky130_fd_sc_hd__a22o_2
XFILLER_23_202 VGND VGND VPWR VPWR sky130_fd_sc_hd__fill_1
XFILLER_31_290 VGND VGND VPWR VPWR sky130_fd_sc_hd__fill_1
XFILLER_2_139 VGND VGND VPWR VPWR sky130_fd_sc_hd__fill_1
XFILLER_48_35 VGND VGND VPWR VPWR sky130_fd_sc_hd__decap_3
XFILLER_58_121 VGND VGND VPWR VPWR sky130_fd_sc_hd__decap_3
XFILLER_58_176 VGND VGND VPWR VPWR sky130_fd_sc_hd__decap_3
XFILLER_64_12 VGND VGND VPWR VPWR sky130_fd_sc_hd__decap_3
XFILLER_14_279 VGND VGND VPWR VPWR sky130_fd_sc_hd__fill_1
XFILLER_61_308 VGND VGND VPWR VPWR sky130_fd_sc_hd__decap_3
XFILLER_64_67 VGND VGND VPWR VPWR sky130_fd_sc_hd__decap_3
Xfanout83 _2591_/A VGND VGND VPWR VPWR _2575_/A sky130_fd_sc_hd__buf_1
XFILLER_29_7 VGND VGND VPWR VPWR sky130_fd_sc_hd__fill_1
XFILLER_64_113 VGND VGND VPWR VPWR sky130_fd_sc_hd__decap_3
X_1993_ _1994_/A _1994_/B _2070_/A VGND VGND VPWR VPWR _1993_/Y sky130_fd_sc_hd__o21bai_2
XFILLER_9_272 VGND VGND VPWR VPWR sky130_fd_sc_hd__decap_3
XFILLER_9_294 VGND VGND VPWR VPWR sky130_fd_sc_hd__decap_3
X_2614_ _2614_/A _2614_/B VGND VGND VPWR VPWR _2614_/Y sky130_fd_sc_hd__nand2_2
X_2545_ _2579_/A _2627_/Q VGND VGND VPWR VPWR _2545_/X sky130_fd_sc_hd__or2_2
X_1358_ _2196_/B _2610_/A _1357_/X _2554_/B1 VGND VGND VPWR VPWR _2664_/D sky130_fd_sc_hd__o211a_2
X_2476_ _2528_/A _2476_/B VGND VGND VPWR VPWR _2692_/D sky130_fd_sc_hd__and2_2
XFILLER_43_319 VGND VGND VPWR VPWR sky130_fd_sc_hd__fill_1
XTAP_TAPCELL_ROW_38_344 VGND VPWR sky130_fd_sc_hd__tapvpwrvgnd_1
XFILLER_50_47 VGND VGND VPWR VPWR sky130_fd_sc_hd__fill_1
XFILLER_50_69 VGND VGND VPWR VPWR sky130_fd_sc_hd__decap_3
XFILLER_7_209 VGND VGND VPWR VPWR sky130_fd_sc_hd__fill_2
XTAP_TAPCELL_ROW_21_255 VGND VPWR sky130_fd_sc_hd__tapvpwrvgnd_1
Xclkload3 clkload3/A VGND VGND VPWR VPWR clkload3/X sky130_fd_sc_hd__clkbuf_4
XFILLER_59_45 VGND VGND VPWR VPWR sky130_fd_sc_hd__decap_3
XFILLER_61_116 VGND VGND VPWR VPWR sky130_fd_sc_hd__decap_3
XFILLER_24_81 VGND VGND VPWR VPWR sky130_fd_sc_hd__decap_3
XFILLER_61_138 VGND VGND VPWR VPWR sky130_fd_sc_hd__decap_3
XFILLER_41_6 VGND VGND VPWR VPWR sky130_fd_sc_hd__decap_3
XFILLER_6_220 VGND VGND VPWR VPWR sky130_fd_sc_hd__fill_2
XFILLER_6_253 VGND VGND VPWR VPWR sky130_fd_sc_hd__decap_3
XFILLER_6_286 VGND VGND VPWR VPWR sky130_fd_sc_hd__decap_3
XFILLER_37_102 VGND VGND VPWR VPWR sky130_fd_sc_hd__decap_3
XFILLER_37_113 VGND VGND VPWR VPWR sky130_fd_sc_hd__fill_2
XFILLER_37_124 VGND VGND VPWR VPWR sky130_fd_sc_hd__fill_2
X_2330_ _2687_/Q _1792_/B hold596/X VGND VGND VPWR VPWR _2330_/Y sky130_fd_sc_hd__o21ai_2
X_2261_ _2261_/A _2247_/A VGND VGND VPWR VPWR _2261_/X sky130_fd_sc_hd__or2b_2
X_2192_ _2192_/A _2192_/B VGND VGND VPWR VPWR _2219_/A sky130_fd_sc_hd__nor2_2
XFILLER_52_138 VGND VGND VPWR VPWR sky130_fd_sc_hd__fill_2
XFILLER_60_160 VGND VGND VPWR VPWR sky130_fd_sc_hd__fill_1
X_1976_ _2015_/A _2659_/Q _2618_/A _1976_/D VGND VGND VPWR VPWR _1976_/X sky130_fd_sc_hd__and4b_2
X_2528_ _2528_/A _2528_/B VGND VGND VPWR VPWR _2703_/D sky130_fd_sc_hd__and2_2
XFILLER_29_37 VGND VGND VPWR VPWR sky130_fd_sc_hd__fill_2
XFILLER_45_36 VGND VGND VPWR VPWR sky130_fd_sc_hd__decap_3
Xinput319 hold653/X VGND VGND VPWR VPWR hold654/A sky130_fd_sc_hd__buf_2
X_2459_ _2460_/A _2460_/B VGND VGND VPWR VPWR _2459_/Y sky130_fd_sc_hd__nand2_2
XFILLER_43_149 VGND VGND VPWR VPWR sky130_fd_sc_hd__fill_1
XFILLER_61_57 VGND VGND VPWR VPWR sky130_fd_sc_hd__decap_3
XFILLER_3_223 VGND VGND VPWR VPWR sky130_fd_sc_hd__fill_1
XFILLER_3_234 VGND VGND VPWR VPWR sky130_fd_sc_hd__decap_3
XFILLER_3_256 VGND VGND VPWR VPWR sky130_fd_sc_hd__decap_3
XTAP_TAPCELL_ROW_49_406 VGND VPWR sky130_fd_sc_hd__tapvpwrvgnd_1
XFILLER_19_92 VGND VGND VPWR VPWR sky130_fd_sc_hd__fill_2
XFILLER_34_149 VGND VGND VPWR VPWR sky130_fd_sc_hd__decap_3
XTAP_TAPCELL_ROW_57_450 VGND VPWR sky130_fd_sc_hd__tapvpwrvgnd_1
XFILLER_35_91 VGND VGND VPWR VPWR sky130_fd_sc_hd__decap_3
XFILLER_42_160 VGND VGND VPWR VPWR sky130_fd_sc_hd__decap_3
XFILLER_42_193 VGND VGND VPWR VPWR sky130_fd_sc_hd__decap_3
X_1830_ _1830_/A _1830_/B VGND VGND VPWR VPWR _1886_/B sky130_fd_sc_hd__xor2_2
X_1761_ _1919_/A _1761_/B VGND VGND VPWR VPWR _1762_/B sky130_fd_sc_hd__xnor2_2
Xhold507 _2556_/X VGND VGND VPWR VPWR _2632_/D sky130_fd_sc_hd__clkbuf_2
Xhold518 hold518/A VGND VGND VPWR VPWR hold518/X sky130_fd_sc_hd__clkbuf_2
Xhold529 _2609_/X VGND VGND VPWR VPWR _2653_/D sky130_fd_sc_hd__clkbuf_2
X_2313_ _2313_/A _2313_/B VGND VGND VPWR VPWR _2315_/A sky130_fd_sc_hd__nand2_2
X_1692_ _1700_/A1 _2626_/Q _1700_/A2 _1700_/B2 VGND VGND VPWR VPWR _1693_/B sky130_fd_sc_hd__a22o_2
X_2244_ _2244_/A _2260_/A VGND VGND VPWR VPWR _2247_/A sky130_fd_sc_hd__xnor2_2
X_2175_ _2195_/A _2195_/B VGND VGND VPWR VPWR _2193_/B sky130_fd_sc_hd__xor2_2
XFILLER_21_300 VGND VGND VPWR VPWR sky130_fd_sc_hd__decap_3
XFILLER_25_127 VGND VGND VPWR VPWR sky130_fd_sc_hd__decap_3
XFILLER_25_138 VGND VGND VPWR VPWR sky130_fd_sc_hd__decap_3
XTAP_TAPCELL_ROW_63_486 VGND VPWR sky130_fd_sc_hd__tapvpwrvgnd_1
X_1959_ _1923_/A _1923_/B _1958_/X VGND VGND VPWR VPWR _1964_/A sky130_fd_sc_hd__a21o_2
XFILLER_0_259 VGND VGND VPWR VPWR sky130_fd_sc_hd__decap_3
XFILLER_16_116 VGND VGND VPWR VPWR sky130_fd_sc_hd__fill_2
XFILLER_56_285 VGND VGND VPWR VPWR sky130_fd_sc_hd__decap_3
XFILLER_56_35 VGND VGND VPWR VPWR sky130_fd_sc_hd__decap_3
XFILLER_12_300 VGND VGND VPWR VPWR sky130_fd_sc_hd__decap_3
XFILLER_47_263 VGND VGND VPWR VPWR sky130_fd_sc_hd__decap_3
XFILLER_62_244 VGND VGND VPWR VPWR sky130_fd_sc_hd__decap_3
Xclkbuf_0_clk clk VGND VGND VPWR VPWR clkbuf_0_clk/X sky130_fd_sc_hd__clkbuf_16
XFILLER_30_141 VGND VGND VPWR VPWR sky130_fd_sc_hd__decap_3
XTAP_TAPCELL_ROW_60_467 VGND VPWR sky130_fd_sc_hd__tapvpwrvgnd_1
X_1813_ _1813_/A _1813_/B VGND VGND VPWR VPWR _1814_/B sky130_fd_sc_hd__xor2_2
X_1744_ _1738_/X _1742_/X _1743_/X VGND VGND VPWR VPWR _1744_/Y sky130_fd_sc_hd__o21ai_4
XPHY_EDGE_ROW_15_Right_15 VGND VGND VPWR VPWR sky130_fd_sc_hd__decap_3
X_1675_ _1772_/A _1675_/B VGND VGND VPWR VPWR _1679_/B sky130_fd_sc_hd__xor2_2
XFILLER_53_200 VGND VGND VPWR VPWR sky130_fd_sc_hd__decap_3
XFILLER_53_211 VGND VGND VPWR VPWR sky130_fd_sc_hd__decap_3
XFILLER_53_255 VGND VGND VPWR VPWR sky130_fd_sc_hd__decap_3
XPHY_EDGE_ROW_24_Right_24 VGND VGND VPWR VPWR sky130_fd_sc_hd__decap_3
X_2227_ _2227_/A _2227_/B _2227_/C _2227_/D VGND VGND VPWR VPWR _2228_/B sky130_fd_sc_hd__and4_4
X_2158_ _2326_/A _2158_/B VGND VGND VPWR VPWR _2679_/D sky130_fd_sc_hd__nor2_2
X_2089_ _2102_/A _2176_/A VGND VGND VPWR VPWR _2091_/A sky130_fd_sc_hd__or2b_2
XFILLER_21_152 VGND VGND VPWR VPWR sky130_fd_sc_hd__decap_3
XPHY_EDGE_ROW_33_Right_33 VGND VGND VPWR VPWR sky130_fd_sc_hd__decap_3
XFILLER_29_252 VGND VGND VPWR VPWR sky130_fd_sc_hd__decap_3
XPHY_EDGE_ROW_42_Right_42 VGND VGND VPWR VPWR sky130_fd_sc_hd__decap_3
XFILLER_12_141 VGND VGND VPWR VPWR sky130_fd_sc_hd__fill_1
XPHY_EDGE_ROW_51_Right_51 VGND VGND VPWR VPWR sky130_fd_sc_hd__decap_3
XFILLER_59_7 VGND VGND VPWR VPWR sky130_fd_sc_hd__fill_1
X_1460_ _1460_/A _1460_/B VGND VGND VPWR VPWR _1464_/A sky130_fd_sc_hd__nor2_2
XFILLER_35_244 VGND VGND VPWR VPWR sky130_fd_sc_hd__decap_3
XPHY_EDGE_ROW_35_Left_100 VGND VGND VPWR VPWR sky130_fd_sc_hd__decap_3
XPHY_EDGE_ROW_60_Right_60 VGND VGND VPWR VPWR sky130_fd_sc_hd__decap_3
X_2012_ _2012_/A _2012_/B VGND VGND VPWR VPWR _2013_/B sky130_fd_sc_hd__xor2_2
XFILLER_35_266 VGND VGND VPWR VPWR sky130_fd_sc_hd__decap_3
X_1658_ _1728_/A2 _1670_/B _1411_/X _1697_/A VGND VGND VPWR VPWR _1659_/B sky130_fd_sc_hd__a22o_2
X_1727_ _1727_/A _1727_/B VGND VGND VPWR VPWR _1727_/X sky130_fd_sc_hd__or2_2
XFILLER_37_37 VGND VGND VPWR VPWR sky130_fd_sc_hd__fill_1
X_1589_ _1798_/A _1798_/B VGND VGND VPWR VPWR _1790_/A sky130_fd_sc_hd__or2_2
XFILLER_26_200 VGND VGND VPWR VPWR sky130_fd_sc_hd__fill_1
XFILLER_26_211 VGND VGND VPWR VPWR sky130_fd_sc_hd__decap_3
XFILLER_41_225 VGND VGND VPWR VPWR sky130_fd_sc_hd__decap_3
XFILLER_53_25 VGND VGND VPWR VPWR sky130_fd_sc_hd__decap_3
XFILLER_17_222 VGND VGND VPWR VPWR sky130_fd_sc_hd__fill_2
XFILLER_17_244 VGND VGND VPWR VPWR sky130_fd_sc_hd__fill_1
XFILLER_64_306 VGND VGND VPWR VPWR sky130_fd_sc_hd__fill_2
XFILLER_64_317 VGND VGND VPWR VPWR sky130_fd_sc_hd__decap_3
XFILLER_32_236 VGND VGND VPWR VPWR sky130_fd_sc_hd__decap_3
XFILLER_40_280 VGND VGND VPWR VPWR sky130_fd_sc_hd__decap_3
XTAP_TAPCELL_ROW_10_194 VGND VPWR sky130_fd_sc_hd__tapvpwrvgnd_1
X_1512_ _1446_/A _1446_/B _1511_/X VGND VGND VPWR VPWR _1581_/A sky130_fd_sc_hd__a21oi_2
X_2630_ clkload4/A _2630_/D VGND VGND VPWR VPWR _2630_/Q sky130_fd_sc_hd__dfxtp_2
X_2561_ _2587_/A _2561_/B VGND VGND VPWR VPWR _2561_/X sky130_fd_sc_hd__or2_2
X_2492_ _2492_/A _2492_/B VGND VGND VPWR VPWR _2492_/X sky130_fd_sc_hd__or2_2
XFILLER_4_181 VGND VGND VPWR VPWR sky130_fd_sc_hd__fill_2
XFILLER_55_306 VGND VGND VPWR VPWR sky130_fd_sc_hd__decap_3
X_1374_ _2230_/A _1374_/B VGND VGND VPWR VPWR _1374_/Y sky130_fd_sc_hd__nor2_2
X_1443_ _1511_/A _1511_/B VGND VGND VPWR VPWR _1446_/A sky130_fd_sc_hd__xor2_2
XFILLER_23_225 VGND VGND VPWR VPWR sky130_fd_sc_hd__fill_2
XFILLER_23_258 VGND VGND VPWR VPWR sky130_fd_sc_hd__decap_3
XFILLER_46_317 VGND VGND VPWR VPWR sky130_fd_sc_hd__decap_3
XFILLER_48_69 VGND VGND VPWR VPWR sky130_fd_sc_hd__fill_2
XFILLER_64_24 VGND VGND VPWR VPWR sky130_fd_sc_hd__decap_3
XFILLER_64_35 VGND VGND VPWR VPWR sky130_fd_sc_hd__decap_3
XFILLER_14_203 VGND VGND VPWR VPWR sky130_fd_sc_hd__decap_3
XFILLER_14_236 VGND VGND VPWR VPWR sky130_fd_sc_hd__decap_3
XFILLER_64_57 VGND VGND VPWR VPWR sky130_fd_sc_hd__decap_3
XFILLER_64_79 VGND VGND VPWR VPWR sky130_fd_sc_hd__decap_3
XFILLER_13_83 VGND VGND VPWR VPWR sky130_fd_sc_hd__fill_1
XFILLER_22_291 VGND VGND VPWR VPWR sky130_fd_sc_hd__fill_1
Xfanout84 hold596/A VGND VGND VPWR VPWR _2591_/A sky130_fd_sc_hd__clkbuf_1
XFILLER_49_100 VGND VGND VPWR VPWR sky130_fd_sc_hd__fill_1
XFILLER_49_111 VGND VGND VPWR VPWR sky130_fd_sc_hd__fill_1
XFILLER_38_91 VGND VGND VPWR VPWR sky130_fd_sc_hd__decap_3
XFILLER_49_177 VGND VGND VPWR VPWR sky130_fd_sc_hd__fill_1
XFILLER_52_309 VGND VGND VPWR VPWR sky130_fd_sc_hd__decap_3
XFILLER_64_169 VGND VGND VPWR VPWR sky130_fd_sc_hd__decap_3
XFILLER_9_284 VGND VGND VPWR VPWR sky130_fd_sc_hd__decap_3
XTAP_TAPCELL_ROW_15_220 VGND VPWR sky130_fd_sc_hd__tapvpwrvgnd_1
Xclkload10 _2703_/CLK VGND VGND VPWR VPWR clkload10/X sky130_fd_sc_hd__clkbuf_4
X_1992_ _1998_/A _1998_/B VGND VGND VPWR VPWR _2070_/A sky130_fd_sc_hd__xnor2_2
X_2613_ hold519/X _2614_/B _2612_/Y _2619_/C1 VGND VGND VPWR VPWR _2613_/X sky130_fd_sc_hd__o211a_2
X_2544_ _2580_/A1 hold655/X _2580_/B1 _2543_/X VGND VGND VPWR VPWR _2544_/X sky130_fd_sc_hd__o211a_2
X_2475_ _2692_/Q _2488_/A2 _2450_/Y _2474_/Y VGND VGND VPWR VPWR _2476_/B sky130_fd_sc_hd__a22o_2
XFILLER_28_306 VGND VGND VPWR VPWR sky130_fd_sc_hd__fill_2
XFILLER_55_103 VGND VGND VPWR VPWR sky130_fd_sc_hd__fill_1
XFILLER_55_125 VGND VGND VPWR VPWR sky130_fd_sc_hd__decap_3
XTAP_TAPCELL_ROW_38_345 VGND VPWR sky130_fd_sc_hd__tapvpwrvgnd_1
X_1357_ _1357_/A _1367_/B VGND VGND VPWR VPWR _1357_/X sky130_fd_sc_hd__or2_2
X_1426_ _2665_/Q _2196_/B VGND VGND VPWR VPWR _1426_/X sky130_fd_sc_hd__xor2_2
XFILLER_11_206 VGND VGND VPWR VPWR sky130_fd_sc_hd__fill_2
XFILLER_11_228 VGND VGND VPWR VPWR sky130_fd_sc_hd__decap_3
Xclkload4 clkload4/A VGND VGND VPWR VPWR clkload4/X sky130_fd_sc_hd__clkbuf_4
XFILLER_59_24 VGND VGND VPWR VPWR sky130_fd_sc_hd__fill_2
XFILLER_59_57 VGND VGND VPWR VPWR sky130_fd_sc_hd__decap_3
XFILLER_46_147 VGND VGND VPWR VPWR sky130_fd_sc_hd__fill_1
XFILLER_61_106 VGND VGND VPWR VPWR sky130_fd_sc_hd__decap_3
XTAP_TAPCELL_ROW_12_201 VGND VPWR sky130_fd_sc_hd__tapvpwrvgnd_1
XFILLER_6_232 VGND VGND VPWR VPWR sky130_fd_sc_hd__decap_3
XFILLER_6_265 VGND VGND VPWR VPWR sky130_fd_sc_hd__fill_1
XFILLER_6_276 VGND VGND VPWR VPWR sky130_fd_sc_hd__fill_1
XFILLER_37_147 VGND VGND VPWR VPWR sky130_fd_sc_hd__decap_3
X_2260_ _2260_/A VGND VGND VPWR VPWR _2260_/Y sky130_fd_sc_hd__inv_2
X_2191_ _2160_/Y hold603/X _2326_/A VGND VGND VPWR VPWR _2680_/D sky130_fd_sc_hd__a21oi_2
XFILLER_37_169 VGND VGND VPWR VPWR sky130_fd_sc_hd__decap_3
XFILLER_20_29 VGND VGND VPWR VPWR sky130_fd_sc_hd__fill_1
X_1975_ _2618_/A _2659_/Q _2124_/A VGND VGND VPWR VPWR _1975_/X sky130_fd_sc_hd__or3b_2
X_1409_ _2661_/Q _2015_/A _2018_/A VGND VGND VPWR VPWR _1411_/A sky130_fd_sc_hd__a21o_2
Xinput309 hold613/X VGND VGND VPWR VPWR hold614/A sky130_fd_sc_hd__buf_2
X_2527_ _2687_/Q _1948_/A _2449_/Y _2330_/Y _2703_/Q VGND VGND VPWR VPWR _2528_/B
+ sky130_fd_sc_hd__a32o_2
XFILLER_16_309 VGND VGND VPWR VPWR sky130_fd_sc_hd__fill_1
XFILLER_45_15 VGND VGND VPWR VPWR sky130_fd_sc_hd__decap_3
X_2389_ _2689_/Q _2425_/B VGND VGND VPWR VPWR _2389_/Y sky130_fd_sc_hd__nand2_2
XFILLER_51_161 VGND VGND VPWR VPWR sky130_fd_sc_hd__decap_3
XFILLER_3_268 VGND VGND VPWR VPWR sky130_fd_sc_hd__decap_3
XFILLER_19_136 VGND VGND VPWR VPWR sky130_fd_sc_hd__decap_3
XTAP_TAPCELL_ROW_49_407 VGND VPWR sky130_fd_sc_hd__tapvpwrvgnd_1
XFILLER_34_139 VGND VGND VPWR VPWR sky130_fd_sc_hd__fill_1
XFILLER_42_172 VGND VGND VPWR VPWR sky130_fd_sc_hd__decap_3
XTAP_TAPCELL_ROW_57_451 VGND VPWR sky130_fd_sc_hd__tapvpwrvgnd_1
XFILLER_51_91 VGND VGND VPWR VPWR sky130_fd_sc_hd__decap_3
Xhold508 hold511/X VGND VGND VPWR VPWR hold512/A sky130_fd_sc_hd__clkbuf_2
X_1760_ _2057_/B2 _2019_/A2 _2019_/A3 _1625_/B _1921_/B2 VGND VGND VPWR VPWR _1761_/B
+ sky130_fd_sc_hd__a32o_2
X_1691_ _1663_/X _1737_/A _1736_/A _1736_/B _1735_/A VGND VGND VPWR VPWR _1691_/X
+ sky130_fd_sc_hd__a2111o_2
XFILLER_32_3 VGND VGND VPWR VPWR sky130_fd_sc_hd__fill_2
Xhold519 _2605_/B VGND VGND VPWR VPWR hold519/X sky130_fd_sc_hd__clkbuf_2
X_2312_ _2312_/A _2312_/B VGND VGND VPWR VPWR _2316_/A sky130_fd_sc_hd__nand2_2
X_2243_ _2274_/A _2274_/B VGND VGND VPWR VPWR _2260_/A sky130_fd_sc_hd__xnor2_2
X_2174_ _2206_/A _2174_/B VGND VGND VPWR VPWR _2195_/B sky130_fd_sc_hd__nor2_2
X_1958_ _1958_/A _1958_/B VGND VGND VPWR VPWR _1958_/X sky130_fd_sc_hd__and2_2
X_1889_ _1889_/A _1889_/B VGND VGND VPWR VPWR _1904_/B sky130_fd_sc_hd__xor2_2
XFILLER_56_47 VGND VGND VPWR VPWR sky130_fd_sc_hd__decap_3
XFILLER_24_172 VGND VGND VPWR VPWR sky130_fd_sc_hd__decap_3
XFILLER_31_109 VGND VGND VPWR VPWR sky130_fd_sc_hd__decap_3
XFILLER_56_242 VGND VGND VPWR VPWR sky130_fd_sc_hd__decap_3
XFILLER_56_253 VGND VGND VPWR VPWR sky130_fd_sc_hd__decap_3
XFILLER_56_69 VGND VGND VPWR VPWR sky130_fd_sc_hd__fill_2
XTAP_TAPCELL_ROW_54_432 VGND VPWR sky130_fd_sc_hd__tapvpwrvgnd_1
XFILLER_24_194 VGND VGND VPWR VPWR sky130_fd_sc_hd__fill_2
XFILLER_39_209 VGND VGND VPWR VPWR sky130_fd_sc_hd__fill_1
XFILLER_15_172 VGND VGND VPWR VPWR sky130_fd_sc_hd__decap_3
XFILLER_30_153 VGND VGND VPWR VPWR sky130_fd_sc_hd__fill_1
XFILLER_46_91 VGND VGND VPWR VPWR sky130_fd_sc_hd__decap_3
XFILLER_62_256 VGND VGND VPWR VPWR sky130_fd_sc_hd__decap_3
XTAP_TAPCELL_ROW_60_468 VGND VPWR sky130_fd_sc_hd__tapvpwrvgnd_1
XFILLER_30_175 VGND VGND VPWR VPWR sky130_fd_sc_hd__decap_3
X_1812_ _1861_/A _1812_/B VGND VGND VPWR VPWR _1813_/B sky130_fd_sc_hd__and2_2
X_1743_ _1506_/Y _1546_/X _1740_/Y _1741_/Y VGND VGND VPWR VPWR _1743_/X sky130_fd_sc_hd__o2bb2a_2
X_1674_ _1700_/B1 _1379_/X _1702_/A3 _1702_/B1 _2625_/Q VGND VGND VPWR VPWR _1675_/B
+ sky130_fd_sc_hd__a32o_2
X_2226_ _2226_/A _2226_/B VGND VGND VPWR VPWR _2227_/D sky130_fd_sc_hd__or2_2
XFILLER_38_242 VGND VGND VPWR VPWR sky130_fd_sc_hd__decap_3
XFILLER_38_253 VGND VGND VPWR VPWR sky130_fd_sc_hd__decap_3
XFILLER_53_234 VGND VGND VPWR VPWR sky130_fd_sc_hd__decap_3
XFILLER_53_278 VGND VGND VPWR VPWR sky130_fd_sc_hd__fill_2
X_2157_ _2259_/A _2679_/Q _2155_/Y _2156_/X VGND VGND VPWR VPWR _2158_/B sky130_fd_sc_hd__o2bb2a_2
X_2088_ _2088_/A _2088_/B VGND VGND VPWR VPWR _2176_/A sky130_fd_sc_hd__xor2_2
XFILLER_42_27 VGND VGND VPWR VPWR sky130_fd_sc_hd__fill_1
XFILLER_42_38 VGND VGND VPWR VPWR sky130_fd_sc_hd__fill_1
XFILLER_29_220 VGND VGND VPWR VPWR sky130_fd_sc_hd__decap_3
XTAP_TAPCELL_ROW_8_179 VGND VPWR sky130_fd_sc_hd__tapvpwrvgnd_1
XFILLER_44_245 VGND VGND VPWR VPWR sky130_fd_sc_hd__decap_3
XFILLER_12_197 VGND VGND VPWR VPWR sky130_fd_sc_hd__decap_3
X_1390_ _1390_/A _1390_/B VGND VGND VPWR VPWR _1390_/X sky130_fd_sc_hd__and2_4
XFILLER_35_212 VGND VGND VPWR VPWR sky130_fd_sc_hd__fill_2
XFILLER_35_256 VGND VGND VPWR VPWR sky130_fd_sc_hd__decap_3
X_2011_ _2054_/A _2054_/B VGND VGND VPWR VPWR _2012_/B sky130_fd_sc_hd__xor2_2
XFILLER_50_248 VGND VGND VPWR VPWR sky130_fd_sc_hd__decap_3
X_1588_ _1588_/A _1588_/B VGND VGND VPWR VPWR _1798_/B sky130_fd_sc_hd__xnor2_2
X_1657_ _1657_/A _1657_/B VGND VGND VPWR VPWR _1685_/A sky130_fd_sc_hd__xor2_2
X_1726_ _1726_/A _1726_/B VGND VGND VPWR VPWR _1726_/Y sky130_fd_sc_hd__nand2_2
XFILLER_58_304 VGND VGND VPWR VPWR sky130_fd_sc_hd__decap_3
XFILLER_58_315 VGND VGND VPWR VPWR sky130_fd_sc_hd__decap_3
X_2209_ _2210_/A _2210_/B VGND VGND VPWR VPWR _2211_/A sky130_fd_sc_hd__nor2_2
XFILLER_26_223 VGND VGND VPWR VPWR sky130_fd_sc_hd__decap_3
XFILLER_26_289 VGND VGND VPWR VPWR sky130_fd_sc_hd__decap_3
XFILLER_41_237 VGND VGND VPWR VPWR sky130_fd_sc_hd__fill_1
XFILLER_17_234 VGND VGND VPWR VPWR sky130_fd_sc_hd__decap_3
XFILLER_17_278 VGND VGND VPWR VPWR sky130_fd_sc_hd__fill_2
XFILLER_27_82 VGND VGND VPWR VPWR sky130_fd_sc_hd__decap_3
XTAP_TAPCELL_ROW_4_160 VGND VPWR sky130_fd_sc_hd__tapvpwrvgnd_1
XTAP_TAPCELL_ROW_27_284 VGND VPWR sky130_fd_sc_hd__tapvpwrvgnd_1
XFILLER_64_6 VGND VGND VPWR VPWR sky130_fd_sc_hd__decap_3
XTAP_TAPCELL_ROW_10_195 VGND VPWR sky130_fd_sc_hd__tapvpwrvgnd_1
X_1442_ _1604_/A _1442_/B VGND VGND VPWR VPWR _1511_/B sky130_fd_sc_hd__xor2_2
X_1511_ _1511_/A _1511_/B VGND VGND VPWR VPWR _1511_/X sky130_fd_sc_hd__and2_2
X_2560_ _2592_/A1 hold631/X _2572_/C1 _2559_/X VGND VGND VPWR VPWR _2560_/X sky130_fd_sc_hd__o211a_2
X_2491_ _2491_/A _2491_/B VGND VGND VPWR VPWR _2492_/B sky130_fd_sc_hd__xnor2_2
XFILLER_55_318 VGND VGND VPWR VPWR sky130_fd_sc_hd__fill_2
X_1373_ hold592/X _1948_/A _2591_/A _1372_/Y VGND VGND VPWR VPWR _1373_/X sky130_fd_sc_hd__o2bb2a_2
XFILLER_23_215 VGND VGND VPWR VPWR sky130_fd_sc_hd__decap_3
XFILLER_31_281 VGND VGND VPWR VPWR sky130_fd_sc_hd__decap_3
XFILLER_48_26 VGND VGND VPWR VPWR sky130_fd_sc_hd__fill_2
XPHY_EDGE_ROW_18_Left_83 VGND VGND VPWR VPWR sky130_fd_sc_hd__decap_3
X_2689_ _2689_/CLK _2689_/D VGND VGND VPWR VPWR _2689_/Q sky130_fd_sc_hd__dfxtp_2
X_1709_ _2622_/Q _1709_/B VGND VGND VPWR VPWR _1712_/A sky130_fd_sc_hd__nand2_2
XFILLER_58_134 VGND VGND VPWR VPWR sky130_fd_sc_hd__fill_1
XFILLER_64_47 VGND VGND VPWR VPWR sky130_fd_sc_hd__decap_3
XTAP_TAPCELL_ROW_1_141 VGND VPWR sky130_fd_sc_hd__tapvpwrvgnd_1
XPHY_EDGE_ROW_54_Left_119 VGND VGND VPWR VPWR sky130_fd_sc_hd__decap_3
XFILLER_1_196 VGND VGND VPWR VPWR sky130_fd_sc_hd__fill_1
XFILLER_38_70 VGND VGND VPWR VPWR sky130_fd_sc_hd__decap_3
XFILLER_49_167 VGND VGND VPWR VPWR sky130_fd_sc_hd__fill_1
XPHY_EDGE_ROW_63_Left_128 VGND VGND VPWR VPWR sky130_fd_sc_hd__decap_3
XFILLER_64_137 VGND VGND VPWR VPWR sky130_fd_sc_hd__decap_3
XFILLER_64_159 VGND VGND VPWR VPWR sky130_fd_sc_hd__decap_3
XTAP_TAPCELL_ROW_15_221 VGND VPWR sky130_fd_sc_hd__tapvpwrvgnd_1
XFILLER_13_292 VGND VGND VPWR VPWR sky130_fd_sc_hd__decap_3
XFILLER_62_3 VGND VGND VPWR VPWR sky130_fd_sc_hd__fill_2
XFILLER_9_263 VGND VGND VPWR VPWR sky130_fd_sc_hd__decap_3
Xclkload11 _2702_/CLK VGND VGND VPWR VPWR clkload11/X sky130_fd_sc_hd__clkbuf_4
X_2612_ _2621_/A _2614_/B VGND VGND VPWR VPWR _2612_/Y sky130_fd_sc_hd__nand2_2
X_1991_ _1991_/A _1999_/A VGND VGND VPWR VPWR _1998_/B sky130_fd_sc_hd__xnor2_2
X_2543_ _2579_/A _2626_/Q VGND VGND VPWR VPWR _2543_/X sky130_fd_sc_hd__or2_2
X_2474_ _2478_/B _2473_/Y _2492_/A VGND VGND VPWR VPWR _2474_/Y sky130_fd_sc_hd__o21bai_2
XFILLER_18_29 VGND VGND VPWR VPWR sky130_fd_sc_hd__fill_2
XFILLER_55_137 VGND VGND VPWR VPWR sky130_fd_sc_hd__decap_3
XTAP_TAPCELL_ROW_38_346 VGND VPWR sky130_fd_sc_hd__tapvpwrvgnd_1
X_1356_ _2663_/Q _2618_/B _1355_/X _1356_/C1 VGND VGND VPWR VPWR _1356_/X sky130_fd_sc_hd__o211a_2
XFILLER_51_310 VGND VGND VPWR VPWR sky130_fd_sc_hd__decap_3
XFILLER_63_181 VGND VGND VPWR VPWR sky130_fd_sc_hd__fill_1
XTAP_TAPCELL_ROW_46_390 VGND VPWR sky130_fd_sc_hd__tapvpwrvgnd_1
Xclkload5 clkload5/A VGND VGND VPWR VPWR clkload5/X sky130_fd_sc_hd__clkbuf_4
XFILLER_59_36 VGND VGND VPWR VPWR sky130_fd_sc_hd__decap_3
XPHY_EDGE_ROW_3_Left_68 VGND VGND VPWR VPWR sky130_fd_sc_hd__decap_3
XFILLER_46_137 VGND VGND VPWR VPWR sky130_fd_sc_hd__decap_3
XFILLER_54_181 VGND VGND VPWR VPWR sky130_fd_sc_hd__fill_1
XFILLER_10_240 VGND VGND VPWR VPWR sky130_fd_sc_hd__decap_3
XFILLER_10_251 VGND VGND VPWR VPWR sky130_fd_sc_hd__fill_1
XFILLER_24_94 VGND VGND VPWR VPWR sky130_fd_sc_hd__decap_3
XFILLER_6_200 VGND VGND VPWR VPWR sky130_fd_sc_hd__decap_3
XTAP_TAPCELL_ROW_12_202 VGND VPWR sky130_fd_sc_hd__tapvpwrvgnd_1
XFILLER_40_82 VGND VGND VPWR VPWR sky130_fd_sc_hd__fill_2
X_2190_ _2225_/B _2188_/Y hold602/X VGND VGND VPWR VPWR _2190_/X sky130_fd_sc_hd__a21o_2
XFILLER_45_181 VGND VGND VPWR VPWR sky130_fd_sc_hd__decap_3
XFILLER_52_129 VGND VGND VPWR VPWR sky130_fd_sc_hd__decap_3
XFILLER_60_195 VGND VGND VPWR VPWR sky130_fd_sc_hd__fill_1
X_1974_ _2015_/B _1974_/B VGND VGND VPWR VPWR _1979_/A sky130_fd_sc_hd__and2_2
X_2388_ _2689_/Q _2425_/B VGND VGND VPWR VPWR _2426_/B sky130_fd_sc_hd__nor2_2
XFILLER_28_159 VGND VGND VPWR VPWR sky130_fd_sc_hd__decap_3
XFILLER_45_27 VGND VGND VPWR VPWR sky130_fd_sc_hd__decap_3
X_1339_ _2583_/A _1339_/B VGND VGND VPWR VPWR _1339_/Y sky130_fd_sc_hd__nand2_2
XFILLER_51_184 VGND VGND VPWR VPWR sky130_fd_sc_hd__decap_3
XFILLER_61_37 VGND VGND VPWR VPWR sky130_fd_sc_hd__decap_3
XFILLER_3_225 VGND VGND VPWR VPWR sky130_fd_sc_hd__decap_3
XFILLER_59_240 VGND VGND VPWR VPWR sky130_fd_sc_hd__decap_3
XFILLER_59_273 VGND VGND VPWR VPWR sky130_fd_sc_hd__fill_1
XTAP_TAPCELL_ROW_49_408 VGND VPWR sky130_fd_sc_hd__tapvpwrvgnd_1
XTAP_TAPCELL_ROW_57_452 VGND VPWR sky130_fd_sc_hd__tapvpwrvgnd_1
Xoutput390 _2644_/Q VGND VGND VPWR VPWR b_out[6] sky130_fd_sc_hd__buf_2
XFILLER_42_151 VGND VGND VPWR VPWR sky130_fd_sc_hd__decap_3
XFILLER_42_184 VGND VGND VPWR VPWR sky130_fd_sc_hd__decap_3
Xhold509 hold513/X VGND VGND VPWR VPWR _2605_/C sky130_fd_sc_hd__clkbuf_2
X_1690_ _1735_/B _1690_/B VGND VGND VPWR VPWR _1736_/B sky130_fd_sc_hd__nand2_2
XFILLER_25_3 VGND VGND VPWR VPWR sky130_fd_sc_hd__fill_2
X_2311_ _2311_/A _2299_/A VGND VGND VPWR VPWR _2312_/B sky130_fd_sc_hd__or2b_2
X_2242_ _2242_/A _2242_/B VGND VGND VPWR VPWR _2274_/B sky130_fd_sc_hd__xnor2_2
X_2173_ _2196_/B _2173_/B VGND VGND VPWR VPWR _2174_/B sky130_fd_sc_hd__and2_2
X_1957_ _1858_/A _1858_/B _1915_/B _1914_/B _1914_/A VGND VGND VPWR VPWR _1990_/A
+ sky130_fd_sc_hd__a32o_2
XFILLER_0_228 VGND VGND VPWR VPWR sky130_fd_sc_hd__decap_3
X_2509_ _2699_/Q _2524_/A2 _2524_/B1 _2508_/X VGND VGND VPWR VPWR _2510_/B sky130_fd_sc_hd__a22o_2
X_1888_ _1937_/A _1937_/B VGND VGND VPWR VPWR _1889_/B sky130_fd_sc_hd__xnor2_2
XFILLER_56_15 VGND VGND VPWR VPWR sky130_fd_sc_hd__decap_3
XFILLER_56_221 VGND VGND VPWR VPWR sky130_fd_sc_hd__decap_3
XFILLER_56_59 VGND VGND VPWR VPWR sky130_fd_sc_hd__decap_3
XFILLER_56_298 VGND VGND VPWR VPWR sky130_fd_sc_hd__decap_3
XTAP_TAPCELL_ROW_54_433 VGND VPWR sky130_fd_sc_hd__tapvpwrvgnd_1
XFILLER_21_84 VGND VGND VPWR VPWR sky130_fd_sc_hd__fill_1
XFILLER_47_254 VGND VGND VPWR VPWR sky130_fd_sc_hd__decap_3
XFILLER_62_235 VGND VGND VPWR VPWR sky130_fd_sc_hd__decap_3
XPHY_EDGE_ROW_6_Left_71 VGND VGND VPWR VPWR sky130_fd_sc_hd__decap_3
XFILLER_15_162 VGND VGND VPWR VPWR sky130_fd_sc_hd__decap_3
XFILLER_15_184 VGND VGND VPWR VPWR sky130_fd_sc_hd__decap_3
XFILLER_30_132 VGND VGND VPWR VPWR sky130_fd_sc_hd__decap_3
XFILLER_62_268 VGND VGND VPWR VPWR sky130_fd_sc_hd__decap_3
XTAP_TAPCELL_ROW_60_469 VGND VPWR sky130_fd_sc_hd__tapvpwrvgnd_1
X_1811_ _1811_/A _1811_/B VGND VGND VPWR VPWR _1812_/B sky130_fd_sc_hd__or2_2
X_1742_ _1740_/Y _1741_/Y _1622_/Y _1669_/X VGND VGND VPWR VPWR _1742_/X sky130_fd_sc_hd__a22o_2
X_1673_ _1701_/A _1673_/B VGND VGND VPWR VPWR _1679_/A sky130_fd_sc_hd__xnor2_2
X_2225_ _2225_/A _2225_/B _2222_/C VGND VGND VPWR VPWR _2227_/C sky130_fd_sc_hd__or3b_2
XFILLER_53_246 VGND VGND VPWR VPWR sky130_fd_sc_hd__decap_3
XPHY_EDGE_ROW_5_Right_5 VGND VGND VPWR VPWR sky130_fd_sc_hd__decap_3
X_2156_ _2222_/C _2155_/B _2286_/B VGND VGND VPWR VPWR _2156_/X sky130_fd_sc_hd__a21o_2
X_2087_ _2087_/A _2087_/B VGND VGND VPWR VPWR _2088_/B sky130_fd_sc_hd__xnor2_2
XFILLER_21_165 VGND VGND VPWR VPWR sky130_fd_sc_hd__decap_3
XFILLER_61_290 VGND VGND VPWR VPWR sky130_fd_sc_hd__decap_3
XFILLER_29_287 VGND VGND VPWR VPWR sky130_fd_sc_hd__fill_1
XFILLER_44_202 VGND VGND VPWR VPWR sky130_fd_sc_hd__decap_3
XFILLER_12_176 VGND VGND VPWR VPWR sky130_fd_sc_hd__decap_3
XPHY_EDGE_ROW_32_Left_97 VGND VGND VPWR VPWR sky130_fd_sc_hd__decap_3
XFILLER_32_83 VGND VGND VPWR VPWR sky130_fd_sc_hd__fill_1
XFILLER_57_80 VGND VGND VPWR VPWR sky130_fd_sc_hd__decap_3
X_2010_ _2010_/A _2010_/B VGND VGND VPWR VPWR _2054_/B sky130_fd_sc_hd__xnor2_2
X_1725_ _1725_/A _1725_/B _1725_/C VGND VGND VPWR VPWR _1726_/B sky130_fd_sc_hd__and3_2
X_1587_ _1745_/A _1745_/B VGND VGND VPWR VPWR _1588_/B sky130_fd_sc_hd__xor2_2
X_1656_ _1657_/A _1657_/B VGND VGND VPWR VPWR _1689_/B sky130_fd_sc_hd__or2_2
XFILLER_37_28 VGND VGND VPWR VPWR sky130_fd_sc_hd__decap_3
X_2208_ _2233_/A _2233_/B VGND VGND VPWR VPWR _2210_/B sky130_fd_sc_hd__xor2_2
X_2139_ _2139_/A _2139_/B VGND VGND VPWR VPWR _2140_/B sky130_fd_sc_hd__xor2_2
XFILLER_53_16 VGND VGND VPWR VPWR sky130_fd_sc_hd__decap_3
Xhold670 hold670/A VGND VGND VPWR VPWR hold670/X sky130_fd_sc_hd__clkbuf_2
XTAP_TAPCELL_ROW_27_285 VGND VPWR sky130_fd_sc_hd__tapvpwrvgnd_1
XTAP_TAPCELL_ROW_4_161 VGND VPWR sky130_fd_sc_hd__tapvpwrvgnd_1
XFILLER_40_271 VGND VGND VPWR VPWR sky130_fd_sc_hd__decap_3
XFILLER_43_60 VGND VGND VPWR VPWR sky130_fd_sc_hd__decap_3
XFILLER_43_93 VGND VGND VPWR VPWR sky130_fd_sc_hd__decap_3
X_1441_ _1478_/A2 _1603_/A2 _1702_/A3 _1709_/B _2632_/Q VGND VGND VPWR VPWR _1442_/B
+ sky130_fd_sc_hd__a32o_2
X_1510_ _1465_/A _1465_/B _1509_/Y VGND VGND VPWR VPWR _1585_/A sky130_fd_sc_hd__a21oi_2
X_1372_ _2670_/Q VGND VGND VPWR VPWR _1372_/Y sky130_fd_sc_hd__inv_2
XFILLER_23_238 VGND VGND VPWR VPWR sky130_fd_sc_hd__fill_2
XFILLER_31_271 VGND VGND VPWR VPWR sky130_fd_sc_hd__fill_2
X_2688_ _2689_/CLK _2688_/D VGND VGND VPWR VPWR _2707_/A sky130_fd_sc_hd__dfxtp_2
X_1708_ _1708_/A _1708_/B VGND VGND VPWR VPWR _1714_/A sky130_fd_sc_hd__xor2_2
XFILLER_48_38 VGND VGND VPWR VPWR sky130_fd_sc_hd__decap_3
XFILLER_58_124 VGND VGND VPWR VPWR sky130_fd_sc_hd__fill_2
X_1639_ _1639_/A _1639_/B VGND VGND VPWR VPWR _1661_/B sky130_fd_sc_hd__xnor2_2
XFILLER_14_227 VGND VGND VPWR VPWR sky130_fd_sc_hd__decap_3
XFILLER_58_179 VGND VGND VPWR VPWR sky130_fd_sc_hd__decap_3
XFILLER_64_15 VGND VGND VPWR VPWR sky130_fd_sc_hd__decap_3
XTAP_TAPCELL_ROW_1_142 VGND VPWR sky130_fd_sc_hd__tapvpwrvgnd_1
XFILLER_38_82 VGND VGND VPWR VPWR sky130_fd_sc_hd__fill_2
XFILLER_49_124 VGND VGND VPWR VPWR sky130_fd_sc_hd__decap_3
XFILLER_64_116 VGND VGND VPWR VPWR sky130_fd_sc_hd__decap_3
XTAP_TAPCELL_ROW_15_222 VGND VPWR sky130_fd_sc_hd__tapvpwrvgnd_1
X_1990_ _1990_/A _1990_/B VGND VGND VPWR VPWR _1999_/A sky130_fd_sc_hd__xnor2_2
XFILLER_9_231 VGND VGND VPWR VPWR sky130_fd_sc_hd__decap_3
XFILLER_9_275 VGND VGND VPWR VPWR sky130_fd_sc_hd__decap_3
Xclkload12 _2689_/CLK VGND VGND VPWR VPWR clkload12/X sky130_fd_sc_hd__clkbuf_4
X_2611_ _2654_/Q _2610_/A hold541/X _2611_/C1 VGND VGND VPWR VPWR _2611_/X sky130_fd_sc_hd__o211a_2
X_2542_ _2580_/A1 hold635/X _2580_/B1 _2541_/X VGND VGND VPWR VPWR _2542_/X sky130_fd_sc_hd__o211a_2
X_1355_ _1355_/A _1367_/B VGND VGND VPWR VPWR _1355_/X sky130_fd_sc_hd__or2_2
X_1424_ _2666_/Q VGND VGND VPWR VPWR _2274_/A sky130_fd_sc_hd__inv_2
X_2473_ _2472_/B _2472_/C _2472_/A VGND VGND VPWR VPWR _2473_/Y sky130_fd_sc_hd__a21oi_2
XFILLER_18_19 VGND VGND VPWR VPWR sky130_fd_sc_hd__fill_2
XFILLER_55_116 VGND VGND VPWR VPWR sky130_fd_sc_hd__decap_3
XTAP_TAPCELL_ROW_38_347 VGND VPWR sky130_fd_sc_hd__tapvpwrvgnd_1
XFILLER_34_29 VGND VGND VPWR VPWR sky130_fd_sc_hd__decap_3
XTAP_TAPCELL_ROW_46_391 VGND VPWR sky130_fd_sc_hd__tapvpwrvgnd_1
Xclkload6 clkload6/A VGND VGND VPWR VPWR clkload6/X sky130_fd_sc_hd__clkbuf_4
XFILLER_19_319 VGND VGND VPWR VPWR sky130_fd_sc_hd__fill_1
XFILLER_61_119 VGND VGND VPWR VPWR sky130_fd_sc_hd__decap_3
XFILLER_6_256 VGND VGND VPWR VPWR sky130_fd_sc_hd__decap_3
XTAP_TAPCELL_ROW_12_203 VGND VPWR sky130_fd_sc_hd__tapvpwrvgnd_1
XFILLER_41_9 VGND VGND VPWR VPWR sky130_fd_sc_hd__decap_3
XFILLER_37_105 VGND VGND VPWR VPWR sky130_fd_sc_hd__decap_3
XFILLER_45_160 VGND VGND VPWR VPWR sky130_fd_sc_hd__fill_2
XFILLER_52_108 VGND VGND VPWR VPWR sky130_fd_sc_hd__decap_3
XTAP_TAPCELL_ROW_35_328 VGND VPWR sky130_fd_sc_hd__tapvpwrvgnd_1
XFILLER_60_130 VGND VGND VPWR VPWR sky130_fd_sc_hd__decap_3
XFILLER_60_141 VGND VGND VPWR VPWR sky130_fd_sc_hd__decap_3
XTAP_TAPCELL_ROW_43_372 VGND VPWR sky130_fd_sc_hd__tapvpwrvgnd_1
X_1973_ _1973_/A _1973_/B VGND VGND VPWR VPWR _1983_/A sky130_fd_sc_hd__xor2_2
X_2525_ _2525_/A _2525_/B VGND VGND VPWR VPWR _2702_/D sky130_fd_sc_hd__and2_2
X_1407_ _2661_/Q _2660_/Q VGND VGND VPWR VPWR _1407_/X sky130_fd_sc_hd__xor2_2
X_2387_ _2672_/Q _2387_/B VGND VGND VPWR VPWR _2425_/B sky130_fd_sc_hd__xnor2_2
XFILLER_36_160 VGND VGND VPWR VPWR sky130_fd_sc_hd__fill_2
XFILLER_45_39 VGND VGND VPWR VPWR sky130_fd_sc_hd__decap_3
XFILLER_3_237 VGND VGND VPWR VPWR sky130_fd_sc_hd__decap_3
XFILLER_3_259 VGND VGND VPWR VPWR sky130_fd_sc_hd__decap_3
Xoutput380 _2649_/Q VGND VGND VPWR VPWR b_out[11] sky130_fd_sc_hd__buf_2
Xoutput391 _2645_/Q VGND VGND VPWR VPWR b_out[7] sky130_fd_sc_hd__buf_2
XFILLER_19_116 VGND VGND VPWR VPWR sky130_fd_sc_hd__decap_3
XFILLER_34_119 VGND VGND VPWR VPWR sky130_fd_sc_hd__fill_1
XFILLER_59_252 VGND VGND VPWR VPWR sky130_fd_sc_hd__decap_3
XTAP_TAPCELL_ROW_49_409 VGND VPWR sky130_fd_sc_hd__tapvpwrvgnd_1
XTAP_TAPCELL_ROW_57_453 VGND VPWR sky130_fd_sc_hd__tapvpwrvgnd_1
XFILLER_35_94 VGND VGND VPWR VPWR sky130_fd_sc_hd__decap_3
XFILLER_42_163 VGND VGND VPWR VPWR sky130_fd_sc_hd__decap_3
XFILLER_2_281 VGND VGND VPWR VPWR sky130_fd_sc_hd__fill_1
X_2310_ _2310_/A _2310_/B VGND VGND VPWR VPWR _2317_/A sky130_fd_sc_hd__nand2_2
X_2241_ _2241_/A _2241_/B VGND VGND VPWR VPWR _2242_/B sky130_fd_sc_hd__nor2_2
X_2172_ _2196_/B _2173_/B VGND VGND VPWR VPWR _2206_/A sky130_fd_sc_hd__nor2_2
XFILLER_18_182 VGND VGND VPWR VPWR sky130_fd_sc_hd__decap_3
XFILLER_21_303 VGND VGND VPWR VPWR sky130_fd_sc_hd__decap_3
X_1956_ _1940_/A _1940_/B _1955_/X VGND VGND VPWR VPWR _1991_/A sky130_fd_sc_hd__a21o_2
X_1887_ _1834_/A _1834_/B _1886_/X VGND VGND VPWR VPWR _1937_/B sky130_fd_sc_hd__a21oi_2
X_2508_ _2523_/B _2439_/A VGND VGND VPWR VPWR _2508_/X sky130_fd_sc_hd__or2b_2
XFILLER_56_200 VGND VGND VPWR VPWR sky130_fd_sc_hd__decap_3
XFILLER_56_288 VGND VGND VPWR VPWR sky130_fd_sc_hd__decap_3
XFILLER_56_38 VGND VGND VPWR VPWR sky130_fd_sc_hd__decap_3
X_2439_ _2439_/A _2439_/B _2439_/C _2439_/D VGND VGND VPWR VPWR _2439_/Y sky130_fd_sc_hd__nand4_2
XFILLER_12_303 VGND VGND VPWR VPWR sky130_fd_sc_hd__decap_3
XFILLER_24_141 VGND VGND VPWR VPWR sky130_fd_sc_hd__fill_1
XFILLER_24_152 VGND VGND VPWR VPWR sky130_fd_sc_hd__fill_1
XTAP_TAPCELL_ROW_54_434 VGND VPWR sky130_fd_sc_hd__tapvpwrvgnd_1
XFILLER_21_30 VGND VGND VPWR VPWR sky130_fd_sc_hd__fill_1
XFILLER_47_200 VGND VGND VPWR VPWR sky130_fd_sc_hd__decap_3
XFILLER_46_82 VGND VGND VPWR VPWR sky130_fd_sc_hd__fill_2
XFILLER_47_233 VGND VGND VPWR VPWR sky130_fd_sc_hd__decap_3
XFILLER_47_266 VGND VGND VPWR VPWR sky130_fd_sc_hd__fill_1
XFILLER_62_247 VGND VGND VPWR VPWR sky130_fd_sc_hd__decap_3
XFILLER_30_144 VGND VGND VPWR VPWR sky130_fd_sc_hd__decap_3
XFILLER_62_92 VGND VGND VPWR VPWR sky130_fd_sc_hd__fill_1
X_1810_ _1811_/A _1811_/B VGND VGND VPWR VPWR _1861_/A sky130_fd_sc_hd__nand2_2
X_1741_ _1741_/A _1741_/B VGND VGND VPWR VPWR _1741_/Y sky130_fd_sc_hd__xnor2_2
X_1672_ _1700_/A1 _2627_/Q _2626_/Q _1700_/B2 VGND VGND VPWR VPWR _1673_/B sky130_fd_sc_hd__a22o_2
XFILLER_38_200 VGND VGND VPWR VPWR sky130_fd_sc_hd__decap_3
XFILLER_53_203 VGND VGND VPWR VPWR sky130_fd_sc_hd__fill_1
XFILLER_53_214 VGND VGND VPWR VPWR sky130_fd_sc_hd__decap_3
X_2224_ _1900_/B _2071_/Y _2222_/Y _2223_/X VGND VGND VPWR VPWR _2227_/B sky130_fd_sc_hd__o31a_2
X_2155_ _2222_/C _2155_/B VGND VGND VPWR VPWR _2155_/Y sky130_fd_sc_hd__nor2_2
XFILLER_53_225 VGND VGND VPWR VPWR sky130_fd_sc_hd__decap_3
XFILLER_53_258 VGND VGND VPWR VPWR sky130_fd_sc_hd__decap_3
X_2086_ _2265_/B2 _2086_/A2 _1430_/Y _2557_/B VGND VGND VPWR VPWR _2087_/B sky130_fd_sc_hd__a22o_2
XFILLER_21_155 VGND VGND VPWR VPWR sky130_fd_sc_hd__fill_1
X_1939_ _1955_/A _1955_/B VGND VGND VPWR VPWR _1940_/B sky130_fd_sc_hd__xor2_2
XFILLER_29_255 VGND VGND VPWR VPWR sky130_fd_sc_hd__fill_1
XPHY_EDGE_ROW_11_Right_11 VGND VGND VPWR VPWR sky130_fd_sc_hd__decap_3
XPHY_EDGE_ROW_20_Right_20 VGND VGND VPWR VPWR sky130_fd_sc_hd__decap_3
XFILLER_35_247 VGND VGND VPWR VPWR sky130_fd_sc_hd__decap_3
XFILLER_35_269 VGND VGND VPWR VPWR sky130_fd_sc_hd__decap_3
X_1724_ _1724_/A _1726_/A _1724_/C _1724_/D VGND VGND VPWR VPWR _1724_/Y sky130_fd_sc_hd__nand4_2
X_1586_ _1544_/A _1544_/B _1585_/Y VGND VGND VPWR VPWR _1745_/B sky130_fd_sc_hd__a21o_2
X_1655_ _1655_/A _1655_/B VGND VGND VPWR VPWR _1657_/B sky130_fd_sc_hd__xnor2_2
XFILLER_26_214 VGND VGND VPWR VPWR sky130_fd_sc_hd__decap_3
X_2207_ _2207_/A _2207_/B VGND VGND VPWR VPWR _2233_/B sky130_fd_sc_hd__xnor2_2
X_2138_ _2138_/A _2138_/B VGND VGND VPWR VPWR _2139_/B sky130_fd_sc_hd__xor2_2
X_2069_ _2069_/A _2113_/B VGND VGND VPWR VPWR _2222_/A sky130_fd_sc_hd__xnor2_2
XFILLER_41_228 VGND VGND VPWR VPWR sky130_fd_sc_hd__decap_3
XFILLER_53_28 VGND VGND VPWR VPWR sky130_fd_sc_hd__decap_3
Xhold660 a_in[9] VGND VGND VPWR VPWR hold660/X sky130_fd_sc_hd__clkbuf_2
Xhold671 _2566_/D VGND VGND VPWR VPWR hold671/X sky130_fd_sc_hd__clkbuf_2
XTAP_TAPCELL_ROW_4_162 VGND VPWR sky130_fd_sc_hd__tapvpwrvgnd_1
XFILLER_17_225 VGND VGND VPWR VPWR sky130_fd_sc_hd__decap_3
XFILLER_17_258 VGND VGND VPWR VPWR sky130_fd_sc_hd__decap_3
XFILLER_27_95 VGND VGND VPWR VPWR sky130_fd_sc_hd__fill_2
XFILLER_32_239 VGND VGND VPWR VPWR sky130_fd_sc_hd__decap_3
XTAP_TAPCELL_ROW_27_286 VGND VPWR sky130_fd_sc_hd__tapvpwrvgnd_1
XFILLER_40_250 VGND VGND VPWR VPWR sky130_fd_sc_hd__fill_2
XFILLER_40_283 VGND VGND VPWR VPWR sky130_fd_sc_hd__decap_3
X_1440_ _1601_/A _1440_/B VGND VGND VPWR VPWR _1511_/A sky130_fd_sc_hd__xnor2_2
XFILLER_31_250 VGND VGND VPWR VPWR sky130_fd_sc_hd__decap_3
X_1638_ _1640_/A _1640_/B VGND VGND VPWR VPWR _1661_/A sky130_fd_sc_hd__xor2_2
X_2687_ _2696_/CLK _2687_/D VGND VGND VPWR VPWR _2687_/Q sky130_fd_sc_hd__dfxtp_2
X_1707_ _1707_/A _1707_/B VGND VGND VPWR VPWR _1726_/A sky130_fd_sc_hd__xnor2_2
XFILLER_48_17 VGND VGND VPWR VPWR sky130_fd_sc_hd__decap_3
X_1569_ _2655_/Q _1976_/D _1926_/A1 _1768_/C VGND VGND VPWR VPWR _1570_/B sky130_fd_sc_hd__a22o_2
XFILLER_14_206 VGND VGND VPWR VPWR sky130_fd_sc_hd__fill_1
XFILLER_14_239 VGND VGND VPWR VPWR sky130_fd_sc_hd__decap_3
XFILLER_64_27 VGND VGND VPWR VPWR sky130_fd_sc_hd__fill_1
XFILLER_64_38 VGND VGND VPWR VPWR sky130_fd_sc_hd__decap_3
XTAP_TAPCELL_ROW_1_143 VGND VPWR sky130_fd_sc_hd__tapvpwrvgnd_1
XFILLER_13_20 VGND VGND VPWR VPWR sky130_fd_sc_hd__fill_1
XFILLER_22_250 VGND VGND VPWR VPWR sky130_fd_sc_hd__fill_2
XTAP_TAPCELL_ROW_24_267 VGND VPWR sky130_fd_sc_hd__tapvpwrvgnd_1
Xhold490 hold502/X VGND VGND VPWR VPWR _2605_/D sky130_fd_sc_hd__clkbuf_2
XFILLER_38_94 VGND VGND VPWR VPWR sky130_fd_sc_hd__decap_3
XFILLER_64_128 VGND VGND VPWR VPWR sky130_fd_sc_hd__decap_3
XFILLER_13_272 VGND VGND VPWR VPWR sky130_fd_sc_hd__decap_3
XFILLER_60_312 VGND VGND VPWR VPWR sky130_fd_sc_hd__decap_3
XFILLER_9_287 VGND VGND VPWR VPWR sky130_fd_sc_hd__fill_1
Xclkload13 _2692_/CLK VGND VGND VPWR VPWR clkload13/X sky130_fd_sc_hd__clkbuf_4
X_2610_ _2610_/A _2610_/B VGND VGND VPWR VPWR _2610_/Y sky130_fd_sc_hd__nand2_2
X_2541_ _2575_/A _2625_/Q VGND VGND VPWR VPWR _2541_/X sky130_fd_sc_hd__or2_2
X_2472_ _2472_/A _2472_/B _2472_/C VGND VGND VPWR VPWR _2478_/B sky130_fd_sc_hd__and3_2
XFILLER_28_309 VGND VGND VPWR VPWR sky130_fd_sc_hd__decap_3
X_1354_ _2662_/Q _2618_/B hold584/X _1356_/C1 VGND VGND VPWR VPWR _1354_/X sky130_fd_sc_hd__o211a_2
X_1423_ _1471_/A _1471_/B VGND VGND VPWR VPWR _1434_/A sky130_fd_sc_hd__xor2_2
XFILLER_51_301 VGND VGND VPWR VPWR sky130_fd_sc_hd__decap_3
XFILLER_55_128 VGND VGND VPWR VPWR sky130_fd_sc_hd__decap_3
XFILLER_63_172 VGND VGND VPWR VPWR sky130_fd_sc_hd__decap_3
XTAP_TAPCELL_ROW_38_348 VGND VPWR sky130_fd_sc_hd__tapvpwrvgnd_1
XTAP_TAPCELL_ROW_46_392 VGND VPWR sky130_fd_sc_hd__tapvpwrvgnd_1
XFILLER_50_29 VGND VGND VPWR VPWR sky130_fd_sc_hd__decap_3
Xclkload7 clkload7/A VGND VGND VPWR VPWR clkload7/X sky130_fd_sc_hd__clkbuf_4
XFILLER_46_106 VGND VGND VPWR VPWR sky130_fd_sc_hd__decap_3
XFILLER_46_128 VGND VGND VPWR VPWR sky130_fd_sc_hd__decap_3
XFILLER_24_85 VGND VGND VPWR VPWR sky130_fd_sc_hd__decap_3
XFILLER_61_109 VGND VGND VPWR VPWR sky130_fd_sc_hd__decap_3
XTAP_TAPCELL_ROW_12_204 VGND VPWR sky130_fd_sc_hd__tapvpwrvgnd_1
XFILLER_45_172 VGND VGND VPWR VPWR sky130_fd_sc_hd__fill_2
XFILLER_45_194 VGND VGND VPWR VPWR sky130_fd_sc_hd__fill_1
XTAP_TAPCELL_ROW_35_329 VGND VPWR sky130_fd_sc_hd__tapvpwrvgnd_1
XFILLER_60_197 VGND VGND VPWR VPWR sky130_fd_sc_hd__decap_3
XTAP_TAPCELL_ROW_43_373 VGND VPWR sky130_fd_sc_hd__tapvpwrvgnd_1
X_1972_ _2023_/A _1972_/B VGND VGND VPWR VPWR _1973_/B sky130_fd_sc_hd__xnor2_2
XFILLER_5_290 VGND VGND VPWR VPWR sky130_fd_sc_hd__decap_3
XPHY_EDGE_ROW_49_Right_49 VGND VGND VPWR VPWR sky130_fd_sc_hd__decap_3
X_2524_ _2702_/Q _2524_/A2 _2524_/B1 _2523_/X VGND VGND VPWR VPWR _2525_/B sky130_fd_sc_hd__a22o_2
X_2455_ _2528_/A _2455_/B VGND VGND VPWR VPWR _2689_/D sky130_fd_sc_hd__and2_2
XFILLER_28_139 VGND VGND VPWR VPWR sky130_fd_sc_hd__fill_1
XFILLER_45_18 VGND VGND VPWR VPWR sky130_fd_sc_hd__decap_3
XPHY_EDGE_ROW_58_Right_58 VGND VGND VPWR VPWR sky130_fd_sc_hd__decap_3
X_1406_ _1435_/A _1435_/B VGND VGND VPWR VPWR _1499_/A sky130_fd_sc_hd__xor2_2
X_2386_ _2686_/Q _2671_/Q VGND VGND VPWR VPWR _2387_/B sky130_fd_sc_hd__and2b_2
XFILLER_24_312 VGND VGND VPWR VPWR sky130_fd_sc_hd__decap_3
XFILLER_36_150 VGND VGND VPWR VPWR sky130_fd_sc_hd__decap_3
XFILLER_51_164 VGND VGND VPWR VPWR sky130_fd_sc_hd__decap_3
XFILLER_51_175 VGND VGND VPWR VPWR sky130_fd_sc_hd__decap_3
XFILLER_10_21 VGND VGND VPWR VPWR sky130_fd_sc_hd__fill_2
Xoutput370 _1310_/Y VGND VGND VPWR VPWR acc_out[2] sky130_fd_sc_hd__buf_2
Xoutput381 _2650_/Q VGND VGND VPWR VPWR b_out[12] sky130_fd_sc_hd__buf_2
Xoutput392 _2646_/Q VGND VGND VPWR VPWR b_out[8] sky130_fd_sc_hd__buf_2
XFILLER_19_139 VGND VGND VPWR VPWR sky130_fd_sc_hd__decap_3
XFILLER_42_175 VGND VGND VPWR VPWR sky130_fd_sc_hd__decap_3
XFILLER_42_197 VGND VGND VPWR VPWR sky130_fd_sc_hd__decap_3
X_2240_ _2240_/A _2240_/B VGND VGND VPWR VPWR _2241_/B sky130_fd_sc_hd__nor2_2
X_2171_ _2274_/A _2171_/B VGND VGND VPWR VPWR _2173_/B sky130_fd_sc_hd__xnor2_2
XFILLER_18_194 VGND VGND VPWR VPWR sky130_fd_sc_hd__fill_2
XFILLER_25_109 VGND VGND VPWR VPWR sky130_fd_sc_hd__decap_3
XFILLER_33_142 VGND VGND VPWR VPWR sky130_fd_sc_hd__decap_3
XFILLER_33_164 VGND VGND VPWR VPWR sky130_fd_sc_hd__decap_3
XFILLER_33_197 VGND VGND VPWR VPWR sky130_fd_sc_hd__decap_3
XTAP_TAPCELL_ROW_31_310 VGND VPWR sky130_fd_sc_hd__tapvpwrvgnd_1
X_1955_ _1955_/A _1955_/B VGND VGND VPWR VPWR _1955_/X sky130_fd_sc_hd__and2_2
X_1886_ _1833_/B _1886_/B VGND VGND VPWR VPWR _1886_/X sky130_fd_sc_hd__and2b_2
X_2438_ _2438_/A _2438_/B VGND VGND VPWR VPWR _2439_/D sky130_fd_sc_hd__or2_2
XFILLER_56_212 VGND VGND VPWR VPWR sky130_fd_sc_hd__decap_3
XFILLER_56_234 VGND VGND VPWR VPWR sky130_fd_sc_hd__fill_1
XFILLER_56_245 VGND VGND VPWR VPWR sky130_fd_sc_hd__fill_1
XFILLER_56_256 VGND VGND VPWR VPWR sky130_fd_sc_hd__decap_3
XTAP_TAPCELL_ROW_54_435 VGND VPWR sky130_fd_sc_hd__tapvpwrvgnd_1
X_2369_ _2677_/Q _2369_/B VGND VGND VPWR VPWR _2370_/B sky130_fd_sc_hd__xnor2_2
XFILLER_24_197 VGND VGND VPWR VPWR sky130_fd_sc_hd__decap_3
XFILLER_47_212 VGND VGND VPWR VPWR sky130_fd_sc_hd__fill_2
XFILLER_15_175 VGND VGND VPWR VPWR sky130_fd_sc_hd__decap_3
XFILLER_46_94 VGND VGND VPWR VPWR sky130_fd_sc_hd__decap_3
XFILLER_62_259 VGND VGND VPWR VPWR sky130_fd_sc_hd__decap_3
XFILLER_62_82 VGND VGND VPWR VPWR sky130_fd_sc_hd__fill_2
X_1740_ _1622_/A _1622_/B _1739_/X VGND VGND VPWR VPWR _1740_/Y sky130_fd_sc_hd__a21oi_2
X_1671_ _1671_/A _1707_/A VGND VGND VPWR VPWR _1733_/A sky130_fd_sc_hd__and2_2
XFILLER_38_212 VGND VGND VPWR VPWR sky130_fd_sc_hd__decap_3
XFILLER_38_245 VGND VGND VPWR VPWR sky130_fd_sc_hd__decap_3
XFILLER_38_256 VGND VGND VPWR VPWR sky130_fd_sc_hd__fill_1
XFILLER_53_237 VGND VGND VPWR VPWR sky130_fd_sc_hd__decap_3
X_2223_ _2072_/X _2074_/Y _2222_/Y VGND VGND VPWR VPWR _2223_/X sky130_fd_sc_hd__a21o_2
X_2154_ _2222_/A _2076_/B _2222_/B _2153_/Y VGND VGND VPWR VPWR _2155_/B sky130_fd_sc_hd__a31o_2
X_2085_ _2132_/A _2132_/B VGND VGND VPWR VPWR _2088_/A sky130_fd_sc_hd__xor2_2
XFILLER_21_101 VGND VGND VPWR VPWR sky130_fd_sc_hd__decap_3
XFILLER_61_281 VGND VGND VPWR VPWR sky130_fd_sc_hd__decap_3
XTAP_TAPCELL_ROW_51_416 VGND VPWR sky130_fd_sc_hd__tapvpwrvgnd_1
X_1938_ _1889_/A _1889_/B _1937_/X VGND VGND VPWR VPWR _1955_/B sky130_fd_sc_hd__o21ai_2
X_1869_ _1921_/B2 _1494_/B _1921_/B1 _2057_/B2 VGND VGND VPWR VPWR _1870_/B sky130_fd_sc_hd__a22o_2
XFILLER_29_223 VGND VGND VPWR VPWR sky130_fd_sc_hd__fill_1
XFILLER_44_248 VGND VGND VPWR VPWR sky130_fd_sc_hd__decap_3
XFILLER_32_85 VGND VGND VPWR VPWR sky130_fd_sc_hd__decap_3
XFILLER_57_60 VGND VGND VPWR VPWR sky130_fd_sc_hd__decap_3
XFILLER_35_259 VGND VGND VPWR VPWR sky130_fd_sc_hd__fill_1
XFILLER_43_270 VGND VGND VPWR VPWR sky130_fd_sc_hd__decap_3
XFILLER_43_281 VGND VGND VPWR VPWR sky130_fd_sc_hd__decap_3
X_1654_ _1681_/A _1681_/B _1653_/X VGND VGND VPWR VPWR _1657_/A sky130_fd_sc_hd__a21oi_2
X_1723_ _1723_/A _1723_/B VGND VGND VPWR VPWR _1724_/D sky130_fd_sc_hd__or2_2
XFILLER_58_307 VGND VGND VPWR VPWR sky130_fd_sc_hd__fill_1
XFILLER_58_318 VGND VGND VPWR VPWR sky130_fd_sc_hd__fill_2
X_1585_ _1585_/A _1585_/B VGND VGND VPWR VPWR _1585_/Y sky130_fd_sc_hd__nor2_2
X_2206_ _2206_/A _2245_/B VGND VGND VPWR VPWR _2207_/B sky130_fd_sc_hd__xnor2_2
XFILLER_26_226 VGND VGND VPWR VPWR sky130_fd_sc_hd__fill_2
X_2137_ _2162_/A _2162_/B VGND VGND VPWR VPWR _2138_/B sky130_fd_sc_hd__xor2_2
X_2068_ _2082_/B _2068_/B VGND VGND VPWR VPWR _2113_/B sky130_fd_sc_hd__xnor2_2
Xhold650 hold650/A VGND VGND VPWR VPWR hold650/X sky130_fd_sc_hd__clkbuf_2
Xhold661 hold661/A VGND VGND VPWR VPWR hold661/X sky130_fd_sc_hd__clkbuf_2
Xhold672 a_in[15] VGND VGND VPWR VPWR hold672/X sky130_fd_sc_hd__clkbuf_2
XFILLER_17_237 VGND VGND VPWR VPWR sky130_fd_sc_hd__fill_2
XFILLER_25_281 VGND VGND VPWR VPWR sky130_fd_sc_hd__decap_3
XFILLER_27_85 VGND VGND VPWR VPWR sky130_fd_sc_hd__fill_1
XFILLER_43_40 VGND VGND VPWR VPWR sky130_fd_sc_hd__fill_2
XTAP_TAPCELL_ROW_27_287 VGND VPWR sky130_fd_sc_hd__tapvpwrvgnd_1
XFILLER_4_130 VGND VGND VPWR VPWR sky130_fd_sc_hd__fill_2
XFILLER_4_141 VGND VGND VPWR VPWR sky130_fd_sc_hd__fill_2
XFILLER_64_9 VGND VGND VPWR VPWR sky130_fd_sc_hd__decap_3
X_1370_ _1792_/A _1792_/B VGND VGND VPWR VPWR _1370_/Y sky130_fd_sc_hd__nor2_2
XFILLER_16_270 VGND VGND VPWR VPWR sky130_fd_sc_hd__decap_3
XFILLER_31_284 VGND VGND VPWR VPWR sky130_fd_sc_hd__decap_3
X_1637_ _1637_/A _1637_/B VGND VGND VPWR VPWR _1640_/B sky130_fd_sc_hd__xnor2_2
X_2686_ clkload9/A _2686_/D VGND VGND VPWR VPWR _2686_/Q sky130_fd_sc_hd__dfxtp_2
X_1706_ _1706_/A _1706_/B VGND VGND VPWR VPWR _1724_/A sky130_fd_sc_hd__xor2_2
XFILLER_48_29 VGND VGND VPWR VPWR sky130_fd_sc_hd__decap_3
XFILLER_58_115 VGND VGND VPWR VPWR sky130_fd_sc_hd__decap_3
X_1499_ _1499_/A _1499_/B VGND VGND VPWR VPWR _1500_/B sky130_fd_sc_hd__xor2_2
X_1568_ _1568_/A _1568_/B VGND VGND VPWR VPWR _1580_/A sky130_fd_sc_hd__xor2_2
XTAP_TAPCELL_ROW_1_144 VGND VPWR sky130_fd_sc_hd__tapvpwrvgnd_1
XTAP_TAPCELL_ROW_24_268 VGND VPWR sky130_fd_sc_hd__tapvpwrvgnd_1
Xfanout77 _2230_/A VGND VGND VPWR VPWR _2326_/A sky130_fd_sc_hd__clkbuf_1
XFILLER_1_111 VGND VGND VPWR VPWR sky130_fd_sc_hd__fill_1
Xhold491 _2578_/X VGND VGND VPWR VPWR _2640_/D sky130_fd_sc_hd__clkbuf_2
Xhold480 hold558/X VGND VGND VPWR VPWR hold559/A sky130_fd_sc_hd__clkbuf_2
XFILLER_38_51 VGND VGND VPWR VPWR sky130_fd_sc_hd__fill_2
XFILLER_38_73 VGND VGND VPWR VPWR sky130_fd_sc_hd__decap_3
XFILLER_57_181 VGND VGND VPWR VPWR sky130_fd_sc_hd__decap_3
XFILLER_13_262 VGND VGND VPWR VPWR sky130_fd_sc_hd__decap_3
XFILLER_13_295 VGND VGND VPWR VPWR sky130_fd_sc_hd__decap_3
XFILLER_9_266 VGND VGND VPWR VPWR sky130_fd_sc_hd__decap_3
XPHY_EDGE_ROW_41_Left_106 VGND VGND VPWR VPWR sky130_fd_sc_hd__decap_3
X_1422_ _1595_/A _1422_/B VGND VGND VPWR VPWR _1471_/B sky130_fd_sc_hd__xnor2_2
XPHY_EDGE_ROW_50_Left_115 VGND VGND VPWR VPWR sky130_fd_sc_hd__decap_3
XFILLER_51_313 VGND VGND VPWR VPWR sky130_fd_sc_hd__decap_3
XFILLER_63_195 VGND VGND VPWR VPWR sky130_fd_sc_hd__fill_2
XTAP_TAPCELL_ROW_38_349 VGND VPWR sky130_fd_sc_hd__tapvpwrvgnd_1
XTAP_TAPCELL_ROW_46_393 VGND VPWR sky130_fd_sc_hd__tapvpwrvgnd_1
Xclkload8 clkload8/A VGND VGND VPWR VPWR clkload8/X sky130_fd_sc_hd__clkbuf_4
XFILLER_59_39 VGND VGND VPWR VPWR sky130_fd_sc_hd__decap_3
X_2669_ clkload6/A _2669_/D VGND VGND VPWR VPWR _2669_/Q sky130_fd_sc_hd__dfxtp_2
XFILLER_10_243 VGND VGND VPWR VPWR sky130_fd_sc_hd__fill_1
XFILLER_54_195 VGND VGND VPWR VPWR sky130_fd_sc_hd__fill_1
XTAP_TAPCELL_ROW_12_205 VGND VPWR sky130_fd_sc_hd__tapvpwrvgnd_1
XFILLER_10_276 VGND VGND VPWR VPWR sky130_fd_sc_hd__decap_3
XFILLER_40_52 VGND VGND VPWR VPWR sky130_fd_sc_hd__decap_3
XFILLER_40_85 VGND VGND VPWR VPWR sky130_fd_sc_hd__decap_3
XFILLER_6_203 VGND VGND VPWR VPWR sky130_fd_sc_hd__decap_3
XFILLER_37_118 VGND VGND VPWR VPWR sky130_fd_sc_hd__decap_3
XFILLER_45_184 VGND VGND VPWR VPWR sky130_fd_sc_hd__decap_3
XFILLER_60_3 VGND VGND VPWR VPWR sky130_fd_sc_hd__fill_1
XTAP_TAPCELL_ROW_43_374 VGND VPWR sky130_fd_sc_hd__tapvpwrvgnd_1
X_1971_ _2553_/B _2086_/A2 _1430_/Y _2551_/B VGND VGND VPWR VPWR _1972_/B sky130_fd_sc_hd__a22o_2
X_1405_ _1405_/A _1405_/B VGND VGND VPWR VPWR _1435_/B sky130_fd_sc_hd__xnor2_2
X_2523_ _2523_/A _2523_/B VGND VGND VPWR VPWR _2523_/X sky130_fd_sc_hd__or2_2
X_2454_ _2689_/Q _2488_/A2 _2450_/Y _2453_/X VGND VGND VPWR VPWR _2455_/B sky130_fd_sc_hd__a22o_2
X_2385_ _2385_/A _2385_/B VGND VGND VPWR VPWR _2460_/A sky130_fd_sc_hd__nor2_2
XFILLER_24_302 VGND VGND VPWR VPWR sky130_fd_sc_hd__decap_3
X_1336_ _2583_/A _1339_/B VGND VGND VPWR VPWR _2618_/B sky130_fd_sc_hd__and2_2
XFILLER_51_110 VGND VGND VPWR VPWR sky130_fd_sc_hd__fill_2
XFILLER_51_132 VGND VGND VPWR VPWR sky130_fd_sc_hd__fill_1
XFILLER_3_228 VGND VGND VPWR VPWR sky130_fd_sc_hd__decap_3
XFILLER_59_243 VGND VGND VPWR VPWR sky130_fd_sc_hd__decap_3
Xoutput360 _1600_/A2 VGND VGND VPWR VPWR a_out[8] sky130_fd_sc_hd__buf_2
Xoutput371 _1312_/X VGND VGND VPWR VPWR acc_out[3] sky130_fd_sc_hd__buf_2
Xoutput382 _2651_/Q VGND VGND VPWR VPWR b_out[13] sky130_fd_sc_hd__buf_2
Xoutput393 _2647_/Q VGND VGND VPWR VPWR b_out[9] sky130_fd_sc_hd__buf_2
XFILLER_27_184 VGND VGND VPWR VPWR sky130_fd_sc_hd__decap_3
XFILLER_42_132 VGND VGND VPWR VPWR sky130_fd_sc_hd__decap_3
XFILLER_42_154 VGND VGND VPWR VPWR sky130_fd_sc_hd__decap_3
XFILLER_30_305 VGND VGND VPWR VPWR sky130_fd_sc_hd__decap_3
XFILLER_42_187 VGND VGND VPWR VPWR sky130_fd_sc_hd__decap_3
XFILLER_51_40 VGND VGND VPWR VPWR sky130_fd_sc_hd__decap_3
XTAP_TAPCELL_ROW_40_355 VGND VPWR sky130_fd_sc_hd__tapvpwrvgnd_1
X_2621__401 VGND VGND VPWR VPWR _2621__401/HI _2621_/CIN sky130_fd_sc_hd__conb_1
XFILLER_18_151 VGND VGND VPWR VPWR sky130_fd_sc_hd__decap_3
XTAP_TAPCELL_ROW_48_400 VGND VPWR sky130_fd_sc_hd__tapvpwrvgnd_1
X_2170_ _2313_/A _1426_/X _1430_/Y _2561_/B VGND VGND VPWR VPWR _2171_/B sky130_fd_sc_hd__a22o_2
XFILLER_33_110 VGND VGND VPWR VPWR sky130_fd_sc_hd__fill_2
X_1954_ _1941_/A _1954_/B VGND VGND VPWR VPWR _1998_/A sky130_fd_sc_hd__and2b_2
X_1885_ _1885_/A _1885_/B VGND VGND VPWR VPWR _1937_/A sky130_fd_sc_hd__xnor2_2
XFILLER_56_18 VGND VGND VPWR VPWR sky130_fd_sc_hd__decap_3
XFILLER_56_29 VGND VGND VPWR VPWR sky130_fd_sc_hd__decap_3
X_2506_ _2525_/A _2506_/B VGND VGND VPWR VPWR _2698_/D sky130_fd_sc_hd__and2_2
X_2437_ _2437_/A _2437_/B _2437_/C VGND VGND VPWR VPWR _2438_/B sky130_fd_sc_hd__and3_2
X_2368_ _2368_/A _2372_/B VGND VGND VPWR VPWR _2369_/B sky130_fd_sc_hd__and2_2
XFILLER_56_224 VGND VGND VPWR VPWR sky130_fd_sc_hd__fill_2
XTAP_TAPCELL_ROW_54_436 VGND VPWR sky130_fd_sc_hd__tapvpwrvgnd_1
X_1319_ _2694_/Q _1319_/B VGND VGND VPWR VPWR _1319_/X sky130_fd_sc_hd__xor2_2
X_2299_ _2299_/A _2311_/A VGND VGND VPWR VPWR _2310_/A sky130_fd_sc_hd__xnor2_2
XTAP_TAPCELL_ROW_62_480 VGND VPWR sky130_fd_sc_hd__tapvpwrvgnd_1
XFILLER_46_40 VGND VGND VPWR VPWR sky130_fd_sc_hd__decap_3
XFILLER_47_257 VGND VGND VPWR VPWR sky130_fd_sc_hd__decap_3
XFILLER_47_279 VGND VGND VPWR VPWR sky130_fd_sc_hd__fill_1
XFILLER_15_165 VGND VGND VPWR VPWR sky130_fd_sc_hd__decap_3
XFILLER_15_187 VGND VGND VPWR VPWR sky130_fd_sc_hd__decap_3
XFILLER_46_62 VGND VGND VPWR VPWR sky130_fd_sc_hd__fill_1
XFILLER_55_290 VGND VGND VPWR VPWR sky130_fd_sc_hd__fill_1
XFILLER_62_238 VGND VGND VPWR VPWR sky130_fd_sc_hd__decap_3
X_1670_ _1697_/A _1670_/B VGND VGND VPWR VPWR _1707_/A sky130_fd_sc_hd__nand2_2
XFILLER_23_3 VGND VGND VPWR VPWR sky130_fd_sc_hd__fill_1
X_2222_ _2222_/A _2222_/B _2222_/C _2222_/D VGND VGND VPWR VPWR _2222_/Y sky130_fd_sc_hd__nand4_2
XFILLER_53_249 VGND VGND VPWR VPWR sky130_fd_sc_hd__decap_3
X_2153_ _2225_/A VGND VGND VPWR VPWR _2153_/Y sky130_fd_sc_hd__inv_2
X_2084_ _2197_/B _2084_/B VGND VGND VPWR VPWR _2132_/B sky130_fd_sc_hd__xnor2_2
XFILLER_61_260 VGND VGND VPWR VPWR sky130_fd_sc_hd__decap_3
XFILLER_61_293 VGND VGND VPWR VPWR sky130_fd_sc_hd__decap_3
XTAP_TAPCELL_ROW_51_417 VGND VPWR sky130_fd_sc_hd__tapvpwrvgnd_1
X_1937_ _1937_/A _1937_/B VGND VGND VPWR VPWR _1937_/X sky130_fd_sc_hd__or2_2
X_1868_ _1868_/A _1868_/B VGND VGND VPWR VPWR _1871_/A sky130_fd_sc_hd__nor2_2
X_1799_ _1790_/Y _1591_/X _1744_/Y _1790_/B _1798_/Y VGND VGND VPWR VPWR _1846_/A
+ sky130_fd_sc_hd__a32o_2
XFILLER_29_268 VGND VGND VPWR VPWR sky130_fd_sc_hd__decap_3
XFILLER_44_205 VGND VGND VPWR VPWR sky130_fd_sc_hd__fill_1
XFILLER_52_293 VGND VGND VPWR VPWR sky130_fd_sc_hd__decap_3
XFILLER_12_179 VGND VGND VPWR VPWR sky130_fd_sc_hd__decap_3
XFILLER_32_64 VGND VGND VPWR VPWR sky130_fd_sc_hd__fill_1
XFILLER_4_312 VGND VGND VPWR VPWR sky130_fd_sc_hd__decap_3
XFILLER_57_83 VGND VGND VPWR VPWR sky130_fd_sc_hd__decap_3
XFILLER_50_219 VGND VGND VPWR VPWR sky130_fd_sc_hd__decap_3
XPHY_EDGE_ROW_9_Right_9 VGND VGND VPWR VPWR sky130_fd_sc_hd__decap_3
X_1584_ _1584_/A _1584_/B VGND VGND VPWR VPWR _1745_/A sky130_fd_sc_hd__xor2_2
X_1653_ _1653_/A _1653_/B VGND VGND VPWR VPWR _1653_/X sky130_fd_sc_hd__and2_2
X_1722_ _1706_/A _1706_/B _1721_/Y VGND VGND VPWR VPWR _1723_/B sky130_fd_sc_hd__a21o_2
X_2205_ _2234_/A _2234_/B VGND VGND VPWR VPWR _2245_/B sky130_fd_sc_hd__xor2_2
XFILLER_26_238 VGND VGND VPWR VPWR sky130_fd_sc_hd__fill_1
XFILLER_26_249 VGND VGND VPWR VPWR sky130_fd_sc_hd__decap_3
XFILLER_53_19 VGND VGND VPWR VPWR sky130_fd_sc_hd__decap_3
X_2136_ _2291_/A _2136_/B VGND VGND VPWR VPWR _2162_/B sky130_fd_sc_hd__xnor2_2
X_2067_ _2067_/A _2067_/B VGND VGND VPWR VPWR _2068_/B sky130_fd_sc_hd__xnor2_2
Xhold640 a_in[11] VGND VGND VPWR VPWR hold640/X sky130_fd_sc_hd__clkbuf_2
Xhold651 _2569_/D VGND VGND VPWR VPWR hold651/X sky130_fd_sc_hd__clkbuf_2
Xhold662 hold662/A VGND VGND VPWR VPWR hold662/X sky130_fd_sc_hd__clkbuf_2
Xhold673 hold673/A VGND VGND VPWR VPWR hold673/X sky130_fd_sc_hd__clkbuf_2
XFILLER_17_216 VGND VGND VPWR VPWR sky130_fd_sc_hd__decap_3
XFILLER_40_274 VGND VGND VPWR VPWR sky130_fd_sc_hd__decap_3
XFILLER_40_296 VGND VGND VPWR VPWR sky130_fd_sc_hd__decap_3
XFILLER_43_63 VGND VGND VPWR VPWR sky130_fd_sc_hd__decap_3
XFILLER_43_96 VGND VGND VPWR VPWR sky130_fd_sc_hd__decap_3
XTAP_TAPCELL_ROW_27_288 VGND VPWR sky130_fd_sc_hd__tapvpwrvgnd_1
XFILLER_4_197 VGND VGND VPWR VPWR sky130_fd_sc_hd__decap_3
XFILLER_63_300 VGND VGND VPWR VPWR sky130_fd_sc_hd__decap_3
Xplace300 _2554_/B1 VGND VGND VPWR VPWR _2611_/C1 sky130_fd_sc_hd__buf_1
XFILLER_31_241 VGND VGND VPWR VPWR sky130_fd_sc_hd__decap_3
X_1705_ _1721_/A _1721_/B VGND VGND VPWR VPWR _1706_/B sky130_fd_sc_hd__xor2_2
X_1567_ _1598_/A _1567_/B VGND VGND VPWR VPWR _1568_/B sky130_fd_sc_hd__xnor2_2
X_1636_ _1655_/A _1655_/B _1635_/X VGND VGND VPWR VPWR _1640_/A sky130_fd_sc_hd__a21oi_2
X_2685_ clkload7/A _2685_/D VGND VGND VPWR VPWR _2685_/Q sky130_fd_sc_hd__dfxtp_2
XFILLER_64_18 VGND VGND VPWR VPWR sky130_fd_sc_hd__decap_3
XFILLER_64_29 VGND VGND VPWR VPWR sky130_fd_sc_hd__decap_3
XTAP_TAPCELL_ROW_1_145 VGND VPWR sky130_fd_sc_hd__tapvpwrvgnd_1
X_1498_ _1616_/A _1616_/B _1497_/Y VGND VGND VPWR VPWR _1500_/A sky130_fd_sc_hd__a21o_2
X_2119_ _2113_/Y _2114_/Y _2117_/Y _2118_/Y VGND VGND VPWR VPWR _2119_/X sky130_fd_sc_hd__a31o_2
XFILLER_22_241 VGND VGND VPWR VPWR sky130_fd_sc_hd__fill_2
XTAP_TAPCELL_ROW_24_269 VGND VPWR sky130_fd_sc_hd__tapvpwrvgnd_1
Xfanout78 hold409/A VGND VGND VPWR VPWR _2230_/A sky130_fd_sc_hd__buf_1
XFILLER_13_77 VGND VGND VPWR VPWR sky130_fd_sc_hd__fill_2
XFILLER_49_127 VGND VGND VPWR VPWR sky130_fd_sc_hd__decap_3
Xhold492 hold570/X VGND VGND VPWR VPWR hold571/A sky130_fd_sc_hd__clkbuf_2
Xhold481 hold560/X VGND VGND VPWR VPWR _2604_/C sky130_fd_sc_hd__clkbuf_2
Xhold470 _2552_/X VGND VGND VPWR VPWR _2630_/D sky130_fd_sc_hd__clkbuf_2
XFILLER_38_85 VGND VGND VPWR VPWR sky130_fd_sc_hd__decap_3
XFILLER_64_119 VGND VGND VPWR VPWR sky130_fd_sc_hd__decap_3
XFILLER_13_241 VGND VGND VPWR VPWR sky130_fd_sc_hd__fill_1
XFILLER_9_234 VGND VGND VPWR VPWR sky130_fd_sc_hd__fill_1
XFILLER_9_278 VGND VGND VPWR VPWR sky130_fd_sc_hd__fill_2
X_1421_ _1908_/B2 _1625_/B _1420_/X _1710_/A2 VGND VGND VPWR VPWR _1422_/B sky130_fd_sc_hd__a22o_2
X_2470_ _2528_/A _2470_/B VGND VGND VPWR VPWR _2691_/D sky130_fd_sc_hd__and2_2
XFILLER_55_119 VGND VGND VPWR VPWR sky130_fd_sc_hd__decap_3
X_1352_ _1352_/A _1352_/B VGND VGND VPWR VPWR _1352_/X sky130_fd_sc_hd__or2_2
Xclkload9 clkload9/A VGND VGND VPWR VPWR clkload9/X sky130_fd_sc_hd__clkbuf_4
X_2668_ _2668_/CLK _2668_/D VGND VGND VPWR VPWR _2668_/Q sky130_fd_sc_hd__dfxtp_2
X_1619_ _1664_/A _1664_/B _1618_/Y VGND VGND VPWR VPWR _1621_/A sky130_fd_sc_hd__o21a_2
X_2599_ _2608_/A _2651_/Q VGND VGND VPWR VPWR _2599_/X sky130_fd_sc_hd__or2_2
XFILLER_54_141 VGND VGND VPWR VPWR sky130_fd_sc_hd__decap_3
XFILLER_10_200 VGND VGND VPWR VPWR sky130_fd_sc_hd__decap_3
XFILLER_40_20 VGND VGND VPWR VPWR sky130_fd_sc_hd__decap_3
XTAP_TAPCELL_ROW_12_206 VGND VPWR sky130_fd_sc_hd__tapvpwrvgnd_1
XTAP_TAPCELL_ROW_20_250 VGND VPWR sky130_fd_sc_hd__tapvpwrvgnd_1
XFILLER_40_42 VGND VGND VPWR VPWR sky130_fd_sc_hd__decap_3
XFILLER_6_259 VGND VGND VPWR VPWR sky130_fd_sc_hd__decap_3
XFILLER_37_108 VGND VGND VPWR VPWR sky130_fd_sc_hd__decap_3
XFILLER_60_133 VGND VGND VPWR VPWR sky130_fd_sc_hd__decap_3
XPHY_EDGE_ROW_23_Left_88 VGND VGND VPWR VPWR sky130_fd_sc_hd__decap_3
XTAP_TAPCELL_ROW_43_375 VGND VPWR sky130_fd_sc_hd__tapvpwrvgnd_1
X_1970_ _2006_/A _2006_/B VGND VGND VPWR VPWR _1973_/A sky130_fd_sc_hd__xor2_2
XFILLER_5_281 VGND VGND VPWR VPWR sky130_fd_sc_hd__decap_3
X_1335_ _2702_/Q _1335_/B VGND VGND VPWR VPWR _1335_/X sky130_fd_sc_hd__xor2_2
X_1404_ _1519_/A _1404_/B VGND VGND VPWR VPWR _1405_/B sky130_fd_sc_hd__xor2_2
X_2453_ _2492_/A _2453_/B VGND VGND VPWR VPWR _2453_/X sky130_fd_sc_hd__or2_2
X_2384_ _2690_/Q _2384_/B VGND VGND VPWR VPWR _2385_/B sky130_fd_sc_hd__and2b_2
XFILLER_36_141 VGND VGND VPWR VPWR sky130_fd_sc_hd__decap_3
Xoutput350 _1926_/A1 VGND VGND VPWR VPWR a_out[13] sky130_fd_sc_hd__buf_2
Xoutput361 _1478_/A2 VGND VGND VPWR VPWR a_out[9] sky130_fd_sc_hd__buf_2
XFILLER_19_108 VGND VGND VPWR VPWR sky130_fd_sc_hd__decap_3
XFILLER_19_119 VGND VGND VPWR VPWR sky130_fd_sc_hd__decap_3
XFILLER_59_255 VGND VGND VPWR VPWR sky130_fd_sc_hd__decap_3
Xoutput372 _1315_/Y VGND VGND VPWR VPWR acc_out[4] sky130_fd_sc_hd__buf_2
Xoutput383 _2652_/Q VGND VGND VPWR VPWR b_out[14] sky130_fd_sc_hd__buf_2
XFILLER_35_53 VGND VGND VPWR VPWR sky130_fd_sc_hd__decap_3
XFILLER_35_64 VGND VGND VPWR VPWR sky130_fd_sc_hd__decap_3
XFILLER_35_97 VGND VGND VPWR VPWR sky130_fd_sc_hd__fill_2
XFILLER_42_100 VGND VGND VPWR VPWR sky130_fd_sc_hd__fill_2
XFILLER_42_122 VGND VGND VPWR VPWR sky130_fd_sc_hd__fill_2
XFILLER_42_166 VGND VGND VPWR VPWR sky130_fd_sc_hd__decap_3
XTAP_TAPCELL_ROW_40_356 VGND VPWR sky130_fd_sc_hd__tapvpwrvgnd_1
XFILLER_18_141 VGND VGND VPWR VPWR sky130_fd_sc_hd__decap_3
XFILLER_18_185 VGND VGND VPWR VPWR sky130_fd_sc_hd__fill_2
XTAP_TAPCELL_ROW_48_401 VGND VPWR sky130_fd_sc_hd__tapvpwrvgnd_1
XFILLER_21_306 VGND VGND VPWR VPWR sky130_fd_sc_hd__fill_1
XFILLER_33_122 VGND VGND VPWR VPWR sky130_fd_sc_hd__decap_3
XFILLER_33_155 VGND VGND VPWR VPWR sky130_fd_sc_hd__fill_1
X_1953_ _1953_/A _1953_/B VGND VGND VPWR VPWR _1994_/B sky130_fd_sc_hd__nand2_2
X_1884_ _1933_/A _1933_/B VGND VGND VPWR VPWR _1885_/B sky130_fd_sc_hd__xor2_2
X_2505_ _2698_/Q _2524_/A2 _2524_/B1 _2504_/X VGND VGND VPWR VPWR _2506_/B sky130_fd_sc_hd__a22o_2
XFILLER_56_203 VGND VGND VPWR VPWR sky130_fd_sc_hd__decap_3
X_1318_ _2693_/Q _2692_/Q _1314_/B _1314_/A VGND VGND VPWR VPWR _1319_/B sky130_fd_sc_hd__o31a_2
X_2436_ _2430_/X _2496_/A _2448_/A _2518_/B VGND VGND VPWR VPWR _2439_/C sky130_fd_sc_hd__and4bb_2
X_2367_ _2695_/Q _2397_/B VGND VGND VPWR VPWR _2422_/A sky130_fd_sc_hd__or2_2
X_2298_ _2272_/A _2271_/B _2271_/A VGND VGND VPWR VPWR _2311_/A sky130_fd_sc_hd__a21boi_2
XFILLER_12_306 VGND VGND VPWR VPWR sky130_fd_sc_hd__fill_2
XFILLER_24_166 VGND VGND VPWR VPWR sky130_fd_sc_hd__decap_3
XTAP_TAPCELL_ROW_54_437 VGND VPWR sky130_fd_sc_hd__tapvpwrvgnd_1
XFILLER_24_188 VGND VGND VPWR VPWR sky130_fd_sc_hd__decap_3
XTAP_TAPCELL_ROW_62_481 VGND VPWR sky130_fd_sc_hd__tapvpwrvgnd_1
XFILLER_47_203 VGND VGND VPWR VPWR sky130_fd_sc_hd__decap_3
XFILLER_47_236 VGND VGND VPWR VPWR sky130_fd_sc_hd__decap_3
XFILLER_15_111 VGND VGND VPWR VPWR sky130_fd_sc_hd__fill_1
XFILLER_15_133 VGND VGND VPWR VPWR sky130_fd_sc_hd__fill_1
XFILLER_30_147 VGND VGND VPWR VPWR sky130_fd_sc_hd__decap_3
XFILLER_7_57 VGND VGND VPWR VPWR sky130_fd_sc_hd__fill_1
XFILLER_38_203 VGND VGND VPWR VPWR sky130_fd_sc_hd__decap_3
XFILLER_38_236 VGND VGND VPWR VPWR sky130_fd_sc_hd__fill_1
X_2221_ _2221_/A _2227_/A VGND VGND VPWR VPWR _2222_/D sky130_fd_sc_hd__and2_2
X_2152_ _2113_/Y _2117_/Y _2117_/A VGND VGND VPWR VPWR _2225_/A sky130_fd_sc_hd__o21a_2
XFILLER_53_217 VGND VGND VPWR VPWR sky130_fd_sc_hd__fill_2
XFILLER_53_228 VGND VGND VPWR VPWR sky130_fd_sc_hd__decap_3
XTAP_TAPCELL_ROW_51_418 VGND VPWR sky130_fd_sc_hd__tapvpwrvgnd_1
X_2083_ _2635_/Q _1420_/A _2125_/C _1416_/X _2124_/A VGND VGND VPWR VPWR _2084_/B
+ sky130_fd_sc_hd__a32o_2
XFILLER_61_272 VGND VGND VPWR VPWR sky130_fd_sc_hd__decap_3
XPHY_EDGE_ROW_26_Left_91 VGND VGND VPWR VPWR sky130_fd_sc_hd__decap_3
X_1936_ _1936_/A _1936_/B VGND VGND VPWR VPWR _1955_/A sky130_fd_sc_hd__xor2_2
X_1867_ _1867_/A _1867_/B VGND VGND VPWR VPWR _1868_/B sky130_fd_sc_hd__nor2_2
XPHY_EDGE_ROW_10_Left_75 VGND VGND VPWR VPWR sky130_fd_sc_hd__decap_3
X_1798_ _1798_/A _1798_/B VGND VGND VPWR VPWR _1798_/Y sky130_fd_sc_hd__nor2_2
XFILLER_29_225 VGND VGND VPWR VPWR sky130_fd_sc_hd__decap_3
X_2419_ _2419_/A _2419_/B VGND VGND VPWR VPWR _2439_/A sky130_fd_sc_hd__xnor2_2
XFILLER_44_239 VGND VGND VPWR VPWR sky130_fd_sc_hd__decap_3
XFILLER_52_250 VGND VGND VPWR VPWR sky130_fd_sc_hd__fill_2
XFILLER_28_280 VGND VGND VPWR VPWR sky130_fd_sc_hd__decap_3
XFILLER_35_206 VGND VGND VPWR VPWR sky130_fd_sc_hd__decap_3
XFILLER_50_209 VGND VGND VPWR VPWR sky130_fd_sc_hd__fill_1
XFILLER_11_191 VGND VGND VPWR VPWR sky130_fd_sc_hd__decap_3
X_1721_ _1721_/A _1721_/B VGND VGND VPWR VPWR _1721_/Y sky130_fd_sc_hd__nor2_2
X_1583_ _1785_/A _1785_/B VGND VGND VPWR VPWR _1584_/B sky130_fd_sc_hd__xnor2_2
X_1652_ _1678_/A _1652_/B VGND VGND VPWR VPWR _1681_/B sky130_fd_sc_hd__xor2_2
XFILLER_26_217 VGND VGND VPWR VPWR sky130_fd_sc_hd__decap_3
XFILLER_58_309 VGND VGND VPWR VPWR sky130_fd_sc_hd__decap_3
X_2204_ _2291_/A _2204_/B VGND VGND VPWR VPWR _2234_/B sky130_fd_sc_hd__xnor2_2
X_2135_ _2557_/B _1469_/Y _1538_/X _2555_/B VGND VGND VPWR VPWR _2136_/B sky130_fd_sc_hd__a22o_2
XFILLER_34_272 VGND VGND VPWR VPWR sky130_fd_sc_hd__fill_1
X_2066_ _2107_/A _2107_/B VGND VGND VPWR VPWR _2067_/B sky130_fd_sc_hd__xor2_2
Xhold630 hold630/A VGND VGND VPWR VPWR hold630/X sky130_fd_sc_hd__clkbuf_2
X_1919_ _1919_/A _1919_/B VGND VGND VPWR VPWR _1958_/B sky130_fd_sc_hd__xnor2_2
XFILLER_1_316 VGND VGND VPWR VPWR sky130_fd_sc_hd__decap_3
Xhold641 hold641/A VGND VGND VPWR VPWR hold641/X sky130_fd_sc_hd__clkbuf_2
Xhold652 a_in[4] VGND VGND VPWR VPWR hold652/X sky130_fd_sc_hd__clkbuf_2
Xhold663 _2566_/A VGND VGND VPWR VPWR hold663/X sky130_fd_sc_hd__clkbuf_2
Xhold674 hold674/A VGND VGND VPWR VPWR hold674/X sky130_fd_sc_hd__clkbuf_2
XFILLER_17_228 VGND VGND VPWR VPWR sky130_fd_sc_hd__decap_3
XFILLER_40_253 VGND VGND VPWR VPWR sky130_fd_sc_hd__decap_3
XFILLER_40_286 VGND VGND VPWR VPWR sky130_fd_sc_hd__decap_3
XTAP_TAPCELL_ROW_18_234 VGND VPWR sky130_fd_sc_hd__tapvpwrvgnd_1
Xplace301 _1356_/C1 VGND VGND VPWR VPWR _2554_/B1 sky130_fd_sc_hd__buf_1
X_2684_ clkload7/A _2684_/D VGND VGND VPWR VPWR _2684_/Q sky130_fd_sc_hd__dfxtp_2
X_1704_ _1708_/A _1708_/B VGND VGND VPWR VPWR _1721_/B sky130_fd_sc_hd__nand2_2
X_1497_ _1497_/A _1497_/B VGND VGND VPWR VPWR _1497_/Y sky130_fd_sc_hd__nor2_2
X_1566_ _1960_/B2 _1494_/B _1921_/B1 _1908_/B2 VGND VGND VPWR VPWR _1567_/B sky130_fd_sc_hd__a22o_2
X_1635_ _1635_/A _1635_/B VGND VGND VPWR VPWR _1635_/X sky130_fd_sc_hd__and2_2
X_2118_ _2113_/Y _2117_/Y hold601/X VGND VGND VPWR VPWR _2118_/Y sky130_fd_sc_hd__o21ai_2
X_2049_ _2557_/B _2086_/A2 _1430_/Y _2555_/B VGND VGND VPWR VPWR _2050_/B sky130_fd_sc_hd__a22o_2
XFILLER_13_45 VGND VGND VPWR VPWR sky130_fd_sc_hd__fill_1
XFILLER_22_253 VGND VGND VPWR VPWR sky130_fd_sc_hd__fill_2
XFILLER_22_275 VGND VGND VPWR VPWR sky130_fd_sc_hd__decap_3
Xfanout79 _2583_/A VGND VGND VPWR VPWR _2608_/A sky130_fd_sc_hd__buf_1
Xhold471 hold660/X VGND VGND VPWR VPWR hold661/A sky130_fd_sc_hd__clkbuf_2
Xhold460 hold658/X VGND VGND VPWR VPWR _2606_/A sky130_fd_sc_hd__clkbuf_2
XFILLER_38_64 VGND VGND VPWR VPWR sky130_fd_sc_hd__decap_3
Xhold493 hold572/X VGND VGND VPWR VPWR _2606_/B sky130_fd_sc_hd__clkbuf_2
Xhold482 _2602_/X VGND VGND VPWR VPWR _2652_/D sky130_fd_sc_hd__clkbuf_2
XFILLER_54_85 VGND VGND VPWR VPWR sky130_fd_sc_hd__decap_3
XFILLER_57_172 VGND VGND VPWR VPWR sky130_fd_sc_hd__decap_3
XFILLER_60_315 VGND VGND VPWR VPWR sky130_fd_sc_hd__decap_3
XFILLER_13_286 VGND VGND VPWR VPWR sky130_fd_sc_hd__decap_3
XFILLER_55_7 VGND VGND VPWR VPWR sky130_fd_sc_hd__fill_2
X_1351_ _2661_/Q _2618_/B _1349_/X _1356_/C1 VGND VGND VPWR VPWR _1351_/X sky130_fd_sc_hd__o211a_2
X_1420_ _1420_/A _2125_/C VGND VGND VPWR VPWR _1420_/X sky130_fd_sc_hd__and2_2
XFILLER_48_150 VGND VGND VPWR VPWR sky130_fd_sc_hd__fill_2
XFILLER_51_304 VGND VGND VPWR VPWR sky130_fd_sc_hd__decap_3
XFILLER_63_153 VGND VGND VPWR VPWR sky130_fd_sc_hd__fill_2
XFILLER_63_175 VGND VGND VPWR VPWR sky130_fd_sc_hd__decap_3
X_1618_ _1618_/A _1618_/B VGND VGND VPWR VPWR _1618_/Y sky130_fd_sc_hd__nand2_2
X_2667_ _2668_/CLK _2667_/D VGND VGND VPWR VPWR _2667_/Q sky130_fd_sc_hd__dfxtp_2
XFILLER_46_109 VGND VGND VPWR VPWR sky130_fd_sc_hd__fill_1
X_1549_ _1549_/A _1549_/B VGND VGND VPWR VPWR _1549_/X sky130_fd_sc_hd__and2_2
X_2598_ _2602_/A1 _1363_/A _2602_/B1 _2597_/X VGND VGND VPWR VPWR _2598_/X sky130_fd_sc_hd__o211a_2
XFILLER_39_172 VGND VGND VPWR VPWR sky130_fd_sc_hd__decap_3
XFILLER_42_315 VGND VGND VPWR VPWR sky130_fd_sc_hd__decap_3
XFILLER_54_197 VGND VGND VPWR VPWR sky130_fd_sc_hd__decap_3
XTAP_TAPCELL_ROW_37_340 VGND VPWR sky130_fd_sc_hd__tapvpwrvgnd_1
XFILLER_10_234 VGND VGND VPWR VPWR sky130_fd_sc_hd__decap_3
XFILLER_24_88 VGND VGND VPWR VPWR sky130_fd_sc_hd__decap_3
XFILLER_49_52 VGND VGND VPWR VPWR sky130_fd_sc_hd__decap_3
XFILLER_18_312 VGND VGND VPWR VPWR sky130_fd_sc_hd__decap_3
XFILLER_60_101 VGND VGND VPWR VPWR sky130_fd_sc_hd__decap_3
XTAP_TAPCELL_ROW_43_376 VGND VPWR sky130_fd_sc_hd__tapvpwrvgnd_1
X_2521_ _2525_/A _2521_/B VGND VGND VPWR VPWR _2701_/D sky130_fd_sc_hd__and2_2
XFILLER_46_3 VGND VGND VPWR VPWR sky130_fd_sc_hd__fill_1
XFILLER_5_293 VGND VGND VPWR VPWR sky130_fd_sc_hd__decap_3
XPHY_EDGE_ROW_18_Right_18 VGND VGND VPWR VPWR sky130_fd_sc_hd__decap_3
X_1334_ _2701_/Q _2700_/Q _1331_/B _2708_/A VGND VGND VPWR VPWR _1335_/B sky130_fd_sc_hd__o31a_2
X_1403_ _1628_/A2 _1386_/X _1677_/B1 _1646_/A2 VGND VGND VPWR VPWR _1404_/B sky130_fd_sc_hd__a22o_2
X_2452_ _2452_/A _2452_/B VGND VGND VPWR VPWR _2453_/B sky130_fd_sc_hd__xnor2_2
X_2383_ _2384_/B _2690_/Q VGND VGND VPWR VPWR _2385_/A sky130_fd_sc_hd__and2b_2
XFILLER_24_315 VGND VGND VPWR VPWR sky130_fd_sc_hd__fill_1
XFILLER_36_131 VGND VGND VPWR VPWR sky130_fd_sc_hd__decap_3
XFILLER_36_175 VGND VGND VPWR VPWR sky130_fd_sc_hd__fill_1
XFILLER_51_101 VGND VGND VPWR VPWR sky130_fd_sc_hd__decap_3
XPHY_EDGE_ROW_27_Right_27 VGND VGND VPWR VPWR sky130_fd_sc_hd__decap_3
XFILLER_51_167 VGND VGND VPWR VPWR sky130_fd_sc_hd__fill_1
XFILLER_51_178 VGND VGND VPWR VPWR sky130_fd_sc_hd__decap_3
XPHY_EDGE_ROW_36_Right_36 VGND VGND VPWR VPWR sky130_fd_sc_hd__decap_3
Xoutput351 _2636_/Q VGND VGND VPWR VPWR a_out[14] sky130_fd_sc_hd__buf_2
Xoutput362 _2707_/X VGND VGND VPWR VPWR acc_out[0] sky130_fd_sc_hd__buf_2
Xoutput373 _1317_/Y VGND VGND VPWR VPWR acc_out[5] sky130_fd_sc_hd__buf_2
Xoutput384 _2653_/Q VGND VGND VPWR VPWR b_out[15] sky130_fd_sc_hd__buf_2
XFILLER_59_234 VGND VGND VPWR VPWR sky130_fd_sc_hd__decap_3
XFILLER_30_318 VGND VGND VPWR VPWR sky130_fd_sc_hd__fill_2
XFILLER_42_178 VGND VGND VPWR VPWR sky130_fd_sc_hd__fill_1
XFILLER_51_20 VGND VGND VPWR VPWR sky130_fd_sc_hd__decap_3
XPHY_EDGE_ROW_45_Right_45 VGND VGND VPWR VPWR sky130_fd_sc_hd__decap_3
XFILLER_51_31 VGND VGND VPWR VPWR sky130_fd_sc_hd__decap_3
XPHY_EDGE_ROW_54_Right_54 VGND VGND VPWR VPWR sky130_fd_sc_hd__decap_3
XTAP_TAPCELL_ROW_40_357 VGND VPWR sky130_fd_sc_hd__tapvpwrvgnd_1
XFILLER_2_241 VGND VGND VPWR VPWR sky130_fd_sc_hd__decap_3
XFILLER_2_263 VGND VGND VPWR VPWR sky130_fd_sc_hd__decap_3
XFILLER_18_120 VGND VGND VPWR VPWR sky130_fd_sc_hd__decap_3
XFILLER_18_197 VGND VGND VPWR VPWR sky130_fd_sc_hd__decap_3
XFILLER_33_101 VGND VGND VPWR VPWR sky130_fd_sc_hd__decap_3
XFILLER_33_145 VGND VGND VPWR VPWR sky130_fd_sc_hd__decap_3
XPHY_EDGE_ROW_38_Left_103 VGND VGND VPWR VPWR sky130_fd_sc_hd__decap_3
XPHY_EDGE_ROW_63_Right_63 VGND VGND VPWR VPWR sky130_fd_sc_hd__decap_3
XTAP_TAPCELL_ROW_48_402 VGND VPWR sky130_fd_sc_hd__tapvpwrvgnd_1
XFILLER_33_167 VGND VGND VPWR VPWR sky130_fd_sc_hd__fill_1
X_1883_ _1830_/A _1830_/B _1882_/X VGND VGND VPWR VPWR _1933_/B sky130_fd_sc_hd__a21oi_2
XPHY_EDGE_ROW_47_Left_112 VGND VGND VPWR VPWR sky130_fd_sc_hd__decap_3
X_2504_ _2523_/B _2439_/B VGND VGND VPWR VPWR _2504_/X sky130_fd_sc_hd__or2b_2
X_2435_ _2435_/A _2435_/B VGND VGND VPWR VPWR _2518_/B sky130_fd_sc_hd__nor2_2
XFILLER_56_215 VGND VGND VPWR VPWR sky130_fd_sc_hd__decap_3
X_1317_ _2693_/Q _1317_/B VGND VGND VPWR VPWR _1317_/Y sky130_fd_sc_hd__xnor2_2
X_2366_ _2678_/Q _2366_/B VGND VGND VPWR VPWR _2397_/B sky130_fd_sc_hd__xnor2_2
X_2297_ _2312_/A _2297_/B VGND VGND VPWR VPWR _2299_/A sky130_fd_sc_hd__and2_2
XPHY_EDGE_ROW_56_Left_121 VGND VGND VPWR VPWR sky130_fd_sc_hd__decap_3
XFILLER_46_20 VGND VGND VPWR VPWR sky130_fd_sc_hd__decap_3
XFILLER_46_97 VGND VGND VPWR VPWR sky130_fd_sc_hd__fill_2
XFILLER_55_281 VGND VGND VPWR VPWR sky130_fd_sc_hd__decap_3
XFILLER_62_229 VGND VGND VPWR VPWR sky130_fd_sc_hd__decap_3
XFILLER_15_178 VGND VGND VPWR VPWR sky130_fd_sc_hd__decap_3
XFILLER_38_215 VGND VGND VPWR VPWR sky130_fd_sc_hd__fill_1
XFILLER_38_248 VGND VGND VPWR VPWR sky130_fd_sc_hd__decap_3
X_2220_ _2220_/A _2220_/B VGND VGND VPWR VPWR _2255_/A sky130_fd_sc_hd__nand2_2
X_2151_ _2226_/A _2151_/B VGND VGND VPWR VPWR _2222_/C sky130_fd_sc_hd__and2_2
X_2082_ _2068_/B _2082_/B VGND VGND VPWR VPWR _2116_/A sky130_fd_sc_hd__nand2b_2
XFILLER_21_104 VGND VGND VPWR VPWR sky130_fd_sc_hd__fill_2
XFILLER_61_251 VGND VGND VPWR VPWR sky130_fd_sc_hd__decap_3
XFILLER_61_284 VGND VGND VPWR VPWR sky130_fd_sc_hd__decap_3
XTAP_TAPCELL_ROW_51_419 VGND VPWR sky130_fd_sc_hd__tapvpwrvgnd_1
XFILLER_21_159 VGND VGND VPWR VPWR sky130_fd_sc_hd__decap_3
X_1935_ _1987_/A _1987_/B VGND VGND VPWR VPWR _1936_/B sky130_fd_sc_hd__xnor2_2
X_1866_ _1867_/A _1867_/B VGND VGND VPWR VPWR _1868_/A sky130_fd_sc_hd__and2_2
X_2418_ _2418_/A _2418_/B VGND VGND VPWR VPWR _2419_/B sky130_fd_sc_hd__nor2_2
XFILLER_29_248 VGND VGND VPWR VPWR sky130_fd_sc_hd__fill_1
XFILLER_37_292 VGND VGND VPWR VPWR sky130_fd_sc_hd__decap_3
X_2349_ _2682_/Q _2351_/B _2354_/A VGND VGND VPWR VPWR _2350_/B sky130_fd_sc_hd__o21a_2
XFILLER_12_126 VGND VGND VPWR VPWR sky130_fd_sc_hd__fill_1
XFILLER_52_284 VGND VGND VPWR VPWR sky130_fd_sc_hd__fill_1
XPHY_EDGE_ROW_0_Right_0 VGND VGND VPWR VPWR sky130_fd_sc_hd__decap_3
XTAP_TAPCELL_ROW_7_174 VGND VPWR sky130_fd_sc_hd__tapvpwrvgnd_1
XFILLER_43_273 VGND VGND VPWR VPWR sky130_fd_sc_hd__decap_3
XFILLER_43_284 VGND VGND VPWR VPWR sky130_fd_sc_hd__fill_1
X_1651_ _1710_/A2 _1697_/B _1677_/B1 _1728_/A2 VGND VGND VPWR VPWR _1652_/B sky130_fd_sc_hd__a22o_2
X_1720_ _1720_/A _1725_/C VGND VGND VPWR VPWR _1723_/A sky130_fd_sc_hd__xnor2_2
X_1582_ _1530_/A _1530_/B _1581_/Y VGND VGND VPWR VPWR _1785_/B sky130_fd_sc_hd__a21oi_2
XFILLER_19_281 VGND VGND VPWR VPWR sky130_fd_sc_hd__decap_3
X_2203_ _2561_/B _1469_/Y _1538_/X _2265_/B2 VGND VGND VPWR VPWR _2204_/B sky130_fd_sc_hd__a22o_2
X_2134_ _2553_/B _2290_/A2 _2313_/B _2551_/B VGND VGND VPWR VPWR _2162_/A sky130_fd_sc_hd__a22o_2
X_2065_ _2029_/A _2029_/B _2064_/X VGND VGND VPWR VPWR _2107_/B sky130_fd_sc_hd__a21boi_2
Xhold620 a_in[1] VGND VGND VPWR VPWR hold620/X sky130_fd_sc_hd__clkbuf_2
Xhold631 _2567_/B VGND VGND VPWR VPWR hold631/X sky130_fd_sc_hd__clkbuf_2
Xhold642 hold642/A VGND VGND VPWR VPWR hold642/X sky130_fd_sc_hd__clkbuf_2
Xhold653 hold653/A VGND VGND VPWR VPWR hold653/X sky130_fd_sc_hd__clkbuf_2
X_1918_ _2631_/Q _2019_/A2 _2019_/A3 _1416_/X _2022_/A1 VGND VGND VPWR VPWR _1919_/B
+ sky130_fd_sc_hd__a32o_2
X_1849_ _2673_/Q VGND VGND VPWR VPWR _2382_/A sky130_fd_sc_hd__inv_2
Xhold664 a_in[8] VGND VGND VPWR VPWR hold664/X sky130_fd_sc_hd__clkbuf_2
Xhold675 load_weight VGND VGND VPWR VPWR hold675/X sky130_fd_sc_hd__clkbuf_2
Xmax_cap394 _1570_/A VGND VGND VPWR VPWR _1601_/A sky130_fd_sc_hd__buf_8
XFILLER_25_284 VGND VGND VPWR VPWR sky130_fd_sc_hd__fill_1
XFILLER_25_295 VGND VGND VPWR VPWR sky130_fd_sc_hd__fill_1
XFILLER_40_265 VGND VGND VPWR VPWR sky130_fd_sc_hd__decap_3
XFILLER_4_26 VGND VGND VPWR VPWR sky130_fd_sc_hd__fill_2
XFILLER_4_59 VGND VGND VPWR VPWR sky130_fd_sc_hd__fill_1
Xplace302 _2550_/B1 VGND VGND VPWR VPWR _1356_/C1 sky130_fd_sc_hd__buf_1
XFILLER_16_273 VGND VGND VPWR VPWR sky130_fd_sc_hd__decap_3
XFILLER_31_221 VGND VGND VPWR VPWR sky130_fd_sc_hd__decap_3
XFILLER_31_265 VGND VGND VPWR VPWR sky130_fd_sc_hd__decap_3
XTAP_TAPCELL_ROW_18_235 VGND VPWR sky130_fd_sc_hd__tapvpwrvgnd_1
XFILLER_31_287 VGND VGND VPWR VPWR sky130_fd_sc_hd__decap_3
X_1634_ _1706_/A _1634_/B VGND VGND VPWR VPWR _1655_/B sky130_fd_sc_hd__xor2_2
X_2683_ clkload7/A _2683_/D VGND VGND VPWR VPWR _2683_/Q sky130_fd_sc_hd__dfxtp_2
X_1703_ _1772_/A _1703_/B VGND VGND VPWR VPWR _1708_/B sky130_fd_sc_hd__xor2_2
XFILLER_58_118 VGND VGND VPWR VPWR sky130_fd_sc_hd__decap_3
X_1496_ _1496_/A _1496_/B VGND VGND VPWR VPWR _1616_/B sky130_fd_sc_hd__xnor2_2
X_1565_ _1565_/A _1565_/B VGND VGND VPWR VPWR _1568_/A sky130_fd_sc_hd__nor2_2
XFILLER_22_210 VGND VGND VPWR VPWR sky130_fd_sc_hd__decap_3
X_2117_ _2117_/A _2117_/B VGND VGND VPWR VPWR _2117_/Y sky130_fd_sc_hd__nand2_2
X_2048_ _2093_/A _2093_/B VGND VGND VPWR VPWR _2051_/A sky130_fd_sc_hd__xor2_2
XFILLER_22_232 VGND VGND VPWR VPWR sky130_fd_sc_hd__decap_3
XFILLER_1_136 VGND VGND VPWR VPWR sky130_fd_sc_hd__fill_1
Xhold494 _2582_/X VGND VGND VPWR VPWR _2642_/D sky130_fd_sc_hd__clkbuf_2
Xhold483 hold586/X VGND VGND VPWR VPWR hold587/A sky130_fd_sc_hd__clkbuf_2
Xhold472 hold662/X VGND VGND VPWR VPWR _2566_/A sky130_fd_sc_hd__clkbuf_2
Xhold461 _2584_/X VGND VGND VPWR VPWR _2643_/D sky130_fd_sc_hd__clkbuf_2
Xhold450 hold530/X VGND VGND VPWR VPWR hold531/A sky130_fd_sc_hd__clkbuf_2
XFILLER_38_10 VGND VGND VPWR VPWR sky130_fd_sc_hd__decap_3
XFILLER_38_32 VGND VGND VPWR VPWR sky130_fd_sc_hd__decap_3
XFILLER_38_76 VGND VGND VPWR VPWR sky130_fd_sc_hd__decap_3
XFILLER_57_140 VGND VGND VPWR VPWR sky130_fd_sc_hd__decap_3
XFILLER_57_184 VGND VGND VPWR VPWR sky130_fd_sc_hd__fill_2
XFILLER_57_195 VGND VGND VPWR VPWR sky130_fd_sc_hd__decap_3
XFILLER_13_221 VGND VGND VPWR VPWR sky130_fd_sc_hd__decap_3
XFILLER_13_265 VGND VGND VPWR VPWR sky130_fd_sc_hd__fill_1
XFILLER_9_203 VGND VGND VPWR VPWR sky130_fd_sc_hd__fill_2
XFILLER_9_225 VGND VGND VPWR VPWR sky130_fd_sc_hd__decap_3
XFILLER_13_298 VGND VGND VPWR VPWR sky130_fd_sc_hd__decap_3
XFILLER_9_269 VGND VGND VPWR VPWR sky130_fd_sc_hd__decap_3
XFILLER_48_184 VGND VGND VPWR VPWR sky130_fd_sc_hd__decap_3
XFILLER_48_195 VGND VGND VPWR VPWR sky130_fd_sc_hd__fill_1
X_1617_ _1618_/A _1618_/B VGND VGND VPWR VPWR _1664_/B sky130_fd_sc_hd__xnor2_2
X_2666_ clkload6/A _2666_/D VGND VGND VPWR VPWR _2666_/Q sky130_fd_sc_hd__dfxtp_2
X_2597_ _2608_/A _2650_/Q VGND VGND VPWR VPWR _2597_/X sky130_fd_sc_hd__or2_2
XFILLER_54_110 VGND VGND VPWR VPWR sky130_fd_sc_hd__decap_3
X_1479_ _1601_/A _1479_/B VGND VGND VPWR VPWR _1485_/A sky130_fd_sc_hd__xnor2_2
X_1548_ _1546_/A _1546_/B _1547_/X VGND VGND VPWR VPWR _1798_/A sky130_fd_sc_hd__a21oi_2
XTAP_TAPCELL_ROW_37_341 VGND VPWR sky130_fd_sc_hd__tapvpwrvgnd_1
XFILLER_10_279 VGND VGND VPWR VPWR sky130_fd_sc_hd__fill_2
XFILLER_40_55 VGND VGND VPWR VPWR sky130_fd_sc_hd__decap_3
XFILLER_6_206 VGND VGND VPWR VPWR sky130_fd_sc_hd__fill_1
XFILLER_49_20 VGND VGND VPWR VPWR sky130_fd_sc_hd__fill_1
XFILLER_49_97 VGND VGND VPWR VPWR sky130_fd_sc_hd__decap_3
XFILLER_6_3 VGND VGND VPWR VPWR sky130_fd_sc_hd__fill_1
XFILLER_60_157 VGND VGND VPWR VPWR sky130_fd_sc_hd__decap_3
X_1402_ _1437_/A _1437_/B VGND VGND VPWR VPWR _1405_/A sky130_fd_sc_hd__xor2_2
X_2520_ _2701_/Q _2524_/A2 _2524_/B1 _2519_/X VGND VGND VPWR VPWR _2521_/B sky130_fd_sc_hd__a22o_2
XFILLER_36_110 VGND VGND VPWR VPWR sky130_fd_sc_hd__decap_3
XFILLER_39_3 VGND VGND VPWR VPWR sky130_fd_sc_hd__decap_3
X_1333_ _2701_/Q _1333_/B VGND VGND VPWR VPWR _1333_/Y sky130_fd_sc_hd__xnor2_2
X_2382_ _2382_/A _2382_/B VGND VGND VPWR VPWR _2384_/B sky130_fd_sc_hd__xnor2_2
XFILLER_24_305 VGND VGND VPWR VPWR sky130_fd_sc_hd__decap_3
XFILLER_51_146 VGND VGND VPWR VPWR sky130_fd_sc_hd__fill_2
XTAP_TAPCELL_ROW_34_322 VGND VPWR sky130_fd_sc_hd__tapvpwrvgnd_1
XFILLER_59_246 VGND VGND VPWR VPWR sky130_fd_sc_hd__decap_3
Xoutput352 _2706_/X VGND VGND VPWR VPWR a_out[15] sky130_fd_sc_hd__buf_2
Xoutput363 _1327_/X VGND VGND VPWR VPWR acc_out[10] sky130_fd_sc_hd__buf_2
Xoutput374 _1319_/X VGND VGND VPWR VPWR acc_out[6] sky130_fd_sc_hd__buf_2
Xoutput385 _2639_/Q VGND VGND VPWR VPWR b_out[1] sky130_fd_sc_hd__buf_2
X_2649_ clkload3/A _2649_/D VGND VGND VPWR VPWR _2649_/Q sky130_fd_sc_hd__dfxtp_2
XFILLER_19_78 VGND VGND VPWR VPWR sky130_fd_sc_hd__fill_1
XFILLER_27_110 VGND VGND VPWR VPWR sky130_fd_sc_hd__fill_2
XFILLER_27_132 VGND VGND VPWR VPWR sky130_fd_sc_hd__fill_1
XFILLER_27_187 VGND VGND VPWR VPWR sky130_fd_sc_hd__decap_3
XFILLER_35_77 VGND VGND VPWR VPWR sky130_fd_sc_hd__fill_1
XFILLER_42_135 VGND VGND VPWR VPWR sky130_fd_sc_hd__decap_3
XFILLER_42_157 VGND VGND VPWR VPWR sky130_fd_sc_hd__decap_3
XFILLER_50_190 VGND VGND VPWR VPWR sky130_fd_sc_hd__decap_3
XFILLER_51_43 VGND VGND VPWR VPWR sky130_fd_sc_hd__decap_3
XTAP_TAPCELL_ROW_40_358 VGND VPWR sky130_fd_sc_hd__tapvpwrvgnd_1
XFILLER_51_65 VGND VGND VPWR VPWR sky130_fd_sc_hd__decap_3
XFILLER_2_253 VGND VGND VPWR VPWR sky130_fd_sc_hd__decap_3
XTAP_TAPCELL_ROW_48_403 VGND VPWR sky130_fd_sc_hd__tapvpwrvgnd_1
XFILLER_18_176 VGND VGND VPWR VPWR sky130_fd_sc_hd__decap_3
XFILLER_33_113 VGND VGND VPWR VPWR sky130_fd_sc_hd__decap_3
X_1951_ _2230_/A _1951_/B VGND VGND VPWR VPWR _2674_/D sky130_fd_sc_hd__nor2_2
X_1882_ _2656_/Q _1882_/B VGND VGND VPWR VPWR _1882_/X sky130_fd_sc_hd__and2_2
X_2434_ _2434_/A VGND VGND VPWR VPWR _2435_/A sky130_fd_sc_hd__inv_2
X_2365_ _2677_/Q _2372_/B _2368_/A VGND VGND VPWR VPWR _2366_/B sky130_fd_sc_hd__o21a_2
XFILLER_49_290 VGND VGND VPWR VPWR sky130_fd_sc_hd__fill_2
X_1316_ _2692_/Q _1314_/B _1314_/A VGND VGND VPWR VPWR _1317_/B sky130_fd_sc_hd__o21ai_2
X_2296_ _2274_/A _2275_/A _2294_/Y VGND VGND VPWR VPWR _2297_/B sky130_fd_sc_hd__a21o_2
XFILLER_24_135 VGND VGND VPWR VPWR sky130_fd_sc_hd__decap_3
XFILLER_64_271 VGND VGND VPWR VPWR sky130_fd_sc_hd__decap_3
XFILLER_21_57 VGND VGND VPWR VPWR sky130_fd_sc_hd__fill_1
XFILLER_46_43 VGND VGND VPWR VPWR sky130_fd_sc_hd__decap_3
XFILLER_55_260 VGND VGND VPWR VPWR sky130_fd_sc_hd__decap_3
XFILLER_7_15 VGND VGND VPWR VPWR sky130_fd_sc_hd__fill_1
XFILLER_7_301 VGND VGND VPWR VPWR sky130_fd_sc_hd__fill_2
X_2150_ _2150_/A _2150_/B VGND VGND VPWR VPWR _2151_/B sky130_fd_sc_hd__or2_2
X_2081_ _2259_/A _2678_/Q VGND VGND VPWR VPWR _2081_/Y sky130_fd_sc_hd__nand2_2
XFILLER_14_190 VGND VGND VPWR VPWR sky130_fd_sc_hd__decap_3
XFILLER_21_116 VGND VGND VPWR VPWR sky130_fd_sc_hd__decap_3
XFILLER_61_263 VGND VGND VPWR VPWR sky130_fd_sc_hd__decap_3
XFILLER_61_296 VGND VGND VPWR VPWR sky130_fd_sc_hd__decap_3
X_1934_ _1885_/A _1885_/B _1933_/Y VGND VGND VPWR VPWR _1987_/B sky130_fd_sc_hd__a21oi_2
X_1865_ _1919_/A _1865_/B VGND VGND VPWR VPWR _1867_/B sky130_fd_sc_hd__xnor2_2
X_1796_ _2230_/A _1796_/B VGND VGND VPWR VPWR _2671_/D sky130_fd_sc_hd__nor2_2
X_2417_ _2441_/S _2416_/X VGND VGND VPWR VPWR _2449_/B sky130_fd_sc_hd__nor2b_2
X_2348_ _2701_/Q _2412_/B VGND VGND VPWR VPWR _2434_/A sky130_fd_sc_hd__nand2_2
X_2279_ _2303_/A _2279_/B VGND VGND VPWR VPWR _2289_/B sky130_fd_sc_hd__nor2_2
XFILLER_20_182 VGND VGND VPWR VPWR sky130_fd_sc_hd__decap_3
XFILLER_52_296 VGND VGND VPWR VPWR sky130_fd_sc_hd__decap_3
XFILLER_4_315 VGND VGND VPWR VPWR sky130_fd_sc_hd__decap_3
XFILLER_57_86 VGND VGND VPWR VPWR sky130_fd_sc_hd__decap_3
XTAP_TAPCELL_ROW_7_175 VGND VPWR sky130_fd_sc_hd__tapvpwrvgnd_1
XFILLER_28_271 VGND VGND VPWR VPWR sky130_fd_sc_hd__decap_3
XFILLER_43_241 VGND VGND VPWR VPWR sky130_fd_sc_hd__decap_3
X_1581_ _1581_/A _1581_/B VGND VGND VPWR VPWR _1581_/Y sky130_fd_sc_hd__nor2_2
X_1650_ _1653_/A _1653_/B VGND VGND VPWR VPWR _1681_/A sky130_fd_sc_hd__xor2_2
XFILLER_21_3 VGND VGND VPWR VPWR sky130_fd_sc_hd__fill_2
X_2202_ _2557_/B _2290_/A2 _2313_/B _2555_/B VGND VGND VPWR VPWR _2234_/A sky130_fd_sc_hd__a22o_2
XFILLER_26_208 VGND VGND VPWR VPWR sky130_fd_sc_hd__decap_3
X_2133_ _2088_/A _2088_/B _2132_/X VGND VGND VPWR VPWR _2138_/A sky130_fd_sc_hd__a21o_2
X_2064_ _2064_/A _2028_/A VGND VGND VPWR VPWR _2064_/X sky130_fd_sc_hd__or2b_2
X_1917_ _2018_/A _1917_/B VGND VGND VPWR VPWR _1958_/A sky130_fd_sc_hd__xor2_2
Xhold610 hold610/A VGND VGND VPWR VPWR hold610/X sky130_fd_sc_hd__clkbuf_2
Xhold621 hold621/A VGND VGND VPWR VPWR hold621/X sky130_fd_sc_hd__clkbuf_2
Xhold632 a_in[3] VGND VGND VPWR VPWR hold632/X sky130_fd_sc_hd__clkbuf_2
Xhold643 _2566_/C VGND VGND VPWR VPWR hold643/X sky130_fd_sc_hd__clkbuf_2
Xhold654 hold654/A VGND VGND VPWR VPWR hold654/X sky130_fd_sc_hd__clkbuf_2
Xhold665 hold665/A VGND VGND VPWR VPWR hold665/X sky130_fd_sc_hd__clkbuf_2
Xhold676 hold676/A VGND VGND VPWR VPWR hold676/X sky130_fd_sc_hd__clkbuf_2
Xmax_cap395 _1764_/A VGND VGND VPWR VPWR _1598_/A sky130_fd_sc_hd__buf_8
X_1848_ _2230_/A _1848_/B VGND VGND VPWR VPWR _2672_/D sky130_fd_sc_hd__nor2_2
X_1779_ _1779_/A _1779_/B VGND VGND VPWR VPWR _1780_/B sky130_fd_sc_hd__xnor2_2
XFILLER_17_219 VGND VGND VPWR VPWR sky130_fd_sc_hd__decap_3
XFILLER_43_55 VGND VGND VPWR VPWR sky130_fd_sc_hd__fill_1
XFILLER_40_277 VGND VGND VPWR VPWR sky130_fd_sc_hd__decap_3
XFILLER_40_299 VGND VGND VPWR VPWR sky130_fd_sc_hd__decap_3
XFILLER_43_66 VGND VGND VPWR VPWR sky130_fd_sc_hd__decap_3
XFILLER_4_112 VGND VGND VPWR VPWR sky130_fd_sc_hd__decap_3
XFILLER_16_241 VGND VGND VPWR VPWR sky130_fd_sc_hd__fill_2
XTAP_TAPCELL_ROW_18_236 VGND VPWR sky130_fd_sc_hd__tapvpwrvgnd_1
Xplace303 _2498_/A VGND VGND VPWR VPWR _2550_/B1 sky130_fd_sc_hd__buf_1
XTAP_TAPCELL_ROW_26_280 VGND VPWR sky130_fd_sc_hd__tapvpwrvgnd_1
X_1564_ _1564_/A _1564_/B VGND VGND VPWR VPWR _1565_/B sky130_fd_sc_hd__nor2_2
X_1633_ _1700_/A2 _1697_/B _1677_/B1 _1710_/A2 VGND VGND VPWR VPWR _1634_/B sky130_fd_sc_hd__a22o_2
X_2682_ clkload7/A _2682_/D VGND VGND VPWR VPWR _2682_/Q sky130_fd_sc_hd__dfxtp_2
X_1702_ _2622_/Q _1379_/X _1702_/A3 _1702_/B1 _2623_/Q VGND VGND VPWR VPWR _1703_/B
+ sky130_fd_sc_hd__a32o_2
XFILLER_54_303 VGND VGND VPWR VPWR sky130_fd_sc_hd__decap_3
X_1495_ _1598_/A _1495_/B VGND VGND VPWR VPWR _1496_/B sky130_fd_sc_hd__xnor2_2
X_2116_ _2116_/A _2116_/B VGND VGND VPWR VPWR _2117_/B sky130_fd_sc_hd__nand2_2
X_2047_ _2197_/B _2047_/B VGND VGND VPWR VPWR _2093_/B sky130_fd_sc_hd__xnor2_2
XFILLER_13_69 VGND VGND VPWR VPWR sky130_fd_sc_hd__decap_3
XFILLER_1_159 VGND VGND VPWR VPWR sky130_fd_sc_hd__fill_1
XFILLER_49_108 VGND VGND VPWR VPWR sky130_fd_sc_hd__decap_3
Xhold495 b_in[1] VGND VGND VPWR VPWR hold495/X sky130_fd_sc_hd__clkbuf_2
Xhold484 hold588/X VGND VGND VPWR VPWR _2603_/B sky130_fd_sc_hd__clkbuf_2
Xhold473 _2554_/X VGND VGND VPWR VPWR _2631_/D sky130_fd_sc_hd__clkbuf_2
Xhold462 hold575/X VGND VGND VPWR VPWR hold576/A sky130_fd_sc_hd__clkbuf_2
Xhold451 hold532/X VGND VGND VPWR VPWR _2604_/A sky130_fd_sc_hd__clkbuf_2
Xhold440 _2542_/X VGND VGND VPWR VPWR _2625_/D sky130_fd_sc_hd__clkbuf_2
XFILLER_38_22 VGND VGND VPWR VPWR sky130_fd_sc_hd__decap_3
XFILLER_38_88 VGND VGND VPWR VPWR sky130_fd_sc_hd__decap_3
XFILLER_45_303 VGND VGND VPWR VPWR sky130_fd_sc_hd__fill_1
XFILLER_54_32 VGND VGND VPWR VPWR sky130_fd_sc_hd__decap_3
XFILLER_13_211 VGND VGND VPWR VPWR sky130_fd_sc_hd__decap_3
XFILLER_48_141 VGND VGND VPWR VPWR sky130_fd_sc_hd__decap_3
Xplace199 _2450_/Y VGND VGND VPWR VPWR _2524_/B1 sky130_fd_sc_hd__buf_1
X_1547_ _1545_/A _1547_/B VGND VGND VPWR VPWR _1547_/X sky130_fd_sc_hd__and2b_2
X_1616_ _1616_/A _1616_/B VGND VGND VPWR VPWR _1618_/B sky130_fd_sc_hd__xor2_2
X_2665_ clkload6/A _2665_/D VGND VGND VPWR VPWR _2665_/Q sky130_fd_sc_hd__dfxtp_2
X_2596_ _2602_/A1 _1361_/A _2611_/C1 _2595_/X VGND VGND VPWR VPWR _2596_/X sky130_fd_sc_hd__o211a_2
XFILLER_39_152 VGND VGND VPWR VPWR sky130_fd_sc_hd__decap_3
XFILLER_54_144 VGND VGND VPWR VPWR sky130_fd_sc_hd__decap_3
X_1478_ _1727_/A _1478_/A2 _1600_/A2 _1727_/B VGND VGND VPWR VPWR _1479_/B sky130_fd_sc_hd__a22o_2
XFILLER_10_203 VGND VGND VPWR VPWR sky130_fd_sc_hd__fill_1
XTAP_TAPCELL_ROW_37_342 VGND VPWR sky130_fd_sc_hd__tapvpwrvgnd_1
XFILLER_40_23 VGND VGND VPWR VPWR sky130_fd_sc_hd__decap_3
XFILLER_6_229 VGND VGND VPWR VPWR sky130_fd_sc_hd__decap_3
XFILLER_49_32 VGND VGND VPWR VPWR sky130_fd_sc_hd__decap_3
XFILLER_60_136 VGND VGND VPWR VPWR sky130_fd_sc_hd__decap_3
XFILLER_5_251 VGND VGND VPWR VPWR sky130_fd_sc_hd__fill_1
XFILLER_5_284 VGND VGND VPWR VPWR sky130_fd_sc_hd__decap_3
X_1401_ _1604_/A _1401_/B VGND VGND VPWR VPWR _1437_/B sky130_fd_sc_hd__xor2_2
X_2450_ _2442_/Y _2449_/Y _2327_/Y _1792_/X VGND VGND VPWR VPWR _2450_/Y sky130_fd_sc_hd__a211oi_2
X_2381_ _2427_/B VGND VGND VPWR VPWR _2472_/B sky130_fd_sc_hd__inv_2
XFILLER_36_144 VGND VGND VPWR VPWR sky130_fd_sc_hd__decap_3
X_1332_ _2700_/Q _1331_/B _2708_/A VGND VGND VPWR VPWR _1333_/B sky130_fd_sc_hd__o21ai_2
XFILLER_51_169 VGND VGND VPWR VPWR sky130_fd_sc_hd__fill_1
XTAP_TAPCELL_ROW_34_323 VGND VPWR sky130_fd_sc_hd__tapvpwrvgnd_1
XFILLER_59_258 VGND VGND VPWR VPWR sky130_fd_sc_hd__fill_2
Xoutput353 _1728_/A2 VGND VGND VPWR VPWR a_out[1] sky130_fd_sc_hd__buf_2
Xoutput364 _1329_/Y VGND VGND VPWR VPWR acc_out[11] sky130_fd_sc_hd__buf_2
Xoutput375 _1321_/X VGND VGND VPWR VPWR acc_out[7] sky130_fd_sc_hd__buf_2
Xoutput386 _2640_/Q VGND VGND VPWR VPWR b_out[2] sky130_fd_sc_hd__buf_2
X_2648_ clkload5/A _2648_/D VGND VGND VPWR VPWR _2648_/Q sky130_fd_sc_hd__dfxtp_2
X_2579_ _2579_/A _2641_/Q VGND VGND VPWR VPWR _2579_/X sky130_fd_sc_hd__or2_2
XFILLER_35_67 VGND VGND VPWR VPWR sky130_fd_sc_hd__fill_2
XFILLER_30_309 VGND VGND VPWR VPWR sky130_fd_sc_hd__fill_2
XFILLER_42_169 VGND VGND VPWR VPWR sky130_fd_sc_hd__decap_3
XFILLER_51_77 VGND VGND VPWR VPWR sky130_fd_sc_hd__fill_1
XTAP_TAPCELL_ROW_40_359 VGND VPWR sky130_fd_sc_hd__tapvpwrvgnd_1
XFILLER_2_210 VGND VGND VPWR VPWR sky130_fd_sc_hd__decap_3
XTAP_TAPCELL_ROW_48_404 VGND VPWR sky130_fd_sc_hd__tapvpwrvgnd_1
XFILLER_18_144 VGND VGND VPWR VPWR sky130_fd_sc_hd__decap_3
XFILLER_18_166 VGND VGND VPWR VPWR sky130_fd_sc_hd__fill_1
XFILLER_33_136 VGND VGND VPWR VPWR sky130_fd_sc_hd__decap_3
XFILLER_33_169 VGND VGND VPWR VPWR sky130_fd_sc_hd__fill_2
X_1950_ _1945_/Y _1994_/A _1948_/Y _1949_/Y _2591_/A VGND VGND VPWR VPWR _1951_/B
+ sky130_fd_sc_hd__o32a_2
X_2502_ _2525_/A _2502_/B VGND VGND VPWR VPWR _2697_/D sky130_fd_sc_hd__and2_2
X_1881_ _1930_/B _1881_/B VGND VGND VPWR VPWR _1933_/A sky130_fd_sc_hd__or2_2
XFILLER_51_3 VGND VGND VPWR VPWR sky130_fd_sc_hd__fill_1
X_1315_ _2692_/Q _1315_/B VGND VGND VPWR VPWR _1315_/Y sky130_fd_sc_hd__xnor2_2
X_2433_ _2685_/Q _2342_/B _2415_/Y _2354_/A VGND VGND VPWR VPWR _2448_/A sky130_fd_sc_hd__o211ai_2
X_2364_ _2437_/B _2364_/B VGND VGND VPWR VPWR _2431_/A sky130_fd_sc_hd__nand2_2
XFILLER_56_206 VGND VGND VPWR VPWR sky130_fd_sc_hd__decap_3
X_2295_ _2295_/A _2295_/B _2294_/Y VGND VGND VPWR VPWR _2312_/A sky130_fd_sc_hd__or3b_2
XANTENNA_10 hold575/X VGND VGND VPWR VPWR sky130_fd_sc_hd__diode_2
XFILLER_12_309 VGND VGND VPWR VPWR sky130_fd_sc_hd__decap_3
XFILLER_24_169 VGND VGND VPWR VPWR sky130_fd_sc_hd__decap_3
XFILLER_21_36 VGND VGND VPWR VPWR sky130_fd_sc_hd__decap_3
XFILLER_47_206 VGND VGND VPWR VPWR sky130_fd_sc_hd__decap_3
XFILLER_47_239 VGND VGND VPWR VPWR sky130_fd_sc_hd__fill_2
XFILLER_15_147 VGND VGND VPWR VPWR sky130_fd_sc_hd__fill_2
XFILLER_15_169 VGND VGND VPWR VPWR sky130_fd_sc_hd__decap_3
XFILLER_30_106 VGND VGND VPWR VPWR sky130_fd_sc_hd__decap_3
Xclkbuf_4_9_0_clk clkbuf_0_clk/X VGND VGND VPWR VPWR clkload7/A sky130_fd_sc_hd__clkbuf_8
XFILLER_38_206 VGND VGND VPWR VPWR sky130_fd_sc_hd__decap_3
XFILLER_46_272 VGND VGND VPWR VPWR sky130_fd_sc_hd__decap_3
XFILLER_61_242 VGND VGND VPWR VPWR sky130_fd_sc_hd__decap_3
XFILLER_61_275 VGND VGND VPWR VPWR sky130_fd_sc_hd__decap_3
X_1933_ _1933_/A _1933_/B VGND VGND VPWR VPWR _1933_/Y sky130_fd_sc_hd__nor2_2
X_1864_ _2630_/Q _2019_/A2 _2019_/A3 _1416_/X _2631_/Q VGND VGND VPWR VPWR _1865_/B
+ sky130_fd_sc_hd__a32o_2
X_1795_ _2591_/A _2333_/B _1791_/Y _1794_/X VGND VGND VPWR VPWR _1796_/B sky130_fd_sc_hd__o22a_2
XFILLER_29_217 VGND VGND VPWR VPWR sky130_fd_sc_hd__decap_3
XFILLER_29_228 VGND VGND VPWR VPWR sky130_fd_sc_hd__fill_1
X_2416_ _2354_/A _2685_/Q _2342_/B _2415_/Y VGND VGND VPWR VPWR _2416_/X sky130_fd_sc_hd__a211o_2
X_2347_ _2684_/Q _2347_/B VGND VGND VPWR VPWR _2412_/B sky130_fd_sc_hd__xnor2_2
X_2278_ _2276_/Y _2278_/B VGND VGND VPWR VPWR _2279_/B sky130_fd_sc_hd__and2b_2
XFILLER_12_106 VGND VGND VPWR VPWR sky130_fd_sc_hd__fill_2
XFILLER_52_253 VGND VGND VPWR VPWR sky130_fd_sc_hd__decap_3
XFILLER_32_13 VGND VGND VPWR VPWR sky130_fd_sc_hd__fill_1
XFILLER_32_46 VGND VGND VPWR VPWR sky130_fd_sc_hd__decap_3
XTAP_TAPCELL_ROW_50_410 VGND VPWR sky130_fd_sc_hd__tapvpwrvgnd_1
XFILLER_28_283 VGND VGND VPWR VPWR sky130_fd_sc_hd__decap_3
XFILLER_35_209 VGND VGND VPWR VPWR sky130_fd_sc_hd__decap_3
XTAP_TAPCELL_ROW_7_176 VGND VPWR sky130_fd_sc_hd__tapvpwrvgnd_1
XFILLER_43_253 VGND VGND VPWR VPWR sky130_fd_sc_hd__decap_3
XFILLER_43_264 VGND VGND VPWR VPWR sky130_fd_sc_hd__decap_3
XFILLER_43_297 VGND VGND VPWR VPWR sky130_fd_sc_hd__fill_1
XFILLER_11_172 VGND VGND VPWR VPWR sky130_fd_sc_hd__decap_3
XFILLER_11_194 VGND VGND VPWR VPWR sky130_fd_sc_hd__decap_3
XFILLER_7_165 VGND VGND VPWR VPWR sky130_fd_sc_hd__decap_3
XFILLER_7_187 VGND VGND VPWR VPWR sky130_fd_sc_hd__fill_1
X_1580_ _1580_/A _1580_/B VGND VGND VPWR VPWR _1785_/A sky130_fd_sc_hd__xnor2_2
XFILLER_14_3 VGND VGND VPWR VPWR sky130_fd_sc_hd__fill_1
X_2201_ _2201_/A _2201_/B VGND VGND VPWR VPWR _2207_/A sky130_fd_sc_hd__and2_2
X_2132_ _2132_/A _2132_/B VGND VGND VPWR VPWR _2132_/X sky130_fd_sc_hd__and2_2
XFILLER_19_250 VGND VGND VPWR VPWR sky130_fd_sc_hd__decap_3
XFILLER_34_231 VGND VGND VPWR VPWR sky130_fd_sc_hd__fill_1
XFILLER_34_253 VGND VGND VPWR VPWR sky130_fd_sc_hd__decap_3
XPHY_EDGE_ROW_14_Left_79 VGND VGND VPWR VPWR sky130_fd_sc_hd__decap_3
X_2063_ _2063_/A _2063_/B VGND VGND VPWR VPWR _2107_/A sky130_fd_sc_hd__xnor2_2
X_1916_ _1916_/A1 _2017_/A2 _2017_/A3 _1916_/B1 _2634_/Q VGND VGND VPWR VPWR _1917_/B
+ sky130_fd_sc_hd__a32o_2
X_1847_ _1792_/A _2672_/Q _1792_/X _1846_/Y VGND VGND VPWR VPWR _1848_/B sky130_fd_sc_hd__o2bb2a_2
XFILLER_1_319 VGND VGND VPWR VPWR sky130_fd_sc_hd__fill_1
Xhold600 hold600/A VGND VGND VPWR VPWR _1792_/B sky130_fd_sc_hd__clkbuf_2
Xhold611 _2568_/D VGND VGND VPWR VPWR hold611/X sky130_fd_sc_hd__clkbuf_2
Xhold622 hold622/A VGND VGND VPWR VPWR hold622/X sky130_fd_sc_hd__clkbuf_2
Xhold633 hold633/A VGND VGND VPWR VPWR hold633/X sky130_fd_sc_hd__clkbuf_2
Xhold644 a_in[7] VGND VGND VPWR VPWR hold644/X sky130_fd_sc_hd__clkbuf_2
Xhold655 _2569_/B VGND VGND VPWR VPWR hold655/X sky130_fd_sc_hd__clkbuf_2
Xhold666 hold666/A VGND VGND VPWR VPWR hold666/X sky130_fd_sc_hd__clkbuf_2
Xhold677 compute_enable VGND VGND VPWR VPWR hold677/X sky130_fd_sc_hd__clkbuf_2
Xmax_cap396 _1572_/A VGND VGND VPWR VPWR _1604_/A sky130_fd_sc_hd__buf_8
X_1778_ _1576_/A _1576_/B _1777_/X VGND VGND VPWR VPWR _1779_/B sky130_fd_sc_hd__a21oi_2
XFILLER_57_312 VGND VGND VPWR VPWR sky130_fd_sc_hd__decap_3
XTAP_TAPCELL_ROW_4_157 VGND VPWR sky130_fd_sc_hd__tapvpwrvgnd_1
XFILLER_25_253 VGND VGND VPWR VPWR sky130_fd_sc_hd__decap_3
XFILLER_40_256 VGND VGND VPWR VPWR sky130_fd_sc_hd__fill_2
XFILLER_40_289 VGND VGND VPWR VPWR sky130_fd_sc_hd__fill_2
XFILLER_16_253 VGND VGND VPWR VPWR sky130_fd_sc_hd__decap_3
XTAP_TAPCELL_ROW_18_237 VGND VPWR sky130_fd_sc_hd__tapvpwrvgnd_1
Xplace304 _2498_/A VGND VGND VPWR VPWR _2528_/A sky130_fd_sc_hd__buf_1
XFILLER_16_297 VGND VGND VPWR VPWR sky130_fd_sc_hd__decap_3
XTAP_TAPCELL_ROW_26_281 VGND VPWR sky130_fd_sc_hd__tapvpwrvgnd_1
X_2681_ clkload7/A _2681_/D VGND VGND VPWR VPWR _2681_/Q sky130_fd_sc_hd__dfxtp_2
X_1701_ _1701_/A _1701_/B VGND VGND VPWR VPWR _1708_/A sky130_fd_sc_hd__xnor2_2
X_1494_ _1555_/A _1494_/B VGND VGND VPWR VPWR _1495_/B sky130_fd_sc_hd__nand2_2
X_1563_ _1564_/A _1564_/B VGND VGND VPWR VPWR _1565_/A sky130_fd_sc_hd__and2_2
X_1632_ _1635_/A _1635_/B VGND VGND VPWR VPWR _1655_/A sky130_fd_sc_hd__xor2_2
X_2115_ _2116_/A _2116_/B VGND VGND VPWR VPWR _2117_/A sky130_fd_sc_hd__or2_2
X_2046_ _2265_/B2 _1420_/A _2125_/C _1416_/X _2635_/Q VGND VGND VPWR VPWR _2047_/B
+ sky130_fd_sc_hd__a32o_2
XFILLER_22_278 VGND VGND VPWR VPWR sky130_fd_sc_hd__fill_2
Xhold496 hold496/A VGND VGND VPWR VPWR hold496/X sky130_fd_sc_hd__clkbuf_2
Xhold485 _2590_/X VGND VGND VPWR VPWR _2646_/D sky130_fd_sc_hd__clkbuf_2
Xhold474 hold554/X VGND VGND VPWR VPWR hold555/A sky130_fd_sc_hd__clkbuf_2
Xhold463 hold577/X VGND VGND VPWR VPWR _2606_/D sky130_fd_sc_hd__clkbuf_2
Xhold452 _2600_/X VGND VGND VPWR VPWR _2651_/D sky130_fd_sc_hd__clkbuf_2
Xhold441 hold640/X VGND VGND VPWR VPWR hold641/A sky130_fd_sc_hd__clkbuf_2
Xhold430 hold626/X VGND VGND VPWR VPWR _2569_/A sky130_fd_sc_hd__clkbuf_2
XFILLER_38_67 VGND VGND VPWR VPWR sky130_fd_sc_hd__decap_3
XFILLER_54_22 VGND VGND VPWR VPWR sky130_fd_sc_hd__decap_3
XFILLER_54_44 VGND VGND VPWR VPWR sky130_fd_sc_hd__fill_1
XFILLER_57_175 VGND VGND VPWR VPWR sky130_fd_sc_hd__decap_3
XFILLER_60_318 VGND VGND VPWR VPWR sky130_fd_sc_hd__fill_2
XFILLER_13_256 VGND VGND VPWR VPWR sky130_fd_sc_hd__decap_3
XFILLER_13_289 VGND VGND VPWR VPWR sky130_fd_sc_hd__decap_3
XFILLER_54_88 VGND VGND VPWR VPWR sky130_fd_sc_hd__fill_2
XFILLER_9_216 VGND VGND VPWR VPWR sky130_fd_sc_hd__fill_1
XTAP_TAPCELL_ROW_15_218 VGND VPWR sky130_fd_sc_hd__tapvpwrvgnd_1
XTAP_TAPCELL_ROW_23_262 VGND VPWR sky130_fd_sc_hd__tapvpwrvgnd_1
XFILLER_48_120 VGND VGND VPWR VPWR sky130_fd_sc_hd__decap_3
XFILLER_51_307 VGND VGND VPWR VPWR sky130_fd_sc_hd__decap_3
XFILLER_63_178 VGND VGND VPWR VPWR sky130_fd_sc_hd__decap_3
XFILLER_8_271 VGND VGND VPWR VPWR sky130_fd_sc_hd__decap_3
X_2664_ clkload3/A _2664_/D VGND VGND VPWR VPWR _2664_/Q sky130_fd_sc_hd__dfxtp_2
X_1477_ _1477_/A _1477_/B VGND VGND VPWR VPWR _1741_/A sky130_fd_sc_hd__xnor2_2
X_1546_ _1546_/A _1546_/B VGND VGND VPWR VPWR _1546_/X sky130_fd_sc_hd__xor2_2
X_1615_ _1611_/Y _1643_/B _1614_/Y VGND VGND VPWR VPWR _1618_/A sky130_fd_sc_hd__a21o_2
X_2595_ _2608_/A _2649_/Q VGND VGND VPWR VPWR _2595_/X sky130_fd_sc_hd__or2_2
XFILLER_39_175 VGND VGND VPWR VPWR sky130_fd_sc_hd__fill_1
XFILLER_42_318 VGND VGND VPWR VPWR sky130_fd_sc_hd__fill_2
XTAP_TAPCELL_ROW_37_343 VGND VPWR sky130_fd_sc_hd__tapvpwrvgnd_1
XFILLER_10_237 VGND VGND VPWR VPWR sky130_fd_sc_hd__decap_3
XPHY_EDGE_ROW_17_Left_82 VGND VGND VPWR VPWR sky130_fd_sc_hd__decap_3
X_2029_ _2029_/A _2029_/B VGND VGND VPWR VPWR _2031_/C sky130_fd_sc_hd__xor2_2
XFILLER_49_11 VGND VGND VPWR VPWR sky130_fd_sc_hd__decap_3
XFILLER_18_315 VGND VGND VPWR VPWR sky130_fd_sc_hd__fill_1
XFILLER_49_55 VGND VGND VPWR VPWR sky130_fd_sc_hd__fill_1
XFILLER_49_77 VGND VGND VPWR VPWR sky130_fd_sc_hd__fill_1
XFILLER_45_123 VGND VGND VPWR VPWR sky130_fd_sc_hd__decap_3
X_1331_ _2700_/Q _1331_/B VGND VGND VPWR VPWR _1331_/X sky130_fd_sc_hd__xor2_2
X_1400_ _1600_/A2 _1603_/A2 _1702_/A3 _1709_/B _1478_/A2 VGND VGND VPWR VPWR _1401_/B
+ sky130_fd_sc_hd__a32o_2
X_2380_ _2691_/Q _2391_/B VGND VGND VPWR VPWR _2427_/B sky130_fd_sc_hd__nor2_2
XFILLER_36_134 VGND VGND VPWR VPWR sky130_fd_sc_hd__fill_1
XFILLER_36_189 VGND VGND VPWR VPWR sky130_fd_sc_hd__fill_2
XFILLER_51_104 VGND VGND VPWR VPWR sky130_fd_sc_hd__decap_3
XTAP_TAPCELL_ROW_34_324 VGND VPWR sky130_fd_sc_hd__tapvpwrvgnd_1
XFILLER_10_27 VGND VGND VPWR VPWR sky130_fd_sc_hd__fill_1
X_2647_ _2668_/CLK _2647_/D VGND VGND VPWR VPWR _2647_/Q sky130_fd_sc_hd__dfxtp_2
XFILLER_59_215 VGND VGND VPWR VPWR sky130_fd_sc_hd__fill_1
XFILLER_59_237 VGND VGND VPWR VPWR sky130_fd_sc_hd__decap_3
X_1529_ _1529_/A _1529_/B VGND VGND VPWR VPWR _1530_/B sky130_fd_sc_hd__xor2_2
Xoutput354 _1700_/B1 VGND VGND VPWR VPWR a_out[2] sky130_fd_sc_hd__buf_2
Xoutput365 _1331_/X VGND VGND VPWR VPWR acc_out[12] sky130_fd_sc_hd__buf_2
Xoutput376 _1323_/X VGND VGND VPWR VPWR acc_out[8] sky130_fd_sc_hd__buf_2
Xoutput387 _2641_/Q VGND VGND VPWR VPWR b_out[3] sky130_fd_sc_hd__buf_2
X_2578_ _2580_/A1 hold503/X _2580_/B1 _2577_/X VGND VGND VPWR VPWR _2578_/X sky130_fd_sc_hd__o211a_2
XFILLER_27_167 VGND VGND VPWR VPWR sky130_fd_sc_hd__fill_1
XTAP_TAPCELL_ROW_57_449 VGND VPWR sky130_fd_sc_hd__tapvpwrvgnd_1
XFILLER_51_23 VGND VGND VPWR VPWR sky130_fd_sc_hd__fill_2
XFILLER_51_34 VGND VGND VPWR VPWR sky130_fd_sc_hd__decap_3
XPHY_EDGE_ROW_14_Right_14 VGND VGND VPWR VPWR sky130_fd_sc_hd__decap_3
XPHY_EDGE_ROW_2_Left_67 VGND VGND VPWR VPWR sky130_fd_sc_hd__decap_3
XFILLER_2_244 VGND VGND VPWR VPWR sky130_fd_sc_hd__fill_1
XFILLER_2_266 VGND VGND VPWR VPWR sky130_fd_sc_hd__fill_2
XPHY_EDGE_ROW_23_Right_23 VGND VGND VPWR VPWR sky130_fd_sc_hd__decap_3
XFILLER_18_123 VGND VGND VPWR VPWR sky130_fd_sc_hd__decap_3
XFILLER_33_104 VGND VGND VPWR VPWR sky130_fd_sc_hd__decap_3
XFILLER_41_192 VGND VGND VPWR VPWR sky130_fd_sc_hd__decap_3
XPHY_EDGE_ROW_32_Right_32 VGND VGND VPWR VPWR sky130_fd_sc_hd__decap_3
X_1880_ _1880_/A _1880_/B VGND VGND VPWR VPWR _1881_/B sky130_fd_sc_hd__nor2_2
X_2501_ _2697_/Q _2524_/A2 _2524_/B1 _2500_/X VGND VGND VPWR VPWR _2502_/B sky130_fd_sc_hd__a22o_2
XFILLER_44_3 VGND VGND VPWR VPWR sky130_fd_sc_hd__decap_3
XFILLER_56_218 VGND VGND VPWR VPWR sky130_fd_sc_hd__decap_3
XPHY_EDGE_ROW_41_Right_41 VGND VGND VPWR VPWR sky130_fd_sc_hd__decap_3
X_1314_ _1314_/A _1314_/B VGND VGND VPWR VPWR _1315_/B sky130_fd_sc_hd__nand2_2
X_2432_ _2437_/C _2432_/B VGND VGND VPWR VPWR _2496_/A sky130_fd_sc_hd__and2_2
X_2363_ _2696_/Q _2363_/B VGND VGND VPWR VPWR _2364_/B sky130_fd_sc_hd__or2_2
X_2294_ _2294_/A _2294_/B VGND VGND VPWR VPWR _2294_/Y sky130_fd_sc_hd__nand2_2
XFILLER_49_281 VGND VGND VPWR VPWR sky130_fd_sc_hd__decap_3
XFILLER_64_240 VGND VGND VPWR VPWR sky130_fd_sc_hd__decap_3
XFILLER_64_262 VGND VGND VPWR VPWR sky130_fd_sc_hd__decap_3
XPHY_EDGE_ROW_50_Right_50 VGND VGND VPWR VPWR sky130_fd_sc_hd__decap_3
XANTENNA_11 b_in[4] VGND VGND VPWR VPWR sky130_fd_sc_hd__diode_2
XFILLER_46_56 VGND VGND VPWR VPWR sky130_fd_sc_hd__decap_3
XFILLER_30_118 VGND VGND VPWR VPWR sky130_fd_sc_hd__decap_3
XFILLER_55_284 VGND VGND VPWR VPWR sky130_fd_sc_hd__decap_3
XTAP_TAPCELL_ROW_53_430 VGND VPWR sky130_fd_sc_hd__tapvpwrvgnd_1
XFILLER_61_254 VGND VGND VPWR VPWR sky130_fd_sc_hd__decap_3
XFILLER_61_287 VGND VGND VPWR VPWR sky130_fd_sc_hd__decap_3
X_1932_ _1932_/A _1932_/B VGND VGND VPWR VPWR _1987_/A sky130_fd_sc_hd__xnor2_2
X_1863_ _2018_/A _1863_/B VGND VGND VPWR VPWR _1867_/A sky130_fd_sc_hd__xor2_2
X_2415_ _2703_/Q VGND VGND VPWR VPWR _2415_/Y sky130_fd_sc_hd__inv_2
X_1794_ _1790_/Y _1591_/X _1744_/Y _1792_/X VGND VGND VPWR VPWR _1794_/X sky130_fd_sc_hd__a31o_2
X_2346_ _2354_/A _2346_/B VGND VGND VPWR VPWR _2347_/B sky130_fd_sc_hd__and2_2
X_2277_ _2278_/B _2276_/Y VGND VGND VPWR VPWR _2303_/A sky130_fd_sc_hd__nor2b_2
XFILLER_37_295 VGND VGND VPWR VPWR sky130_fd_sc_hd__fill_2
XFILLER_52_210 VGND VGND VPWR VPWR sky130_fd_sc_hd__fill_2
XFILLER_52_276 VGND VGND VPWR VPWR sky130_fd_sc_hd__decap_3
XTAP_TAPCELL_ROW_50_411 VGND VPWR sky130_fd_sc_hd__tapvpwrvgnd_1
XFILLER_20_151 VGND VGND VPWR VPWR sky130_fd_sc_hd__decap_3
XTAP_TAPCELL_ROW_7_177 VGND VPWR sky130_fd_sc_hd__tapvpwrvgnd_1
XFILLER_28_262 VGND VGND VPWR VPWR sky130_fd_sc_hd__decap_3
XFILLER_43_276 VGND VGND VPWR VPWR sky130_fd_sc_hd__decap_3
XFILLER_7_111 VGND VGND VPWR VPWR sky130_fd_sc_hd__fill_1
XPHY_EDGE_ROW_5_Left_70 VGND VGND VPWR VPWR sky130_fd_sc_hd__decap_3
X_2200_ _2240_/A _2199_/X VGND VGND VPWR VPWR _2233_/A sky130_fd_sc_hd__or2b_2
X_2131_ _2131_/A _2131_/B VGND VGND VPWR VPWR _2139_/A sky130_fd_sc_hd__nand2_2
X_2062_ _2062_/A _2062_/B VGND VGND VPWR VPWR _2063_/B sky130_fd_sc_hd__xor2_2
XFILLER_19_284 VGND VGND VPWR VPWR sky130_fd_sc_hd__fill_1
XFILLER_8_82 VGND VGND VPWR VPWR sky130_fd_sc_hd__fill_2
Xhold601 _1370_/Y VGND VGND VPWR VPWR hold601/X sky130_fd_sc_hd__clkbuf_2
Xhold612 a_in[0] VGND VGND VPWR VPWR hold612/X sky130_fd_sc_hd__clkbuf_2
X_1915_ _1915_/A _1915_/B VGND VGND VPWR VPWR _1936_/A sky130_fd_sc_hd__xor2_2
X_1846_ _1846_/A _1846_/B VGND VGND VPWR VPWR _1846_/Y sky130_fd_sc_hd__xnor2_2
X_1777_ _1777_/A _1777_/B VGND VGND VPWR VPWR _1777_/X sky130_fd_sc_hd__and2_2
XFILLER_57_302 VGND VGND VPWR VPWR sky130_fd_sc_hd__decap_3
XPHY_EDGE_ROW_4_Right_4 VGND VGND VPWR VPWR sky130_fd_sc_hd__decap_3
Xhold623 _2568_/A VGND VGND VPWR VPWR hold623/X sky130_fd_sc_hd__clkbuf_2
Xhold634 hold634/A VGND VGND VPWR VPWR hold634/X sky130_fd_sc_hd__clkbuf_2
Xhold645 hold645/A VGND VGND VPWR VPWR hold645/X sky130_fd_sc_hd__clkbuf_2
Xhold656 b_in[5] VGND VGND VPWR VPWR hold656/X sky130_fd_sc_hd__clkbuf_2
Xhold667 _2566_/B VGND VGND VPWR VPWR hold667/X sky130_fd_sc_hd__clkbuf_2
Xhold678 hold678/A VGND VGND VPWR VPWR hold678/X sky130_fd_sc_hd__clkbuf_2
Xmax_cap397 _2020_/A VGND VGND VPWR VPWR _1919_/A sky130_fd_sc_hd__buf_8
XFILLER_25_232 VGND VGND VPWR VPWR sky130_fd_sc_hd__decap_3
XTAP_TAPCELL_ROW_4_158 VGND VPWR sky130_fd_sc_hd__tapvpwrvgnd_1
X_2329_ _2446_/A _2329_/B VGND VGND VPWR VPWR _2329_/Y sky130_fd_sc_hd__nor2_2
XFILLER_40_268 VGND VGND VPWR VPWR sky130_fd_sc_hd__decap_3
XFILLER_43_57 VGND VGND VPWR VPWR sky130_fd_sc_hd__decap_3
Xclkbuf_4_8_0_clk clkbuf_0_clk/X VGND VGND VPWR VPWR _2696_/CLK sky130_fd_sc_hd__clkbuf_8
XPHY_EDGE_ROW_31_Left_96 VGND VGND VPWR VPWR sky130_fd_sc_hd__decap_3
XFILLER_16_232 VGND VGND VPWR VPWR sky130_fd_sc_hd__fill_1
XFILLER_16_276 VGND VGND VPWR VPWR sky130_fd_sc_hd__decap_3
XFILLER_63_316 VGND VGND VPWR VPWR sky130_fd_sc_hd__decap_3
XTAP_TAPCELL_ROW_18_238 VGND VPWR sky130_fd_sc_hd__tapvpwrvgnd_1
XTAP_TAPCELL_ROW_26_282 VGND VPWR sky130_fd_sc_hd__tapvpwrvgnd_1
Xplace305 _2498_/A VGND VGND VPWR VPWR _2525_/A sky130_fd_sc_hd__buf_1
XFILLER_31_268 VGND VGND VPWR VPWR sky130_fd_sc_hd__decap_3
XFILLER_31_279 VGND VGND VPWR VPWR sky130_fd_sc_hd__fill_1
X_1631_ _1772_/A _1631_/B VGND VGND VPWR VPWR _1635_/B sky130_fd_sc_hd__xor2_2
X_2680_ _2696_/CLK _2680_/D VGND VGND VPWR VPWR _2680_/Q sky130_fd_sc_hd__dfxtp_2
X_1700_ _1700_/A1 _1700_/A2 _1700_/B1 _1700_/B2 VGND VGND VPWR VPWR _1701_/B sky130_fd_sc_hd__a22o_2
X_1493_ _1502_/A _1502_/B VGND VGND VPWR VPWR _1496_/A sky130_fd_sc_hd__xor2_2
X_1562_ _1919_/A _1562_/B VGND VGND VPWR VPWR _1564_/B sky130_fd_sc_hd__xnor2_2
X_2114_ _2114_/A VGND VGND VPWR VPWR _2114_/Y sky130_fd_sc_hd__inv_2
X_2045_ _2045_/A1 _2043_/X _2044_/X VGND VGND VPWR VPWR _2093_/A sky130_fd_sc_hd__a21o_2
XFILLER_22_213 VGND VGND VPWR VPWR sky130_fd_sc_hd__decap_3
XFILLER_22_224 VGND VGND VPWR VPWR sky130_fd_sc_hd__decap_3
XFILLER_22_235 VGND VGND VPWR VPWR sky130_fd_sc_hd__decap_3
Xhold453 hold566/X VGND VGND VPWR VPWR hold567/A sky130_fd_sc_hd__clkbuf_2
Xhold442 hold642/X VGND VGND VPWR VPWR _2566_/C sky130_fd_sc_hd__clkbuf_2
Xhold431 _2546_/X VGND VGND VPWR VPWR _2627_/D sky130_fd_sc_hd__clkbuf_2
Xhold420 hold636/X VGND VGND VPWR VPWR hold637/A sky130_fd_sc_hd__clkbuf_2
X_1829_ _1829_/A _1829_/B VGND VGND VPWR VPWR _1830_/B sky130_fd_sc_hd__xor2_2
XFILLER_38_13 VGND VGND VPWR VPWR sky130_fd_sc_hd__decap_3
XFILLER_38_79 VGND VGND VPWR VPWR sky130_fd_sc_hd__decap_3
XFILLER_57_143 VGND VGND VPWR VPWR sky130_fd_sc_hd__fill_2
Xhold497 hold497/A VGND VGND VPWR VPWR hold497/X sky130_fd_sc_hd__clkbuf_2
Xhold486 hold562/X VGND VGND VPWR VPWR hold563/A sky130_fd_sc_hd__clkbuf_2
Xhold475 hold556/X VGND VGND VPWR VPWR _2604_/B sky130_fd_sc_hd__clkbuf_2
Xhold464 _2586_/X VGND VGND VPWR VPWR _2644_/D sky130_fd_sc_hd__clkbuf_2
XFILLER_57_198 VGND VGND VPWR VPWR sky130_fd_sc_hd__decap_3
XTAP_TAPCELL_ROW_15_219 VGND VPWR sky130_fd_sc_hd__tapvpwrvgnd_1
XFILLER_21_290 VGND VGND VPWR VPWR sky130_fd_sc_hd__decap_3
XFILLER_9_228 VGND VGND VPWR VPWR sky130_fd_sc_hd__decap_3
XTAP_TAPCELL_ROW_23_263 VGND VPWR sky130_fd_sc_hd__tapvpwrvgnd_1
XFILLER_0_194 VGND VGND VPWR VPWR sky130_fd_sc_hd__fill_2
XFILLER_28_90 VGND VGND VPWR VPWR sky130_fd_sc_hd__decap_3
XFILLER_48_165 VGND VGND VPWR VPWR sky130_fd_sc_hd__decap_3
XFILLER_48_187 VGND VGND VPWR VPWR sky130_fd_sc_hd__decap_3
XFILLER_63_113 VGND VGND VPWR VPWR sky130_fd_sc_hd__decap_3
XTAP_TAPCELL_ROW_46_388 VGND VPWR sky130_fd_sc_hd__tapvpwrvgnd_1
X_1614_ _1642_/A _1642_/B VGND VGND VPWR VPWR _1614_/Y sky130_fd_sc_hd__nor2_2
X_2663_ clkload0/A _2663_/D VGND VGND VPWR VPWR _2663_/Q sky130_fd_sc_hd__dfxtp_2
X_2594_ _2602_/A1 _1359_/A _2611_/C1 _2593_/X VGND VGND VPWR VPWR _2594_/X sky130_fd_sc_hd__o211a_2
X_1476_ _1546_/A _1476_/B VGND VGND VPWR VPWR _1477_/B sky130_fd_sc_hd__nor2_2
X_1545_ _1545_/A _1547_/B VGND VGND VPWR VPWR _1546_/B sky130_fd_sc_hd__xnor2_2
XFILLER_24_15 VGND VGND VPWR VPWR sky130_fd_sc_hd__fill_2
XFILLER_39_198 VGND VGND VPWR VPWR sky130_fd_sc_hd__fill_1
XFILLER_54_113 VGND VGND VPWR VPWR sky130_fd_sc_hd__fill_1
X_2028_ _2028_/A _2064_/A VGND VGND VPWR VPWR _2029_/B sky130_fd_sc_hd__xnor2_2
XFILLER_40_58 VGND VGND VPWR VPWR sky130_fd_sc_hd__decap_3
XFILLER_45_113 VGND VGND VPWR VPWR sky130_fd_sc_hd__fill_1
XFILLER_5_220 VGND VGND VPWR VPWR sky130_fd_sc_hd__decap_3
XTAP_TAPCELL_ROW_11_200 VGND VPWR sky130_fd_sc_hd__tapvpwrvgnd_1
XFILLER_30_80 VGND VGND VPWR VPWR sky130_fd_sc_hd__decap_3
XFILLER_30_91 VGND VGND VPWR VPWR sky130_fd_sc_hd__decap_3
XFILLER_39_6 VGND VGND VPWR VPWR sky130_fd_sc_hd__decap_3
X_1330_ _2699_/Q _2698_/Q _1327_/B _2708_/A VGND VGND VPWR VPWR _1331_/B sky130_fd_sc_hd__o31a_2
XFILLER_36_113 VGND VGND VPWR VPWR sky130_fd_sc_hd__fill_1
XTAP_TAPCELL_ROW_34_325 VGND VPWR sky130_fd_sc_hd__tapvpwrvgnd_1
Xoutput355 _1700_/A2 VGND VGND VPWR VPWR a_out[3] sky130_fd_sc_hd__buf_2
Xoutput366 _1333_/Y VGND VGND VPWR VPWR acc_out[13] sky130_fd_sc_hd__buf_2
Xoutput377 _1325_/X VGND VGND VPWR VPWR acc_out[9] sky130_fd_sc_hd__buf_2
X_2646_ _2668_/CLK _2646_/D VGND VGND VPWR VPWR _2646_/Q sky130_fd_sc_hd__dfxtp_2
X_2577_ _2579_/A _2640_/Q VGND VGND VPWR VPWR _2577_/X sky130_fd_sc_hd__or2_2
XFILLER_27_113 VGND VGND VPWR VPWR sky130_fd_sc_hd__decap_3
XFILLER_59_249 VGND VGND VPWR VPWR sky130_fd_sc_hd__decap_3
X_1459_ _1459_/A _1459_/B VGND VGND VPWR VPWR _1460_/B sky130_fd_sc_hd__nor2_2
X_1528_ _1598_/A _1528_/B VGND VGND VPWR VPWR _1529_/B sky130_fd_sc_hd__xnor2_2
Xoutput388 _2642_/Q VGND VGND VPWR VPWR b_out[4] sky130_fd_sc_hd__buf_2
XFILLER_27_146 VGND VGND VPWR VPWR sky130_fd_sc_hd__decap_3
XFILLER_35_190 VGND VGND VPWR VPWR sky130_fd_sc_hd__decap_3
XFILLER_42_105 VGND VGND VPWR VPWR sky130_fd_sc_hd__decap_3
XFILLER_42_116 VGND VGND VPWR VPWR sky130_fd_sc_hd__decap_3
XFILLER_42_138 VGND VGND VPWR VPWR sky130_fd_sc_hd__fill_2
XFILLER_50_193 VGND VGND VPWR VPWR sky130_fd_sc_hd__decap_3
XFILLER_51_46 VGND VGND VPWR VPWR sky130_fd_sc_hd__fill_2
XFILLER_51_68 VGND VGND VPWR VPWR sky130_fd_sc_hd__fill_1
XFILLER_2_223 VGND VGND VPWR VPWR sky130_fd_sc_hd__decap_3
XFILLER_2_256 VGND VGND VPWR VPWR sky130_fd_sc_hd__fill_1
XFILLER_18_179 VGND VGND VPWR VPWR sky130_fd_sc_hd__decap_3
XFILLER_33_116 VGND VGND VPWR VPWR sky130_fd_sc_hd__decap_3
XFILLER_58_293 VGND VGND VPWR VPWR sky130_fd_sc_hd__decap_3
XFILLER_26_190 VGND VGND VPWR VPWR sky130_fd_sc_hd__fill_1
XTAP_TAPCELL_ROW_31_306 VGND VPWR sky130_fd_sc_hd__tapvpwrvgnd_1
X_2500_ _2523_/B _2439_/D VGND VGND VPWR VPWR _2500_/X sky130_fd_sc_hd__or2b_2
X_2431_ _2431_/A _2431_/B VGND VGND VPWR VPWR _2432_/B sky130_fd_sc_hd__nand2_2
XFILLER_2_62 VGND VGND VPWR VPWR sky130_fd_sc_hd__fill_1
X_1313_ _2691_/Q _2690_/Q _2689_/Q _2707_/A VGND VGND VPWR VPWR _1314_/B sky130_fd_sc_hd__or4_2
X_2362_ _2696_/Q _2363_/B VGND VGND VPWR VPWR _2437_/B sky130_fd_sc_hd__nand2_2
X_2293_ _2292_/A _2292_/B _2292_/C VGND VGND VPWR VPWR _2294_/B sky130_fd_sc_hd__a21o_2
XFILLER_24_138 VGND VGND VPWR VPWR sky130_fd_sc_hd__fill_2
XFILLER_24_149 VGND VGND VPWR VPWR sky130_fd_sc_hd__decap_3
XFILLER_64_274 VGND VGND VPWR VPWR sky130_fd_sc_hd__decap_3
XFILLER_64_285 VGND VGND VPWR VPWR sky130_fd_sc_hd__decap_3
XANTENNA_12 _2648_/Q VGND VGND VPWR VPWR sky130_fd_sc_hd__diode_2
X_2629_ clkload0/A _2629_/D VGND VGND VPWR VPWR _2629_/Q sky130_fd_sc_hd__dfxtp_2
XFILLER_46_46 VGND VGND VPWR VPWR sky130_fd_sc_hd__fill_1
XFILLER_46_79 VGND VGND VPWR VPWR sky130_fd_sc_hd__decap_3
XFILLER_55_263 VGND VGND VPWR VPWR sky130_fd_sc_hd__decap_3
XFILLER_23_182 VGND VGND VPWR VPWR sky130_fd_sc_hd__decap_3
XFILLER_62_67 VGND VGND VPWR VPWR sky130_fd_sc_hd__fill_2
XTAP_TAPCELL_ROW_53_431 VGND VPWR sky130_fd_sc_hd__tapvpwrvgnd_1
XFILLER_23_9 VGND VGND VPWR VPWR sky130_fd_sc_hd__fill_2
XFILLER_46_263 VGND VGND VPWR VPWR sky130_fd_sc_hd__decap_3
XFILLER_61_222 VGND VGND VPWR VPWR sky130_fd_sc_hd__fill_2
XFILLER_61_233 VGND VGND VPWR VPWR sky130_fd_sc_hd__decap_3
XFILLER_61_266 VGND VGND VPWR VPWR sky130_fd_sc_hd__decap_3
XFILLER_14_160 VGND VGND VPWR VPWR sky130_fd_sc_hd__fill_1
XFILLER_14_193 VGND VGND VPWR VPWR sky130_fd_sc_hd__decap_3
XFILLER_61_299 VGND VGND VPWR VPWR sky130_fd_sc_hd__decap_3
X_1931_ _1931_/A _1930_/X VGND VGND VPWR VPWR _1932_/B sky130_fd_sc_hd__nor2b_2
X_1862_ _2022_/A1 _2017_/A2 _2017_/A3 _1916_/B1 _1916_/A1 VGND VGND VPWR VPWR _1863_/B
+ sky130_fd_sc_hd__a32o_2
X_2414_ _2440_/A _2440_/B _2345_/A VGND VGND VPWR VPWR _2441_/S sky130_fd_sc_hd__a21oi_2
X_2345_ _2345_/A _2345_/B VGND VGND VPWR VPWR _2440_/A sky130_fd_sc_hd__nor2_2
X_2276_ _2300_/A _2276_/B VGND VGND VPWR VPWR _2276_/Y sky130_fd_sc_hd__xnor2_2
XFILLER_52_233 VGND VGND VPWR VPWR sky130_fd_sc_hd__decap_3
XFILLER_52_299 VGND VGND VPWR VPWR sky130_fd_sc_hd__fill_1
XTAP_TAPCELL_ROW_50_412 VGND VPWR sky130_fd_sc_hd__tapvpwrvgnd_1
XFILLER_20_185 VGND VGND VPWR VPWR sky130_fd_sc_hd__decap_3
XFILLER_4_307 VGND VGND VPWR VPWR sky130_fd_sc_hd__fill_1
XFILLER_4_318 VGND VGND VPWR VPWR sky130_fd_sc_hd__fill_2
XTAP_TAPCELL_ROW_7_178 VGND VPWR sky130_fd_sc_hd__tapvpwrvgnd_1
XFILLER_28_274 VGND VGND VPWR VPWR sky130_fd_sc_hd__decap_3
XFILLER_43_222 VGND VGND VPWR VPWR sky130_fd_sc_hd__fill_2
XFILLER_43_244 VGND VGND VPWR VPWR sky130_fd_sc_hd__decap_3
XFILLER_57_89 VGND VGND VPWR VPWR sky130_fd_sc_hd__fill_2
XPHY_EDGE_ROW_44_Left_109 VGND VGND VPWR VPWR sky130_fd_sc_hd__decap_3
XFILLER_34_200 VGND VGND VPWR VPWR sky130_fd_sc_hd__decap_3
XPHY_EDGE_ROW_53_Left_118 VGND VGND VPWR VPWR sky130_fd_sc_hd__decap_3
X_2130_ _2176_/A _2177_/B VGND VGND VPWR VPWR _2140_/A sky130_fd_sc_hd__xor2_2
X_2061_ _2061_/A _2061_/B VGND VGND VPWR VPWR _2062_/B sky130_fd_sc_hd__xor2_2
X_1914_ _1914_/A _1914_/B VGND VGND VPWR VPWR _1915_/B sky130_fd_sc_hd__xor2_2
XFILLER_8_72 VGND VGND VPWR VPWR sky130_fd_sc_hd__fill_2
XPHY_EDGE_ROW_62_Left_127 VGND VGND VPWR VPWR sky130_fd_sc_hd__decap_3
Xhold602 _2189_/Y VGND VGND VPWR VPWR hold602/X sky130_fd_sc_hd__clkbuf_2
Xhold613 hold613/A VGND VGND VPWR VPWR hold613/X sky130_fd_sc_hd__clkbuf_2
Xhold624 a_in[5] VGND VGND VPWR VPWR hold624/X sky130_fd_sc_hd__clkbuf_2
Xhold635 _2568_/C VGND VGND VPWR VPWR hold635/X sky130_fd_sc_hd__clkbuf_2
X_1845_ _1898_/A _1898_/B VGND VGND VPWR VPWR _1846_/B sky130_fd_sc_hd__xor2_4
X_1776_ _1776_/A _1776_/B VGND VGND VPWR VPWR _1779_/A sky130_fd_sc_hd__xnor2_2
Xhold646 hold646/A VGND VGND VPWR VPWR hold646/X sky130_fd_sc_hd__clkbuf_2
Xhold657 hold657/A VGND VGND VPWR VPWR hold657/X sky130_fd_sc_hd__clkbuf_2
Xhold668 a_in[10] VGND VGND VPWR VPWR hold668/X sky130_fd_sc_hd__clkbuf_2
Xmax_cap398 _1962_/A VGND VGND VPWR VPWR _1910_/A sky130_fd_sc_hd__buf_8
X_2328_ hold596/X _2327_/Y _1372_/Y _1792_/X VGND VGND VPWR VPWR _2329_/B sky130_fd_sc_hd__o22a_2
XFILLER_25_222 VGND VGND VPWR VPWR sky130_fd_sc_hd__fill_2
XFILLER_25_266 VGND VGND VPWR VPWR sky130_fd_sc_hd__decap_3
XTAP_TAPCELL_ROW_4_159 VGND VPWR sky130_fd_sc_hd__tapvpwrvgnd_1
X_2259_ _2259_/A _2683_/Q VGND VGND VPWR VPWR _2259_/Y sky130_fd_sc_hd__nand2_2
XFILLER_40_236 VGND VGND VPWR VPWR sky130_fd_sc_hd__decap_3
XFILLER_43_25 VGND VGND VPWR VPWR sky130_fd_sc_hd__fill_2
XFILLER_31_225 VGND VGND VPWR VPWR sky130_fd_sc_hd__decap_3
XTAP_TAPCELL_ROW_18_239 VGND VPWR sky130_fd_sc_hd__tapvpwrvgnd_1
XTAP_TAPCELL_ROW_26_283 VGND VPWR sky130_fd_sc_hd__tapvpwrvgnd_1
Xplace306 _1339_/Y VGND VGND VPWR VPWR _2614_/B sky130_fd_sc_hd__buf_1
X_1630_ _2626_/Q _1379_/X _1702_/A3 _1702_/B1 _2627_/Q VGND VGND VPWR VPWR _1631_/B
+ sky130_fd_sc_hd__a32o_2
XFILLER_39_303 VGND VGND VPWR VPWR sky130_fd_sc_hd__decap_3
X_1492_ _1595_/A _1492_/B VGND VGND VPWR VPWR _1502_/B sky130_fd_sc_hd__xnor2_2
X_1561_ _2008_/B2 _2019_/A2 _2019_/A3 _1625_/B _2057_/B2 VGND VGND VPWR VPWR _1562_/B
+ sky130_fd_sc_hd__a32o_2
XFILLER_54_306 VGND VGND VPWR VPWR sky130_fd_sc_hd__fill_2
XFILLER_54_317 VGND VGND VPWR VPWR sky130_fd_sc_hd__decap_3
X_2113_ _2069_/A _2113_/B VGND VGND VPWR VPWR _2113_/Y sky130_fd_sc_hd__nand2b_2
X_2044_ _2662_/Q _2661_/Q _2660_/Q _2124_/A VGND VGND VPWR VPWR _2044_/X sky130_fd_sc_hd__and4b_2
Xhold487 hold564/X VGND VGND VPWR VPWR _2603_/A sky130_fd_sc_hd__clkbuf_2
Xhold476 _2598_/X VGND VGND VPWR VPWR _2650_/D sky130_fd_sc_hd__clkbuf_2
Xhold465 hold543/X VGND VGND VPWR VPWR hold544/A sky130_fd_sc_hd__clkbuf_2
Xhold454 hold568/X VGND VGND VPWR VPWR _2603_/C sky130_fd_sc_hd__clkbuf_2
Xhold443 _2558_/X VGND VGND VPWR VPWR _2633_/D sky130_fd_sc_hd__clkbuf_2
Xhold432 hold620/X VGND VGND VPWR VPWR hold621/A sky130_fd_sc_hd__clkbuf_2
Xhold421 hold638/X VGND VGND VPWR VPWR _2567_/A sky130_fd_sc_hd__clkbuf_2
Xhold410 _2446_/Y VGND VGND VPWR VPWR _2688_/D sky130_fd_sc_hd__clkbuf_2
X_1828_ _1877_/A1 _1926_/B1 _1390_/X _1916_/A1 VGND VGND VPWR VPWR _1829_/B sky130_fd_sc_hd__a22o_2
X_1759_ _1816_/A _1759_/B VGND VGND VPWR VPWR _1762_/A sky130_fd_sc_hd__xor2_2
XFILLER_38_25 VGND VGND VPWR VPWR sky130_fd_sc_hd__decap_3
Xhold498 _2605_/A VGND VGND VPWR VPWR hold498/X sky130_fd_sc_hd__clkbuf_2
XFILLER_13_225 VGND VGND VPWR VPWR sky130_fd_sc_hd__decap_3
XFILLER_54_35 VGND VGND VPWR VPWR sky130_fd_sc_hd__decap_3
XFILLER_60_309 VGND VGND VPWR VPWR sky130_fd_sc_hd__decap_3
XTAP_TAPCELL_ROW_0_140 VGND VPWR sky130_fd_sc_hd__tapvpwrvgnd_1
XTAP_TAPCELL_ROW_23_264 VGND VPWR sky130_fd_sc_hd__tapvpwrvgnd_1
XFILLER_0_173 VGND VGND VPWR VPWR sky130_fd_sc_hd__decap_3
XFILLER_48_144 VGND VGND VPWR VPWR sky130_fd_sc_hd__decap_3
XFILLER_63_169 VGND VGND VPWR VPWR sky130_fd_sc_hd__decap_3
XTAP_TAPCELL_ROW_46_389 VGND VPWR sky130_fd_sc_hd__tapvpwrvgnd_1
XFILLER_12_291 VGND VGND VPWR VPWR sky130_fd_sc_hd__decap_3
XFILLER_8_240 VGND VGND VPWR VPWR sky130_fd_sc_hd__decap_3
XFILLER_8_262 VGND VGND VPWR VPWR sky130_fd_sc_hd__decap_3
X_1544_ _1544_/A _1544_/B VGND VGND VPWR VPWR _1547_/B sky130_fd_sc_hd__xor2_2
X_1613_ _1613_/A _1613_/B VGND VGND VPWR VPWR _1643_/B sky130_fd_sc_hd__and2_2
X_2662_ clkload6/A _2662_/D VGND VGND VPWR VPWR _2662_/Q sky130_fd_sc_hd__dfxtp_2
X_2593_ _2608_/A _2648_/Q VGND VGND VPWR VPWR _2593_/X sky130_fd_sc_hd__or2_2
XFILLER_39_133 VGND VGND VPWR VPWR sky130_fd_sc_hd__decap_3
XFILLER_39_155 VGND VGND VPWR VPWR sky130_fd_sc_hd__decap_3
X_1475_ _1473_/C _1532_/B VGND VGND VPWR VPWR _1476_/B sky130_fd_sc_hd__and2b_2
Xclkbuf_4_7_0_clk clkbuf_0_clk/X VGND VGND VPWR VPWR clkload6/A sky130_fd_sc_hd__clkbuf_8
XFILLER_54_147 VGND VGND VPWR VPWR sky130_fd_sc_hd__fill_1
X_2027_ _1983_/A _1983_/B _2026_/Y VGND VGND VPWR VPWR _2064_/A sky130_fd_sc_hd__a21oi_2
XFILLER_40_26 VGND VGND VPWR VPWR sky130_fd_sc_hd__fill_2
XFILLER_40_48 VGND VGND VPWR VPWR sky130_fd_sc_hd__fill_1
XTAP_TAPCELL_ROW_20_245 VGND VPWR sky130_fd_sc_hd__tapvpwrvgnd_1
XFILLER_49_35 VGND VGND VPWR VPWR sky130_fd_sc_hd__decap_3
XFILLER_49_46 VGND VGND VPWR VPWR sky130_fd_sc_hd__decap_3
XFILLER_49_57 VGND VGND VPWR VPWR sky130_fd_sc_hd__decap_3
XFILLER_45_169 VGND VGND VPWR VPWR sky130_fd_sc_hd__decap_3
XFILLER_60_139 VGND VGND VPWR VPWR sky130_fd_sc_hd__fill_1
XFILLER_5_232 VGND VGND VPWR VPWR sky130_fd_sc_hd__decap_3
XFILLER_5_287 VGND VGND VPWR VPWR sky130_fd_sc_hd__decap_3
XFILLER_39_90 VGND VGND VPWR VPWR sky130_fd_sc_hd__decap_3
XFILLER_24_309 VGND VGND VPWR VPWR sky130_fd_sc_hd__decap_3
XFILLER_36_125 VGND VGND VPWR VPWR sky130_fd_sc_hd__decap_3
XFILLER_36_147 VGND VGND VPWR VPWR sky130_fd_sc_hd__decap_3
XTAP_TAPCELL_ROW_34_326 VGND VPWR sky130_fd_sc_hd__tapvpwrvgnd_1
XTAP_TAPCELL_ROW_42_370 VGND VPWR sky130_fd_sc_hd__tapvpwrvgnd_1
X_1527_ _1908_/B2 _1494_/B _1921_/B1 _1854_/B2 VGND VGND VPWR VPWR _1528_/B sky130_fd_sc_hd__a22o_2
Xoutput356 _2626_/Q VGND VGND VPWR VPWR a_out[4] sky130_fd_sc_hd__buf_2
Xoutput367 _1335_/X VGND VGND VPWR VPWR acc_out[14] sky130_fd_sc_hd__buf_2
Xoutput378 _2638_/Q VGND VGND VPWR VPWR b_out[0] sky130_fd_sc_hd__buf_2
Xoutput389 _2643_/Q VGND VGND VPWR VPWR b_out[5] sky130_fd_sc_hd__buf_2
X_2645_ _2668_/CLK _2645_/D VGND VGND VPWR VPWR _2645_/Q sky130_fd_sc_hd__dfxtp_2
X_2576_ _2580_/A1 hold498/X _2619_/C1 _2575_/X VGND VGND VPWR VPWR _2576_/X sky130_fd_sc_hd__o211a_2
X_1389_ _2618_/A _2659_/Q _1484_/A VGND VGND VPWR VPWR _1390_/B sky130_fd_sc_hd__o21ai_2
X_1458_ _1459_/A _1459_/B VGND VGND VPWR VPWR _1460_/A sky130_fd_sc_hd__and2_2
XFILLER_27_169 VGND VGND VPWR VPWR sky130_fd_sc_hd__fill_2
XFILLER_2_213 VGND VGND VPWR VPWR sky130_fd_sc_hd__decap_3
XFILLER_58_250 VGND VGND VPWR VPWR sky130_fd_sc_hd__fill_2
XFILLER_18_147 VGND VGND VPWR VPWR sky130_fd_sc_hd__fill_1
XFILLER_33_139 VGND VGND VPWR VPWR sky130_fd_sc_hd__decap_3
XFILLER_41_172 VGND VGND VPWR VPWR sky130_fd_sc_hd__decap_3
XTAP_TAPCELL_ROW_31_307 VGND VPWR sky130_fd_sc_hd__tapvpwrvgnd_1
X_2430_ _2512_/A _2491_/B _2429_/X VGND VGND VPWR VPWR _2430_/X sky130_fd_sc_hd__or3b_2
X_2361_ _2679_/Q _2361_/B VGND VGND VPWR VPWR _2363_/B sky130_fd_sc_hd__xnor2_2
XFILLER_56_209 VGND VGND VPWR VPWR sky130_fd_sc_hd__decap_3
XFILLER_64_231 VGND VGND VPWR VPWR sky130_fd_sc_hd__decap_3
X_1312_ _2691_/Q _1312_/B VGND VGND VPWR VPWR _1312_/X sky130_fd_sc_hd__xor2_2
X_2292_ _2292_/A _2292_/B _2292_/C VGND VGND VPWR VPWR _2294_/A sky130_fd_sc_hd__nand3_2
XANTENNA_13 _2664_/Q VGND VGND VPWR VPWR sky130_fd_sc_hd__diode_2
XFILLER_20_312 VGND VGND VPWR VPWR sky130_fd_sc_hd__decap_3
XFILLER_32_150 VGND VGND VPWR VPWR sky130_fd_sc_hd__decap_3
XFILLER_64_253 VGND VGND VPWR VPWR sky130_fd_sc_hd__decap_3
XTAP_TAPCELL_ROW_62_476 VGND VPWR sky130_fd_sc_hd__tapvpwrvgnd_1
XFILLER_47_209 VGND VGND VPWR VPWR sky130_fd_sc_hd__decap_3
X_2628_ clkload2/A _2628_/D VGND VGND VPWR VPWR _2628_/Q sky130_fd_sc_hd__dfxtp_2
X_2559_ _2587_/A _2634_/Q VGND VGND VPWR VPWR _2559_/X sky130_fd_sc_hd__or2_2
XFILLER_15_117 VGND VGND VPWR VPWR sky130_fd_sc_hd__decap_3
XFILLER_55_242 VGND VGND VPWR VPWR sky130_fd_sc_hd__fill_2
XFILLER_23_150 VGND VGND VPWR VPWR sky130_fd_sc_hd__decap_3
XFILLER_38_209 VGND VGND VPWR VPWR sky130_fd_sc_hd__decap_3
XFILLER_36_80 VGND VGND VPWR VPWR sky130_fd_sc_hd__decap_3
XFILLER_36_91 VGND VGND VPWR VPWR sky130_fd_sc_hd__decap_3
XFILLER_46_253 VGND VGND VPWR VPWR sky130_fd_sc_hd__fill_1
XFILLER_46_275 VGND VGND VPWR VPWR sky130_fd_sc_hd__decap_3
XFILLER_61_201 VGND VGND VPWR VPWR sky130_fd_sc_hd__decap_3
XFILLER_61_245 VGND VGND VPWR VPWR sky130_fd_sc_hd__decap_3
XFILLER_61_278 VGND VGND VPWR VPWR sky130_fd_sc_hd__fill_2
X_1930_ _1930_/A _1930_/B _1930_/C _1930_/D VGND VGND VPWR VPWR _1930_/X sky130_fd_sc_hd__or4_4
X_1861_ _1861_/A _1861_/B VGND VGND VPWR VPWR _1889_/A sky130_fd_sc_hd__xor2_2
X_1792_ _1792_/A _1792_/B VGND VGND VPWR VPWR _1792_/X sky130_fd_sc_hd__or2_2
X_2413_ _2434_/A _2518_/A _2435_/B VGND VGND VPWR VPWR _2440_/B sky130_fd_sc_hd__a21oi_2
X_2344_ _2702_/Q _2344_/B VGND VGND VPWR VPWR _2345_/B sky130_fd_sc_hd__nor2_2
XFILLER_37_231 VGND VGND VPWR VPWR sky130_fd_sc_hd__fill_2
X_2275_ _2275_/A _2275_/B VGND VGND VPWR VPWR _2276_/B sky130_fd_sc_hd__xnor2_2
XFILLER_32_49 VGND VGND VPWR VPWR sky130_fd_sc_hd__fill_2
XFILLER_52_256 VGND VGND VPWR VPWR sky130_fd_sc_hd__decap_3
XTAP_TAPCELL_ROW_50_413 VGND VPWR sky130_fd_sc_hd__tapvpwrvgnd_1
XFILLER_57_35 VGND VGND VPWR VPWR sky130_fd_sc_hd__decap_3
XFILLER_57_57 VGND VGND VPWR VPWR sky130_fd_sc_hd__decap_3
XFILLER_28_253 VGND VGND VPWR VPWR sky130_fd_sc_hd__fill_2
XFILLER_28_286 VGND VGND VPWR VPWR sky130_fd_sc_hd__decap_3
XFILLER_43_256 VGND VGND VPWR VPWR sky130_fd_sc_hd__fill_1
XFILLER_43_267 VGND VGND VPWR VPWR sky130_fd_sc_hd__decap_3
XFILLER_11_197 VGND VGND VPWR VPWR sky130_fd_sc_hd__decap_3
XFILLER_22_82 VGND VGND VPWR VPWR sky130_fd_sc_hd__fill_2
XFILLER_22_93 VGND VGND VPWR VPWR sky130_fd_sc_hd__fill_1
XFILLER_19_253 VGND VGND VPWR VPWR sky130_fd_sc_hd__fill_2
XFILLER_34_212 VGND VGND VPWR VPWR sky130_fd_sc_hd__decap_3
X_2060_ _2092_/A _2092_/B VGND VGND VPWR VPWR _2061_/B sky130_fd_sc_hd__xor2_2
XFILLER_8_51 VGND VGND VPWR VPWR sky130_fd_sc_hd__decap_3
X_1913_ _1965_/A _1913_/B VGND VGND VPWR VPWR _1914_/B sky130_fd_sc_hd__and2_2
XFILLER_8_62 VGND VGND VPWR VPWR sky130_fd_sc_hd__fill_2
Xhold603 _2190_/X VGND VGND VPWR VPWR hold603/X sky130_fd_sc_hd__clkbuf_2
Xhold614 hold614/A VGND VGND VPWR VPWR hold614/X sky130_fd_sc_hd__clkbuf_2
Xhold625 hold625/A VGND VGND VPWR VPWR hold625/X sky130_fd_sc_hd__clkbuf_2
Xhold636 a_in[13] VGND VGND VPWR VPWR hold636/X sky130_fd_sc_hd__clkbuf_2
Xhold647 _2569_/C VGND VGND VPWR VPWR hold647/X sky130_fd_sc_hd__clkbuf_2
Xhold658 hold658/A VGND VGND VPWR VPWR hold658/X sky130_fd_sc_hd__clkbuf_2
Xhold669 hold669/A VGND VGND VPWR VPWR hold669/X sky130_fd_sc_hd__clkbuf_2
X_1844_ _1947_/D _1844_/B VGND VGND VPWR VPWR _1898_/B sky130_fd_sc_hd__or2_2
X_1775_ _1829_/A _1775_/B VGND VGND VPWR VPWR _1776_/B sky130_fd_sc_hd__xor2_2
XFILLER_57_315 VGND VGND VPWR VPWR sky130_fd_sc_hd__decap_3
Xmax_cap399 _2059_/A VGND VGND VPWR VPWR _2291_/A sky130_fd_sc_hd__buf_8
X_2327_ _2687_/Q VGND VGND VPWR VPWR _2327_/Y sky130_fd_sc_hd__inv_2
X_2258_ _2231_/Y _2257_/X _2326_/A VGND VGND VPWR VPWR _2682_/D sky130_fd_sc_hd__a21oi_4
XFILLER_25_256 VGND VGND VPWR VPWR sky130_fd_sc_hd__fill_1
XFILLER_25_278 VGND VGND VPWR VPWR sky130_fd_sc_hd__fill_2
X_2189_ _2225_/B _2188_/Y hold601/X VGND VGND VPWR VPWR _2189_/Y sky130_fd_sc_hd__o21ai_2
Xplace307 _1352_/B VGND VGND VPWR VPWR _1367_/B sky130_fd_sc_hd__buf_1
XFILLER_16_256 VGND VGND VPWR VPWR sky130_fd_sc_hd__decap_3
XFILLER_16_267 VGND VGND VPWR VPWR sky130_fd_sc_hd__decap_3
XFILLER_31_215 VGND VGND VPWR VPWR sky130_fd_sc_hd__decap_3
X_1560_ _1816_/A _1560_/B VGND VGND VPWR VPWR _1564_/A sky130_fd_sc_hd__xor2_2
XFILLER_12_3 VGND VGND VPWR VPWR sky130_fd_sc_hd__fill_2
X_1491_ _1854_/B2 _1625_/B _1420_/X _1807_/B2 VGND VGND VPWR VPWR _1492_/B sky130_fd_sc_hd__a22o_2
X_2112_ _2116_/A _2116_/B VGND VGND VPWR VPWR _2222_/B sky130_fd_sc_hd__xor2_2
X_2043_ _2661_/Q _2660_/Q _2124_/A VGND VGND VPWR VPWR _2043_/X sky130_fd_sc_hd__or3b_2
X_1827_ _2614_/A _1882_/B VGND VGND VPWR VPWR _1830_/A sky130_fd_sc_hd__xnor2_2
Xhold499 _2615_/X VGND VGND VPWR VPWR _2656_/D sky130_fd_sc_hd__clkbuf_2
Xhold488 _2592_/X VGND VGND VPWR VPWR _2647_/D sky130_fd_sc_hd__clkbuf_2
Xhold477 hold580/X VGND VGND VPWR VPWR hold581/A sky130_fd_sc_hd__clkbuf_2
Xhold466 hold545/X VGND VGND VPWR VPWR _2603_/D sky130_fd_sc_hd__clkbuf_2
Xhold455 _2596_/X VGND VGND VPWR VPWR _2649_/D sky130_fd_sc_hd__clkbuf_2
Xhold444 hold516/X VGND VGND VPWR VPWR hold517/A sky130_fd_sc_hd__clkbuf_2
Xhold433 hold622/X VGND VGND VPWR VPWR _2568_/A sky130_fd_sc_hd__clkbuf_2
Xhold422 _2562_/X VGND VGND VPWR VPWR _2635_/D sky130_fd_sc_hd__clkbuf_2
Xhold411 hold608/X VGND VGND VPWR VPWR hold609/A sky130_fd_sc_hd__clkbuf_2
X_1758_ _2630_/Q _2017_/A2 _2017_/A3 _1916_/B1 _2631_/Q VGND VGND VPWR VPWR _1759_/B
+ sky130_fd_sc_hd__a32o_2
X_1689_ _1689_/A _1689_/B _1689_/C VGND VGND VPWR VPWR _1690_/B sky130_fd_sc_hd__nand3_2
XFILLER_57_167 VGND VGND VPWR VPWR sky130_fd_sc_hd__fill_1
XFILLER_57_178 VGND VGND VPWR VPWR sky130_fd_sc_hd__decap_3
XFILLER_13_259 VGND VGND VPWR VPWR sky130_fd_sc_hd__decap_3
XFILLER_54_25 VGND VGND VPWR VPWR sky130_fd_sc_hd__decap_3
XTAP_TAPCELL_ROW_0_130 VGND VPWR sky130_fd_sc_hd__tapvpwrvgnd_1
XFILLER_21_281 VGND VGND VPWR VPWR sky130_fd_sc_hd__decap_3
XTAP_TAPCELL_ROW_23_265 VGND VPWR sky130_fd_sc_hd__tapvpwrvgnd_1
XFILLER_48_112 VGND VGND VPWR VPWR sky130_fd_sc_hd__decap_3
XFILLER_48_123 VGND VGND VPWR VPWR sky130_fd_sc_hd__decap_3
XFILLER_28_70 VGND VGND VPWR VPWR sky130_fd_sc_hd__fill_2
X_2661_ clkload0/A _2661_/D VGND VGND VPWR VPWR _2661_/Q sky130_fd_sc_hd__dfxtp_2
X_1474_ _1555_/A _1474_/B VGND VGND VPWR VPWR _1532_/B sky130_fd_sc_hd__nand2_2
X_1543_ _1543_/A _1543_/B VGND VGND VPWR VPWR _1544_/B sky130_fd_sc_hd__xnor2_2
X_1612_ _1612_/A _1612_/B VGND VGND VPWR VPWR _1613_/B sky130_fd_sc_hd__or2_2
X_2592_ _2592_/A1 _1357_/A _2611_/C1 _2591_/X VGND VGND VPWR VPWR _2592_/X sky130_fd_sc_hd__o211a_2
X_2026_ _2026_/A _2026_/B VGND VGND VPWR VPWR _2026_/Y sky130_fd_sc_hd__nor2_2
XTAP_TAPCELL_ROW_20_246 VGND VPWR sky130_fd_sc_hd__tapvpwrvgnd_1
XFILLER_49_14 VGND VGND VPWR VPWR sky130_fd_sc_hd__decap_3
XFILLER_18_307 VGND VGND VPWR VPWR sky130_fd_sc_hd__fill_1
XFILLER_45_126 VGND VGND VPWR VPWR sky130_fd_sc_hd__fill_1
XFILLER_30_60 VGND VGND VPWR VPWR sky130_fd_sc_hd__fill_1
XFILLER_5_211 VGND VGND VPWR VPWR sky130_fd_sc_hd__fill_2
XTAP_TAPCELL_ROW_59_460 VGND VPWR sky130_fd_sc_hd__tapvpwrvgnd_1
XFILLER_44_181 VGND VGND VPWR VPWR sky130_fd_sc_hd__fill_2
XFILLER_51_107 VGND VGND VPWR VPWR sky130_fd_sc_hd__decap_3
XFILLER_51_129 VGND VGND VPWR VPWR sky130_fd_sc_hd__decap_3
XTAP_TAPCELL_ROW_34_327 VGND VPWR sky130_fd_sc_hd__tapvpwrvgnd_1
XTAP_TAPCELL_ROW_42_371 VGND VPWR sky130_fd_sc_hd__tapvpwrvgnd_1
X_2644_ clkload1/A _2644_/D VGND VGND VPWR VPWR _2644_/Q sky130_fd_sc_hd__dfxtp_2
X_1457_ _1919_/A _1457_/B VGND VGND VPWR VPWR _1459_/B sky130_fd_sc_hd__xnor2_2
X_1526_ _1551_/A _1551_/B VGND VGND VPWR VPWR _1529_/A sky130_fd_sc_hd__xor2_2
Xoutput346 _1697_/A VGND VGND VPWR VPWR a_out[0] sky130_fd_sc_hd__buf_2
Xoutput357 _2627_/Q VGND VGND VPWR VPWR a_out[5] sky130_fd_sc_hd__buf_2
Xoutput368 _2708_/X VGND VGND VPWR VPWR acc_out[15] sky130_fd_sc_hd__buf_2
Xoutput379 _2648_/Q VGND VGND VPWR VPWR b_out[10] sky130_fd_sc_hd__buf_2
X_2575_ _2575_/A _2639_/Q VGND VGND VPWR VPWR _2575_/X sky130_fd_sc_hd__or2_2
X_1388_ _2618_/A _2659_/Q _1484_/A VGND VGND VPWR VPWR _1390_/A sky130_fd_sc_hd__a21o_2
XFILLER_42_129 VGND VGND VPWR VPWR sky130_fd_sc_hd__decap_3
XFILLER_51_37 VGND VGND VPWR VPWR sky130_fd_sc_hd__decap_3
X_2009_ _2551_/B _2096_/A2 _2009_/B1 _2629_/Q VGND VGND VPWR VPWR _2010_/B sky130_fd_sc_hd__a22o_2
XFILLER_18_126 VGND VGND VPWR VPWR sky130_fd_sc_hd__fill_1
XFILLER_33_107 VGND VGND VPWR VPWR sky130_fd_sc_hd__decap_3
XFILLER_25_93 VGND VGND VPWR VPWR sky130_fd_sc_hd__decap_3
XFILLER_41_195 VGND VGND VPWR VPWR sky130_fd_sc_hd__decap_3
XTAP_TAPCELL_ROW_31_308 VGND VPWR sky130_fd_sc_hd__tapvpwrvgnd_1
Xclkbuf_4_6_0_clk clkbuf_0_clk/X VGND VGND VPWR VPWR clkload5/A sky130_fd_sc_hd__clkbuf_8
XFILLER_44_6 VGND VGND VPWR VPWR sky130_fd_sc_hd__decap_3
X_1311_ _2690_/Q _2689_/Q _2707_/A _1314_/A VGND VGND VPWR VPWR _1312_/B sky130_fd_sc_hd__o31a_2
X_2360_ _2368_/A _2360_/B VGND VGND VPWR VPWR _2361_/B sky130_fd_sc_hd__and2_2
X_2291_ _2291_/A _2291_/B VGND VGND VPWR VPWR _2292_/C sky130_fd_sc_hd__xnor2_2
XFILLER_49_240 VGND VGND VPWR VPWR sky130_fd_sc_hd__fill_1
XFILLER_49_284 VGND VGND VPWR VPWR sky130_fd_sc_hd__decap_3
XFILLER_64_221 VGND VGND VPWR VPWR sky130_fd_sc_hd__decap_3
XFILLER_64_243 VGND VGND VPWR VPWR sky130_fd_sc_hd__decap_3
XFILLER_64_265 VGND VGND VPWR VPWR sky130_fd_sc_hd__decap_3
XPHY_EDGE_ROW_10_Right_10 VGND VGND VPWR VPWR sky130_fd_sc_hd__decap_3
XANTENNA_14 clkload9/A VGND VGND VPWR VPWR sky130_fd_sc_hd__diode_2
XTAP_TAPCELL_ROW_62_477 VGND VPWR sky130_fd_sc_hd__tapvpwrvgnd_1
X_2627_ clkload2/A _2627_/D VGND VGND VPWR VPWR _2627_/Q sky130_fd_sc_hd__dfxtp_2
X_1509_ _1509_/A _1509_/B VGND VGND VPWR VPWR _1509_/Y sky130_fd_sc_hd__nor2_2
X_2558_ _2592_/A1 hold643/X _2572_/C1 _2557_/X VGND VGND VPWR VPWR _2558_/X sky130_fd_sc_hd__o211a_2
X_2489_ _2528_/A _2489_/B VGND VGND VPWR VPWR _2694_/D sky130_fd_sc_hd__and2_2
XFILLER_46_26 VGND VGND VPWR VPWR sky130_fd_sc_hd__fill_2
XFILLER_46_59 VGND VGND VPWR VPWR sky130_fd_sc_hd__decap_3
XFILLER_55_221 VGND VGND VPWR VPWR sky130_fd_sc_hd__decap_3
XFILLER_55_287 VGND VGND VPWR VPWR sky130_fd_sc_hd__decap_3
XFILLER_46_232 VGND VGND VPWR VPWR sky130_fd_sc_hd__decap_3
XFILLER_61_257 VGND VGND VPWR VPWR sky130_fd_sc_hd__decap_3
X_1860_ _1860_/A _1860_/B VGND VGND VPWR VPWR _1861_/B sky130_fd_sc_hd__xor2_2
X_1791_ _1591_/X _1744_/Y _1790_/Y VGND VGND VPWR VPWR _1791_/Y sky130_fd_sc_hd__a21oi_2
X_2412_ _2701_/Q _2412_/B VGND VGND VPWR VPWR _2435_/B sky130_fd_sc_hd__nor2_2
X_2343_ _2702_/Q _2344_/B VGND VGND VPWR VPWR _2345_/A sky130_fd_sc_hd__and2_2
X_2274_ _2274_/A _2274_/B VGND VGND VPWR VPWR _2275_/B sky130_fd_sc_hd__nand2_2
XFILLER_16_29 VGND VGND VPWR VPWR sky130_fd_sc_hd__fill_2
XFILLER_37_221 VGND VGND VPWR VPWR sky130_fd_sc_hd__decap_3
XFILLER_20_121 VGND VGND VPWR VPWR sky130_fd_sc_hd__decap_3
XTAP_TAPCELL_ROW_50_414 VGND VPWR sky130_fd_sc_hd__tapvpwrvgnd_1
X_1989_ _2000_/B _1989_/B VGND VGND VPWR VPWR _1990_/B sky130_fd_sc_hd__xnor2_2
XFILLER_4_309 VGND VGND VPWR VPWR sky130_fd_sc_hd__decap_3
XFILLER_28_210 VGND VGND VPWR VPWR sky130_fd_sc_hd__fill_2
XFILLER_28_265 VGND VGND VPWR VPWR sky130_fd_sc_hd__decap_3
XFILLER_43_279 VGND VGND VPWR VPWR sky130_fd_sc_hd__fill_1
XFILLER_11_165 VGND VGND VPWR VPWR sky130_fd_sc_hd__decap_3
XFILLER_19_298 VGND VGND VPWR VPWR sky130_fd_sc_hd__decap_3
XFILLER_8_85 VGND VGND VPWR VPWR sky130_fd_sc_hd__fill_2
X_1912_ _1912_/A _1912_/B VGND VGND VPWR VPWR _1913_/B sky130_fd_sc_hd__or2_2
X_1843_ _1843_/A _1843_/B _1843_/C VGND VGND VPWR VPWR _1844_/B sky130_fd_sc_hd__nor3_2
Xhold604 clear_acc VGND VGND VPWR VPWR hold604/X sky130_fd_sc_hd__clkbuf_2
Xhold615 _2568_/B VGND VGND VPWR VPWR hold615/X sky130_fd_sc_hd__clkbuf_2
Xhold626 hold626/A VGND VGND VPWR VPWR hold626/X sky130_fd_sc_hd__clkbuf_2
Xhold637 hold637/A VGND VGND VPWR VPWR hold637/X sky130_fd_sc_hd__clkbuf_2
Xhold648 a_in[6] VGND VGND VPWR VPWR hold648/X sky130_fd_sc_hd__clkbuf_2
Xhold659 _2606_/A VGND VGND VPWR VPWR hold659/X sky130_fd_sc_hd__clkbuf_2
X_1774_ _1916_/A1 _1926_/B1 _1390_/X _2022_/A1 VGND VGND VPWR VPWR _1775_/B sky130_fd_sc_hd__a22o_2
X_2326_ _2326_/A _2326_/B VGND VGND VPWR VPWR _2326_/Y sky130_fd_sc_hd__nor2_2
X_2257_ _2257_/A _2257_/B _2284_/A VGND VGND VPWR VPWR _2257_/X sky130_fd_sc_hd__or3b_4
XFILLER_25_235 VGND VGND VPWR VPWR sky130_fd_sc_hd__fill_1
X_2188_ _2222_/C _2155_/B _2226_/A VGND VGND VPWR VPWR _2188_/Y sky130_fd_sc_hd__a21boi_2
XFILLER_0_312 VGND VGND VPWR VPWR sky130_fd_sc_hd__decap_3
XFILLER_16_202 VGND VGND VPWR VPWR sky130_fd_sc_hd__fill_1
XFILLER_63_319 VGND VGND VPWR VPWR sky130_fd_sc_hd__fill_1
XPHY_EDGE_ROW_9_Left_74 VGND VGND VPWR VPWR sky130_fd_sc_hd__decap_3
Xplace308 _2618_/B VGND VGND VPWR VPWR _2610_/A sky130_fd_sc_hd__buf_1
XFILLER_16_279 VGND VGND VPWR VPWR sky130_fd_sc_hd__decap_3
XFILLER_17_94 VGND VGND VPWR VPWR sky130_fd_sc_hd__fill_1
XFILLER_31_205 VGND VGND VPWR VPWR sky130_fd_sc_hd__decap_3
X_1490_ _1671_/A _1490_/B VGND VGND VPWR VPWR _1502_/A sky130_fd_sc_hd__xor2_2
X_2111_ _2150_/A _2111_/B VGND VGND VPWR VPWR _2116_/B sky130_fd_sc_hd__or2_4
X_2042_ _2005_/A _2005_/B _2013_/B _2012_/B _2012_/A VGND VGND VPWR VPWR _2067_/A
+ sky130_fd_sc_hd__a32o_2
XFILLER_22_216 VGND VGND VPWR VPWR sky130_fd_sc_hd__decap_3
XFILLER_22_238 VGND VGND VPWR VPWR sky130_fd_sc_hd__decap_3
XPHY_EDGE_ROW_8_Right_8 VGND VGND VPWR VPWR sky130_fd_sc_hd__decap_3
XTAP_TAPCELL_ROW_17_230 VGND VPWR sky130_fd_sc_hd__tapvpwrvgnd_1
X_1826_ _1826_/A _1826_/B VGND VGND VPWR VPWR _1882_/B sky130_fd_sc_hd__xor2_2
XFILLER_38_16 VGND VGND VPWR VPWR sky130_fd_sc_hd__decap_3
XPHY_EDGE_ROW_39_Right_39 VGND VGND VPWR VPWR sky130_fd_sc_hd__decap_3
Xhold489 hold500/X VGND VGND VPWR VPWR hold501/A sky130_fd_sc_hd__clkbuf_2
Xhold478 hold582/X VGND VGND VPWR VPWR _2606_/C sky130_fd_sc_hd__clkbuf_2
Xhold467 _2594_/X VGND VGND VPWR VPWR _2648_/D sky130_fd_sc_hd__clkbuf_2
Xhold456 hold495/X VGND VGND VPWR VPWR hold496/A sky130_fd_sc_hd__clkbuf_2
Xhold445 hold518/X VGND VGND VPWR VPWR _2605_/B sky130_fd_sc_hd__clkbuf_2
Xhold434 _2535_/X VGND VGND VPWR VPWR _2623_/D sky130_fd_sc_hd__clkbuf_2
Xhold423 hold628/X VGND VGND VPWR VPWR hold629/A sky130_fd_sc_hd__clkbuf_2
Xhold412 hold610/X VGND VGND VPWR VPWR _2568_/D sky130_fd_sc_hd__clkbuf_2
X_1757_ _1804_/A _1804_/B VGND VGND VPWR VPWR _1784_/A sky130_fd_sc_hd__xnor2_2
X_1688_ _1733_/A _1733_/B _1687_/Y VGND VGND VPWR VPWR _1736_/A sky130_fd_sc_hd__a21boi_2
XFILLER_57_113 VGND VGND VPWR VPWR sky130_fd_sc_hd__decap_3
XTAP_TAPCELL_ROW_0_131 VGND VPWR sky130_fd_sc_hd__tapvpwrvgnd_1
X_2309_ _2303_/A _2289_/X _2303_/B VGND VGND VPWR VPWR _2309_/X sky130_fd_sc_hd__o21a_2
XFILLER_21_260 VGND VGND VPWR VPWR sky130_fd_sc_hd__fill_1
XPHY_EDGE_ROW_48_Right_48 VGND VGND VPWR VPWR sky130_fd_sc_hd__decap_3
XTAP_TAPCELL_ROW_23_266 VGND VPWR sky130_fd_sc_hd__tapvpwrvgnd_1
XFILLER_21_293 VGND VGND VPWR VPWR sky130_fd_sc_hd__decap_3
XPHY_EDGE_ROW_57_Right_57 VGND VGND VPWR VPWR sky130_fd_sc_hd__decap_3
XFILLER_48_168 VGND VGND VPWR VPWR sky130_fd_sc_hd__decap_3
XFILLER_28_93 VGND VGND VPWR VPWR sky130_fd_sc_hd__decap_3
XFILLER_63_116 VGND VGND VPWR VPWR sky130_fd_sc_hd__decap_3
XFILLER_12_282 VGND VGND VPWR VPWR sky130_fd_sc_hd__fill_2
XFILLER_44_81 VGND VGND VPWR VPWR sky130_fd_sc_hd__decap_3
X_1611_ _1642_/A _1642_/B VGND VGND VPWR VPWR _1611_/Y sky130_fd_sc_hd__nand2_2
X_2660_ clkload0/A _2660_/D VGND VGND VPWR VPWR _2660_/Q sky130_fd_sc_hd__dfxtp_2
X_1473_ _1555_/A _1474_/B _1473_/C VGND VGND VPWR VPWR _1546_/A sky130_fd_sc_hd__and3_2
X_1542_ _1549_/A _1549_/B VGND VGND VPWR VPWR _1543_/B sky130_fd_sc_hd__xor2_2
X_2591_ _2591_/A _2647_/Q VGND VGND VPWR VPWR _2591_/X sky130_fd_sc_hd__or2_2
XFILLER_39_113 VGND VGND VPWR VPWR sky130_fd_sc_hd__decap_3
X_2025_ _2025_/A _2025_/B VGND VGND VPWR VPWR _2028_/A sky130_fd_sc_hd__xnor2_2
XFILLER_10_219 VGND VGND VPWR VPWR sky130_fd_sc_hd__fill_2
XFILLER_62_171 VGND VGND VPWR VPWR sky130_fd_sc_hd__fill_1
XPHY_EDGE_ROW_59_Left_124 VGND VGND VPWR VPWR sky130_fd_sc_hd__decap_3
XFILLER_40_17 VGND VGND VPWR VPWR sky130_fd_sc_hd__decap_3
XTAP_TAPCELL_ROW_20_247 VGND VPWR sky130_fd_sc_hd__tapvpwrvgnd_1
X_1809_ _1910_/A _1809_/B VGND VGND VPWR VPWR _1811_/B sky130_fd_sc_hd__xnor2_2
XFILLER_38_190 VGND VGND VPWR VPWR sky130_fd_sc_hd__decap_3
XFILLER_30_83 VGND VGND VPWR VPWR sky130_fd_sc_hd__fill_1
XFILLER_30_94 VGND VGND VPWR VPWR sky130_fd_sc_hd__decap_3
XFILLER_39_9 VGND VGND VPWR VPWR sky130_fd_sc_hd__decap_3
XFILLER_5_223 VGND VGND VPWR VPWR sky130_fd_sc_hd__fill_1
XTAP_TAPCELL_ROW_59_461 VGND VPWR sky130_fd_sc_hd__tapvpwrvgnd_1
XFILLER_55_80 VGND VGND VPWR VPWR sky130_fd_sc_hd__decap_3
XFILLER_55_91 VGND VGND VPWR VPWR sky130_fd_sc_hd__decap_3
X_2643_ _2668_/CLK _2643_/D VGND VGND VPWR VPWR _2643_/Q sky130_fd_sc_hd__dfxtp_2
X_2574_ _2580_/A1 hold519/X _2619_/C1 _2573_/X VGND VGND VPWR VPWR _2574_/X sky130_fd_sc_hd__o211a_2
X_1456_ _1908_/B2 _2019_/A2 _2019_/A3 _1625_/B _1960_/B2 VGND VGND VPWR VPWR _1457_/B
+ sky130_fd_sc_hd__a32o_2
X_1525_ _1595_/A _1525_/B VGND VGND VPWR VPWR _1551_/B sky130_fd_sc_hd__xnor2_2
Xoutput347 _2555_/B VGND VGND VPWR VPWR a_out[10] sky130_fd_sc_hd__buf_2
Xoutput358 _1646_/A2 VGND VGND VPWR VPWR a_out[6] sky130_fd_sc_hd__buf_2
Xoutput369 _1308_/Y VGND VGND VPWR VPWR acc_out[1] sky130_fd_sc_hd__buf_2
XFILLER_27_116 VGND VGND VPWR VPWR sky130_fd_sc_hd__decap_3
XFILLER_27_149 VGND VGND VPWR VPWR sky130_fd_sc_hd__fill_2
XFILLER_42_119 VGND VGND VPWR VPWR sky130_fd_sc_hd__decap_3
X_2008_ _2057_/B2 _1555_/B _2095_/B1 _2008_/B2 VGND VGND VPWR VPWR _2054_/A sky130_fd_sc_hd__a22o_2
XFILLER_35_193 VGND VGND VPWR VPWR sky130_fd_sc_hd__decap_3
XFILLER_2_226 VGND VGND VPWR VPWR sky130_fd_sc_hd__fill_2
XFILLER_58_241 VGND VGND VPWR VPWR sky130_fd_sc_hd__decap_3
XFILLER_58_296 VGND VGND VPWR VPWR sky130_fd_sc_hd__fill_1
XFILLER_33_119 VGND VGND VPWR VPWR sky130_fd_sc_hd__decap_3
XTAP_TAPCELL_ROW_31_309 VGND VPWR sky130_fd_sc_hd__tapvpwrvgnd_1
XFILLER_1_270 VGND VGND VPWR VPWR sky130_fd_sc_hd__decap_3
XPHY_EDGE_ROW_22_Left_87 VGND VGND VPWR VPWR sky130_fd_sc_hd__decap_3
X_1310_ _2690_/Q _1310_/B VGND VGND VPWR VPWR _1310_/Y sky130_fd_sc_hd__xnor2_2
X_2290_ _2313_/A _2290_/A2 _2313_/B _2561_/B VGND VGND VPWR VPWR _2291_/B sky130_fd_sc_hd__a22o_2
XFILLER_64_200 VGND VGND VPWR VPWR sky130_fd_sc_hd__decap_3
XFILLER_64_277 VGND VGND VPWR VPWR sky130_fd_sc_hd__decap_3
XFILLER_64_288 VGND VGND VPWR VPWR sky130_fd_sc_hd__fill_1
XFILLER_32_141 VGND VGND VPWR VPWR sky130_fd_sc_hd__decap_3
XFILLER_32_174 VGND VGND VPWR VPWR sky130_fd_sc_hd__fill_2
XTAP_TAPCELL_ROW_62_478 VGND VPWR sky130_fd_sc_hd__tapvpwrvgnd_1
X_2626_ clkload1/A _2626_/D VGND VGND VPWR VPWR _2626_/Q sky130_fd_sc_hd__dfxtp_2
X_2557_ _2587_/A _2557_/B VGND VGND VPWR VPWR _2557_/X sky130_fd_sc_hd__or2_2
X_1439_ _2655_/Q _1877_/A1 _1916_/A1 _1768_/C VGND VGND VPWR VPWR _1440_/B sky130_fd_sc_hd__a22o_2
X_1508_ _1477_/A _1477_/B _1507_/X VGND VGND VPWR VPWR _1545_/A sky130_fd_sc_hd__a21oi_2
X_2488_ _2694_/Q _2488_/A2 _2450_/Y _2487_/X VGND VGND VPWR VPWR _2489_/B sky130_fd_sc_hd__a22o_2
XFILLER_23_130 VGND VGND VPWR VPWR sky130_fd_sc_hd__decap_3
XFILLER_55_266 VGND VGND VPWR VPWR sky130_fd_sc_hd__decap_3
XFILLER_55_277 VGND VGND VPWR VPWR sky130_fd_sc_hd__decap_3
XFILLER_11_41 VGND VGND VPWR VPWR sky130_fd_sc_hd__fill_1
XFILLER_23_185 VGND VGND VPWR VPWR sky130_fd_sc_hd__decap_3
XFILLER_36_71 VGND VGND VPWR VPWR sky130_fd_sc_hd__decap_3
XFILLER_46_200 VGND VGND VPWR VPWR sky130_fd_sc_hd__decap_3
XFILLER_46_266 VGND VGND VPWR VPWR sky130_fd_sc_hd__decap_3
XFILLER_14_141 VGND VGND VPWR VPWR sky130_fd_sc_hd__fill_2
XFILLER_52_81 VGND VGND VPWR VPWR sky130_fd_sc_hd__decap_3
XFILLER_61_236 VGND VGND VPWR VPWR sky130_fd_sc_hd__decap_3
XFILLER_61_269 VGND VGND VPWR VPWR sky130_fd_sc_hd__decap_3
X_1790_ _1790_/A _1790_/B VGND VGND VPWR VPWR _1790_/Y sky130_fd_sc_hd__xnor2_2
X_2411_ _2700_/Q _2409_/B _2410_/Y VGND VGND VPWR VPWR _2518_/A sky130_fd_sc_hd__a21oi_2
X_2342_ _2685_/Q _2342_/B VGND VGND VPWR VPWR _2344_/B sky130_fd_sc_hd__xnor2_2
X_2273_ _2295_/B VGND VGND VPWR VPWR _2275_/A sky130_fd_sc_hd__inv_2
XFILLER_52_225 VGND VGND VPWR VPWR sky130_fd_sc_hd__fill_1
XFILLER_52_236 VGND VGND VPWR VPWR sky130_fd_sc_hd__fill_1
XTAP_TAPCELL_ROW_50_415 VGND VPWR sky130_fd_sc_hd__tapvpwrvgnd_1
XFILLER_20_100 VGND VGND VPWR VPWR sky130_fd_sc_hd__decap_3
XFILLER_32_18 VGND VGND VPWR VPWR sky130_fd_sc_hd__fill_2
X_1988_ _1936_/A _1936_/B _1987_/X VGND VGND VPWR VPWR _1989_/B sky130_fd_sc_hd__o21a_2
X_2609_ _2653_/Q _2583_/A _2611_/C1 hold528/X VGND VGND VPWR VPWR _2609_/X sky130_fd_sc_hd__o211a_2
XFILLER_28_200 VGND VGND VPWR VPWR sky130_fd_sc_hd__fill_2
XFILLER_28_277 VGND VGND VPWR VPWR sky130_fd_sc_hd__decap_3
Xclkbuf_4_5_0_clk clkbuf_0_clk/X VGND VGND VPWR VPWR clkload4/A sky130_fd_sc_hd__clkbuf_8
XFILLER_43_247 VGND VGND VPWR VPWR sky130_fd_sc_hd__fill_1
XFILLER_11_188 VGND VGND VPWR VPWR sky130_fd_sc_hd__decap_3
XFILLER_19_200 VGND VGND VPWR VPWR sky130_fd_sc_hd__decap_3
XTAP_TAPCELL_ROW_6_170 VGND VPWR sky130_fd_sc_hd__tapvpwrvgnd_1
XFILLER_34_203 VGND VGND VPWR VPWR sky130_fd_sc_hd__decap_3
XFILLER_34_269 VGND VGND VPWR VPWR sky130_fd_sc_hd__decap_3
XFILLER_47_92 VGND VGND VPWR VPWR sky130_fd_sc_hd__decap_3
XFILLER_42_280 VGND VGND VPWR VPWR sky130_fd_sc_hd__fill_2
X_1911_ _1912_/A _1912_/B VGND VGND VPWR VPWR _1965_/A sky130_fd_sc_hd__nand2_2
X_1842_ _1843_/A _1843_/B _1843_/C VGND VGND VPWR VPWR _1947_/D sky130_fd_sc_hd__o21a_2
X_1773_ _1773_/A _1831_/C VGND VGND VPWR VPWR _1776_/A sky130_fd_sc_hd__xnor2_2
Xhold605 hold605/A VGND VGND VPWR VPWR hold605/X sky130_fd_sc_hd__clkbuf_2
Xhold616 a_in[14] VGND VGND VPWR VPWR hold616/X sky130_fd_sc_hd__clkbuf_2
Xhold627 _2569_/A VGND VGND VPWR VPWR hold627/X sky130_fd_sc_hd__clkbuf_2
Xhold638 hold638/A VGND VGND VPWR VPWR hold638/X sky130_fd_sc_hd__clkbuf_2
Xhold649 hold649/A VGND VGND VPWR VPWR hold649/X sky130_fd_sc_hd__clkbuf_2
XPHY_EDGE_ROW_25_Left_90 VGND VGND VPWR VPWR sky130_fd_sc_hd__decap_3
XPHY_EDGE_ROW_40_Left_105 VGND VGND VPWR VPWR sky130_fd_sc_hd__decap_3
X_2325_ _2286_/B _2321_/Y _2322_/X _2354_/A hold596/X VGND VGND VPWR VPWR _2325_/X
+ sky130_fd_sc_hd__o32a_2
X_2256_ _2227_/A _2227_/B _2227_/C _2227_/D _2255_/X VGND VGND VPWR VPWR _2284_/A
+ sky130_fd_sc_hd__a41o_2
X_2187_ _2221_/A _2227_/A VGND VGND VPWR VPWR _2225_/B sky130_fd_sc_hd__nand2_2
XFILLER_25_225 VGND VGND VPWR VPWR sky130_fd_sc_hd__fill_1
XFILLER_25_269 VGND VGND VPWR VPWR sky130_fd_sc_hd__decap_3
XFILLER_40_239 VGND VGND VPWR VPWR sky130_fd_sc_hd__decap_3
XFILLER_39_306 VGND VGND VPWR VPWR sky130_fd_sc_hd__fill_1
X_2110_ _2110_/A _2110_/B VGND VGND VPWR VPWR _2111_/B sky130_fd_sc_hd__and2_2
X_2041_ _2033_/A _2033_/B _2032_/A VGND VGND VPWR VPWR _2082_/B sky130_fd_sc_hd__a21o_2
XTAP_TAPCELL_ROW_17_231 VGND VPWR sky130_fd_sc_hd__tapvpwrvgnd_1
Xhold435 hold644/X VGND VGND VPWR VPWR hold645/A sky130_fd_sc_hd__clkbuf_2
Xhold424 hold630/X VGND VGND VPWR VPWR _2567_/B sky130_fd_sc_hd__clkbuf_2
Xhold413 _2539_/X VGND VGND VPWR VPWR _2624_/D sky130_fd_sc_hd__clkbuf_2
X_1825_ _1926_/A1 _1379_/X _1380_/Y _1872_/A _1976_/D VGND VGND VPWR VPWR _1826_/B
+ sky130_fd_sc_hd__a32o_2
X_1756_ _1756_/A _1756_/B VGND VGND VPWR VPWR _1804_/B sky130_fd_sc_hd__xnor2_2
Xhold479 _2588_/X VGND VGND VPWR VPWR _2645_/D sky130_fd_sc_hd__clkbuf_2
Xhold468 hold664/X VGND VGND VPWR VPWR hold665/A sky130_fd_sc_hd__clkbuf_2
Xhold457 hold497/X VGND VGND VPWR VPWR _2605_/A sky130_fd_sc_hd__clkbuf_2
Xhold446 _2574_/X VGND VGND VPWR VPWR _2638_/D sky130_fd_sc_hd__clkbuf_2
X_2308_ _2308_/A _2685_/Q VGND VGND VPWR VPWR _2308_/X sky130_fd_sc_hd__and2_2
X_1687_ _1687_/A _1687_/B VGND VGND VPWR VPWR _1687_/Y sky130_fd_sc_hd__nand2_2
XFILLER_57_158 VGND VGND VPWR VPWR sky130_fd_sc_hd__fill_2
XFILLER_57_169 VGND VGND VPWR VPWR sky130_fd_sc_hd__decap_3
XTAP_TAPCELL_ROW_0_132 VGND VPWR sky130_fd_sc_hd__tapvpwrvgnd_1
X_2239_ _2240_/A _2240_/B VGND VGND VPWR VPWR _2241_/A sky130_fd_sc_hd__and2_2
XFILLER_21_272 VGND VGND VPWR VPWR sky130_fd_sc_hd__decap_3
XFILLER_0_165 VGND VGND VPWR VPWR sky130_fd_sc_hd__decap_3
XFILLER_48_147 VGND VGND VPWR VPWR sky130_fd_sc_hd__decap_3
XTAP_TAPCELL_ROW_14_212 VGND VPWR sky130_fd_sc_hd__tapvpwrvgnd_1
XFILLER_12_294 VGND VGND VPWR VPWR sky130_fd_sc_hd__decap_3
XFILLER_60_81 VGND VGND VPWR VPWR sky130_fd_sc_hd__decap_3
XFILLER_8_210 VGND VGND VPWR VPWR sky130_fd_sc_hd__decap_3
XFILLER_8_265 VGND VGND VPWR VPWR sky130_fd_sc_hd__decap_3
X_1610_ _1610_/A _1610_/B VGND VGND VPWR VPWR _1642_/B sky130_fd_sc_hd__xnor2_2
X_2590_ _2602_/A1 _1355_/A _2602_/B1 _2589_/X VGND VGND VPWR VPWR _2590_/X sky130_fd_sc_hd__o211a_2
X_1472_ _1434_/A _1434_/B _1471_/X VGND VGND VPWR VPWR _1473_/C sky130_fd_sc_hd__a21o_2
X_1541_ _1910_/A _1541_/B VGND VGND VPWR VPWR _1549_/B sky130_fd_sc_hd__xnor2_2
XFILLER_39_136 VGND VGND VPWR VPWR sky130_fd_sc_hd__decap_3
XFILLER_39_158 VGND VGND VPWR VPWR sky130_fd_sc_hd__fill_2
XFILLER_39_169 VGND VGND VPWR VPWR sky130_fd_sc_hd__decap_3
X_2024_ _2024_/A _2024_/B VGND VGND VPWR VPWR _2025_/B sky130_fd_sc_hd__xor2_2
XFILLER_10_209 VGND VGND VPWR VPWR sky130_fd_sc_hd__decap_3
XTAP_TAPCELL_ROW_20_248 VGND VPWR sky130_fd_sc_hd__tapvpwrvgnd_1
X_1808_ _1960_/B2 _1474_/B _2009_/B1 _1908_/B2 VGND VGND VPWR VPWR _1809_/B sky130_fd_sc_hd__a22o_2
X_1739_ _1621_/A _1739_/B VGND VGND VPWR VPWR _1739_/X sky130_fd_sc_hd__and2b_2
XFILLER_18_309 VGND VGND VPWR VPWR sky130_fd_sc_hd__decap_3
XFILLER_49_38 VGND VGND VPWR VPWR sky130_fd_sc_hd__decap_3
XFILLER_49_49 VGND VGND VPWR VPWR sky130_fd_sc_hd__decap_3
XFILLER_41_301 VGND VGND VPWR VPWR sky130_fd_sc_hd__fill_2
XFILLER_14_85 VGND VGND VPWR VPWR sky130_fd_sc_hd__fill_1
XFILLER_5_279 VGND VGND VPWR VPWR sky130_fd_sc_hd__fill_1
XFILLER_36_117 VGND VGND VPWR VPWR sky130_fd_sc_hd__decap_3
XFILLER_36_128 VGND VGND VPWR VPWR sky130_fd_sc_hd__decap_3
XFILLER_39_82 VGND VGND VPWR VPWR sky130_fd_sc_hd__fill_2
XFILLER_39_93 VGND VGND VPWR VPWR sky130_fd_sc_hd__decap_3
XFILLER_55_70 VGND VGND VPWR VPWR sky130_fd_sc_hd__fill_2
XTAP_TAPCELL_ROW_59_462 VGND VPWR sky130_fd_sc_hd__tapvpwrvgnd_1
X_1524_ _1524_/A1 _1625_/B _1420_/X _1606_/A1 VGND VGND VPWR VPWR _1525_/B sky130_fd_sc_hd__a22o_2
Xoutput348 _2557_/B VGND VGND VPWR VPWR a_out[11] sky130_fd_sc_hd__buf_2
Xoutput359 _1628_/A2 VGND VGND VPWR VPWR a_out[7] sky130_fd_sc_hd__buf_2
X_2642_ clkload0/A _2642_/D VGND VGND VPWR VPWR _2642_/Q sky130_fd_sc_hd__dfxtp_2
X_2573_ _2579_/A _2638_/Q VGND VGND VPWR VPWR _2573_/X sky130_fd_sc_hd__or2_2
X_1386_ _2658_/Q _2659_/Q VGND VGND VPWR VPWR _1386_/X sky130_fd_sc_hd__xor2_2
XFILLER_35_172 VGND VGND VPWR VPWR sky130_fd_sc_hd__decap_3
X_2007_ _1973_/A _1973_/B _2006_/X VGND VGND VPWR VPWR _2012_/A sky130_fd_sc_hd__a21o_2
XFILLER_2_216 VGND VGND VPWR VPWR sky130_fd_sc_hd__fill_2
XTAP_TAPCELL_ROW_56_443 VGND VPWR sky130_fd_sc_hd__tapvpwrvgnd_1
XFILLER_41_131 VGND VGND VPWR VPWR sky130_fd_sc_hd__fill_1
XFILLER_41_175 VGND VGND VPWR VPWR sky130_fd_sc_hd__decap_3
XFILLER_41_50 VGND VGND VPWR VPWR sky130_fd_sc_hd__fill_2
XFILLER_41_72 VGND VGND VPWR VPWR sky130_fd_sc_hd__fill_2
XFILLER_1_293 VGND VGND VPWR VPWR sky130_fd_sc_hd__decap_3
XFILLER_2_22 VGND VGND VPWR VPWR sky130_fd_sc_hd__fill_2
XFILLER_49_231 VGND VGND VPWR VPWR sky130_fd_sc_hd__decap_3
XFILLER_49_253 VGND VGND VPWR VPWR sky130_fd_sc_hd__fill_2
XFILLER_64_234 VGND VGND VPWR VPWR sky130_fd_sc_hd__decap_3
XFILLER_64_256 VGND VGND VPWR VPWR sky130_fd_sc_hd__decap_3
XFILLER_20_315 VGND VGND VPWR VPWR sky130_fd_sc_hd__decap_3
XFILLER_32_153 VGND VGND VPWR VPWR sky130_fd_sc_hd__fill_1
XTAP_TAPCELL_ROW_62_479 VGND VPWR sky130_fd_sc_hd__tapvpwrvgnd_1
X_1507_ _1466_/A _1507_/B VGND VGND VPWR VPWR _1507_/X sky130_fd_sc_hd__and2b_2
X_2625_ clkload2/A _2625_/D VGND VGND VPWR VPWR _2625_/Q sky130_fd_sc_hd__dfxtp_2
X_2556_ _2592_/A1 hold671/X _2572_/C1 _2555_/X VGND VGND VPWR VPWR _2556_/X sky130_fd_sc_hd__o211a_2
X_2487_ _2492_/A _2487_/B VGND VGND VPWR VPWR _2487_/X sky130_fd_sc_hd__or2_2
XFILLER_46_17 VGND VGND VPWR VPWR sky130_fd_sc_hd__decap_3
X_1369_ _2591_/A VGND VGND VPWR VPWR _1792_/A sky130_fd_sc_hd__inv_2
X_1438_ _1405_/A _1405_/B _1437_/X VGND VGND VPWR VPWR _1509_/A sky130_fd_sc_hd__a21oi_2
XFILLER_23_153 VGND VGND VPWR VPWR sky130_fd_sc_hd__fill_2
XFILLER_11_75 VGND VGND VPWR VPWR sky130_fd_sc_hd__fill_1
XFILLER_36_83 VGND VGND VPWR VPWR sky130_fd_sc_hd__fill_1
XFILLER_46_212 VGND VGND VPWR VPWR sky130_fd_sc_hd__decap_3
XFILLER_61_248 VGND VGND VPWR VPWR sky130_fd_sc_hd__decap_3
XFILLER_14_197 VGND VGND VPWR VPWR sky130_fd_sc_hd__decap_3
X_2410_ _2512_/B _2512_/C _2512_/A VGND VGND VPWR VPWR _2410_/Y sky130_fd_sc_hd__a21oi_2
X_2341_ _2684_/Q _2346_/B _2354_/A VGND VGND VPWR VPWR _2342_/B sky130_fd_sc_hd__o21a_2
XFILLER_28_3 VGND VGND VPWR VPWR sky130_fd_sc_hd__fill_1
X_2272_ _2272_/A _2272_/B VGND VGND VPWR VPWR _2295_/B sky130_fd_sc_hd__xor2_2
XFILLER_37_289 VGND VGND VPWR VPWR sky130_fd_sc_hd__decap_3
XFILLER_52_259 VGND VGND VPWR VPWR sky130_fd_sc_hd__fill_2
XFILLER_60_292 VGND VGND VPWR VPWR sky130_fd_sc_hd__decap_3
XFILLER_20_167 VGND VGND VPWR VPWR sky130_fd_sc_hd__fill_2
X_1987_ _1987_/A _1987_/B VGND VGND VPWR VPWR _1987_/X sky130_fd_sc_hd__or2_2
XFILLER_57_38 VGND VGND VPWR VPWR sky130_fd_sc_hd__fill_2
X_2608_ _2608_/A _2608_/B VGND VGND VPWR VPWR _2608_/Y sky130_fd_sc_hd__nand2_2
X_2539_ _2580_/A1 hold611/X _2580_/B1 _2538_/X VGND VGND VPWR VPWR _2539_/X sky130_fd_sc_hd__o211a_2
XFILLER_28_289 VGND VGND VPWR VPWR sky130_fd_sc_hd__fill_1
XFILLER_43_204 VGND VGND VPWR VPWR sky130_fd_sc_hd__decap_3
XFILLER_11_145 VGND VGND VPWR VPWR sky130_fd_sc_hd__fill_1
XFILLER_51_281 VGND VGND VPWR VPWR sky130_fd_sc_hd__decap_3
XFILLER_47_60 VGND VGND VPWR VPWR sky130_fd_sc_hd__decap_3
XTAP_TAPCELL_ROW_6_171 VGND VPWR sky130_fd_sc_hd__tapvpwrvgnd_1
XFILLER_19_278 VGND VGND VPWR VPWR sky130_fd_sc_hd__fill_2
XTAP_TAPCELL_ROW_29_295 VGND VPWR sky130_fd_sc_hd__tapvpwrvgnd_1
X_1910_ _1910_/A _1910_/B VGND VGND VPWR VPWR _1912_/B sky130_fd_sc_hd__xnor2_2
Xhold606 enable VGND VGND VPWR VPWR hold606/X sky130_fd_sc_hd__clkbuf_2
Xhold617 hold617/A VGND VGND VPWR VPWR hold617/X sky130_fd_sc_hd__clkbuf_2
X_1841_ _1841_/A _1851_/B VGND VGND VPWR VPWR _1843_/C sky130_fd_sc_hd__xnor2_2
X_1772_ _1772_/A _1772_/B VGND VGND VPWR VPWR _1831_/C sky130_fd_sc_hd__xor2_2
XFILLER_57_318 VGND VGND VPWR VPWR sky130_fd_sc_hd__fill_2
Xhold628 a_in[12] VGND VGND VPWR VPWR hold628/X sky130_fd_sc_hd__clkbuf_2
Xhold639 _2567_/A VGND VGND VPWR VPWR hold639/X sky130_fd_sc_hd__clkbuf_2
X_2255_ _2255_/A _2255_/B VGND VGND VPWR VPWR _2255_/X sky130_fd_sc_hd__or2_2
X_2186_ _2186_/A _2226_/B VGND VGND VPWR VPWR _2227_/A sky130_fd_sc_hd__or2_2
XFILLER_33_270 VGND VGND VPWR VPWR sky130_fd_sc_hd__decap_3
XTAP_TAPCELL_ROW_3_152 VGND VPWR sky130_fd_sc_hd__tapvpwrvgnd_1
XFILLER_16_259 VGND VGND VPWR VPWR sky130_fd_sc_hd__decap_3
XFILLER_31_218 VGND VGND VPWR VPWR sky130_fd_sc_hd__decap_3
X_2040_ _2040_/A _2040_/B VGND VGND VPWR VPWR _2069_/A sky130_fd_sc_hd__nand2_2
XTAP_TAPCELL_ROW_17_232 VGND VPWR sky130_fd_sc_hd__tapvpwrvgnd_1
Xhold469 hold666/X VGND VGND VPWR VPWR _2566_/B sky130_fd_sc_hd__clkbuf_2
Xhold458 _2576_/X VGND VGND VPWR VPWR _2639_/D sky130_fd_sc_hd__clkbuf_2
Xhold447 hold648/X VGND VGND VPWR VPWR hold649/A sky130_fd_sc_hd__clkbuf_2
Xhold436 hold646/X VGND VGND VPWR VPWR _2569_/C sky130_fd_sc_hd__clkbuf_2
Xhold425 _2560_/X VGND VGND VPWR VPWR _2634_/D sky130_fd_sc_hd__clkbuf_2
Xhold414 hold612/X VGND VGND VPWR VPWR hold613/A sky130_fd_sc_hd__clkbuf_2
Xhold403 hold406/X VGND VGND VPWR VPWR hold407/A sky130_fd_sc_hd__clkbuf_2
Xclkbuf_4_4_0_clk clkbuf_0_clk/X VGND VGND VPWR VPWR clkload3/A sky130_fd_sc_hd__clkbuf_8
X_1824_ _1824_/A _1824_/B VGND VGND VPWR VPWR _1834_/A sky130_fd_sc_hd__xor2_2
X_1755_ _1814_/A _1755_/B VGND VGND VPWR VPWR _1756_/B sky130_fd_sc_hd__and2_2
X_1686_ _1687_/A _1687_/B VGND VGND VPWR VPWR _1733_/B sky130_fd_sc_hd__xor2_2
XFILLER_38_29 VGND VGND VPWR VPWR sky130_fd_sc_hd__decap_3
XFILLER_57_137 VGND VGND VPWR VPWR sky130_fd_sc_hd__decap_3
X_2307_ _2288_/X _2306_/Y _2525_/A VGND VGND VPWR VPWR _2684_/D sky130_fd_sc_hd__o21a_4
X_2238_ _2264_/A _2264_/B VGND VGND VPWR VPWR _2240_/B sky130_fd_sc_hd__xor2_2
XTAP_TAPCELL_ROW_0_133 VGND VPWR sky130_fd_sc_hd__tapvpwrvgnd_1
X_2169_ _2169_/A _2169_/B VGND VGND VPWR VPWR _2195_/A sky130_fd_sc_hd__xnor2_2
XFILLER_21_284 VGND VGND VPWR VPWR sky130_fd_sc_hd__decap_3
XFILLER_48_115 VGND VGND VPWR VPWR sky130_fd_sc_hd__fill_2
XFILLER_56_192 VGND VGND VPWR VPWR sky130_fd_sc_hd__decap_3
XFILLER_12_262 VGND VGND VPWR VPWR sky130_fd_sc_hd__decap_3
XTAP_TAPCELL_ROW_14_213 VGND VPWR sky130_fd_sc_hd__tapvpwrvgnd_1
XFILLER_12_273 VGND VGND VPWR VPWR sky130_fd_sc_hd__decap_3
XFILLER_60_60 VGND VGND VPWR VPWR sky130_fd_sc_hd__decap_3
X_1540_ _1807_/B2 _1474_/B _2009_/B1 _1555_/A VGND VGND VPWR VPWR _1541_/B sky130_fd_sc_hd__a22o_2
X_1471_ _1471_/A _1471_/B VGND VGND VPWR VPWR _1471_/X sky130_fd_sc_hd__and2_2
XFILLER_62_151 VGND VGND VPWR VPWR sky130_fd_sc_hd__decap_3
X_2023_ _2023_/A _2023_/B VGND VGND VPWR VPWR _2024_/B sky130_fd_sc_hd__xnor2_2
XTAP_TAPCELL_ROW_20_249 VGND VPWR sky130_fd_sc_hd__tapvpwrvgnd_1
X_1807_ _1854_/B2 _1555_/B _2095_/B1 _1807_/B2 VGND VGND VPWR VPWR _1811_/A sky130_fd_sc_hd__a22o_2
XFILLER_49_17 VGND VGND VPWR VPWR sky130_fd_sc_hd__decap_3
X_1738_ _1622_/Y _1669_/X _1691_/X _1737_/X VGND VGND VPWR VPWR _1738_/X sky130_fd_sc_hd__o211a_2
X_1669_ _1663_/X _1737_/A _1668_/X VGND VGND VPWR VPWR _1669_/X sky130_fd_sc_hd__o21a_2
XFILLER_38_181 VGND VGND VPWR VPWR sky130_fd_sc_hd__decap_3
XFILLER_30_52 VGND VGND VPWR VPWR sky130_fd_sc_hd__fill_2
XFILLER_30_85 VGND VGND VPWR VPWR sky130_fd_sc_hd__decap_3
XFILLER_36_107 VGND VGND VPWR VPWR sky130_fd_sc_hd__decap_3
XFILLER_44_151 VGND VGND VPWR VPWR sky130_fd_sc_hd__fill_1
XTAP_TAPCELL_ROW_59_463 VGND VPWR sky130_fd_sc_hd__tapvpwrvgnd_1
X_1523_ _1523_/A _1523_/B VGND VGND VPWR VPWR _1551_/A sky130_fd_sc_hd__xor2_2
Xoutput349 _2634_/Q VGND VGND VPWR VPWR a_out[12] sky130_fd_sc_hd__buf_2
X_2641_ clkload1/A _2641_/D VGND VGND VPWR VPWR _2641_/Q sky130_fd_sc_hd__dfxtp_2
X_2572_ _2308_/A hold523/X _2571_/X _2572_/C1 VGND VGND VPWR VPWR _2572_/X sky130_fd_sc_hd__o211a_2
X_1385_ _1394_/A _1394_/B VGND VGND VPWR VPWR _1487_/A sky130_fd_sc_hd__xor2_2
XFILLER_35_184 VGND VGND VPWR VPWR sky130_fd_sc_hd__decap_3
X_2006_ _2006_/A _2006_/B VGND VGND VPWR VPWR _2006_/X sky130_fd_sc_hd__and2_2
XFILLER_58_210 VGND VGND VPWR VPWR sky130_fd_sc_hd__fill_2
XFILLER_58_232 VGND VGND VPWR VPWR sky130_fd_sc_hd__decap_3
XTAP_TAPCELL_ROW_56_444 VGND VPWR sky130_fd_sc_hd__tapvpwrvgnd_1
XFILLER_25_74 VGND VGND VPWR VPWR sky130_fd_sc_hd__fill_1
XFILLER_26_184 VGND VGND VPWR VPWR sky130_fd_sc_hd__decap_3
XFILLER_41_198 VGND VGND VPWR VPWR sky130_fd_sc_hd__fill_2
XFILLER_44_9 VGND VGND VPWR VPWR sky130_fd_sc_hd__fill_1
XFILLER_2_89 VGND VGND VPWR VPWR sky130_fd_sc_hd__fill_1
XFILLER_49_287 VGND VGND VPWR VPWR sky130_fd_sc_hd__decap_3
XFILLER_64_246 VGND VGND VPWR VPWR sky130_fd_sc_hd__decap_3
XFILLER_64_268 VGND VGND VPWR VPWR sky130_fd_sc_hd__decap_3
XTAP_TAPCELL_ROW_30_300 VGND VPWR sky130_fd_sc_hd__tapvpwrvgnd_1
X_2624_ clkload8/A _2624_/D VGND VGND VPWR VPWR _2624_/Q sky130_fd_sc_hd__dfxtp_2
X_1437_ _1437_/A _1437_/B VGND VGND VPWR VPWR _1437_/X sky130_fd_sc_hd__and2_2
X_1506_ _1741_/A _1741_/B VGND VGND VPWR VPWR _1506_/Y sky130_fd_sc_hd__nor2_2
X_2555_ _2587_/A _2555_/B VGND VGND VPWR VPWR _2555_/X sky130_fd_sc_hd__or2_2
X_2486_ _2486_/A _2486_/B VGND VGND VPWR VPWR _2487_/B sky130_fd_sc_hd__xnor2_2
XFILLER_55_202 VGND VGND VPWR VPWR sky130_fd_sc_hd__decap_3
XFILLER_55_257 VGND VGND VPWR VPWR sky130_fd_sc_hd__decap_3
X_1368_ _2669_/Q _2610_/A _1367_/X _2554_/B1 VGND VGND VPWR VPWR _2669_/D sky130_fd_sc_hd__o211a_2
Xplace290 _2588_/A1 VGND VGND VPWR VPWR _2580_/A1 sky130_fd_sc_hd__buf_1
XFILLER_14_154 VGND VGND VPWR VPWR sky130_fd_sc_hd__decap_3
XFILLER_46_235 VGND VGND VPWR VPWR sky130_fd_sc_hd__fill_1
XFILLER_14_187 VGND VGND VPWR VPWR sky130_fd_sc_hd__decap_3
XFILLER_52_50 VGND VGND VPWR VPWR sky130_fd_sc_hd__decap_3
XFILLER_52_94 VGND VGND VPWR VPWR sky130_fd_sc_hd__fill_1
X_2340_ _2683_/Q _2682_/Q _2351_/B VGND VGND VPWR VPWR _2346_/B sky130_fd_sc_hd__or3_2
X_2271_ _2271_/A _2271_/B VGND VGND VPWR VPWR _2272_/B sky130_fd_sc_hd__nand2_2
XFILLER_20_124 VGND VGND VPWR VPWR sky130_fd_sc_hd__fill_2
XFILLER_60_271 VGND VGND VPWR VPWR sky130_fd_sc_hd__decap_3
X_1986_ _2004_/A _1986_/B VGND VGND VPWR VPWR _2000_/B sky130_fd_sc_hd__xnor2_2
X_2607_ _2604_/X _2605_/X _2606_/X hold526/X VGND VGND VPWR VPWR _2607_/Y sky130_fd_sc_hd__o31ai_2
X_2538_ _2579_/A _2624_/Q VGND VGND VPWR VPWR _2538_/X sky130_fd_sc_hd__or2_2
X_2469_ _2691_/Q _2488_/A2 _2450_/Y _2468_/X VGND VGND VPWR VPWR _2470_/B sky130_fd_sc_hd__a22o_2
XFILLER_28_268 VGND VGND VPWR VPWR sky130_fd_sc_hd__decap_3
XFILLER_43_238 VGND VGND VPWR VPWR sky130_fd_sc_hd__decap_3
XFILLER_11_113 VGND VGND VPWR VPWR sky130_fd_sc_hd__fill_2
XFILLER_22_20 VGND VGND VPWR VPWR sky130_fd_sc_hd__fill_2
XFILLER_19_213 VGND VGND VPWR VPWR sky130_fd_sc_hd__decap_3
XFILLER_19_235 VGND VGND VPWR VPWR sky130_fd_sc_hd__decap_3
XFILLER_47_72 VGND VGND VPWR VPWR sky130_fd_sc_hd__decap_3
XTAP_TAPCELL_ROW_6_172 VGND VPWR sky130_fd_sc_hd__tapvpwrvgnd_1
XFILLER_34_249 VGND VGND VPWR VPWR sky130_fd_sc_hd__decap_3
XFILLER_63_60 VGND VGND VPWR VPWR sky130_fd_sc_hd__fill_2
XFILLER_63_93 VGND VGND VPWR VPWR sky130_fd_sc_hd__fill_1
XTAP_TAPCELL_ROW_29_296 VGND VPWR sky130_fd_sc_hd__tapvpwrvgnd_1
X_1840_ _1840_/A _1850_/A VGND VGND VPWR VPWR _1851_/B sky130_fd_sc_hd__xnor2_2
Xhold607 hold607/A VGND VGND VPWR VPWR hold607/X sky130_fd_sc_hd__clkbuf_2
Xhold618 hold618/A VGND VGND VPWR VPWR hold618/X sky130_fd_sc_hd__clkbuf_2
Xhold629 hold629/A VGND VGND VPWR VPWR hold629/X sky130_fd_sc_hd__clkbuf_2
X_1771_ _1877_/A1 _1379_/X _1380_/Y _1872_/A _1926_/A1 VGND VGND VPWR VPWR _1772_/B
+ sky130_fd_sc_hd__a32o_2
XFILLER_40_3 VGND VGND VPWR VPWR sky130_fd_sc_hd__fill_1
X_2323_ _2686_/Q VGND VGND VPWR VPWR _2368_/A sky130_fd_sc_hd__inv_2
X_2254_ _2220_/A _2251_/B hold601/X VGND VGND VPWR VPWR _2257_/B sky130_fd_sc_hd__o21ai_2
X_2185_ _2186_/A _2226_/B VGND VGND VPWR VPWR _2221_/A sky130_fd_sc_hd__nand2_2
X_1969_ _2197_/B _1969_/B VGND VGND VPWR VPWR _2006_/B sky130_fd_sc_hd__xnor2_2
XFILLER_0_315 VGND VGND VPWR VPWR sky130_fd_sc_hd__decap_3
XTAP_TAPCELL_ROW_3_153 VGND VPWR sky130_fd_sc_hd__tapvpwrvgnd_1
XFILLER_16_238 VGND VGND VPWR VPWR sky130_fd_sc_hd__decap_3
XFILLER_24_282 VGND VGND VPWR VPWR sky130_fd_sc_hd__decap_3
XFILLER_33_63 VGND VGND VPWR VPWR sky130_fd_sc_hd__decap_3
XTAP_TAPCELL_ROW_17_233 VGND VPWR sky130_fd_sc_hd__tapvpwrvgnd_1
X_1823_ _2023_/A _1823_/B VGND VGND VPWR VPWR _1824_/B sky130_fd_sc_hd__xnor2_2
Xhold459 hold656/X VGND VGND VPWR VPWR hold657/A sky130_fd_sc_hd__clkbuf_2
Xhold448 hold650/X VGND VGND VPWR VPWR _2569_/D sky130_fd_sc_hd__clkbuf_2
Xhold437 _2550_/X VGND VGND VPWR VPWR _2629_/D sky130_fd_sc_hd__clkbuf_2
Xhold426 hold652/X VGND VGND VPWR VPWR hold653/A sky130_fd_sc_hd__clkbuf_2
Xhold415 hold614/X VGND VGND VPWR VPWR _2568_/B sky130_fd_sc_hd__clkbuf_2
Xhold404 hold408/X VGND VGND VPWR VPWR hold409/A sky130_fd_sc_hd__clkbuf_2
X_1754_ _1754_/A _1754_/B VGND VGND VPWR VPWR _1755_/B sky130_fd_sc_hd__or2_2
X_1685_ _1685_/A _1685_/B VGND VGND VPWR VPWR _1687_/B sky130_fd_sc_hd__xor2_2
XFILLER_57_116 VGND VGND VPWR VPWR sky130_fd_sc_hd__decap_3
X_2306_ _2289_/X _2303_/B _2305_/X VGND VGND VPWR VPWR _2306_/Y sky130_fd_sc_hd__a21oi_2
X_2237_ _2291_/A _2237_/B VGND VGND VPWR VPWR _2264_/B sky130_fd_sc_hd__xnor2_2
XFILLER_54_29 VGND VGND VPWR VPWR sky130_fd_sc_hd__decap_3
XTAP_TAPCELL_ROW_0_134 VGND VPWR sky130_fd_sc_hd__tapvpwrvgnd_1
X_2168_ _2168_/A _2212_/B VGND VGND VPWR VPWR _2169_/B sky130_fd_sc_hd__xnor2_2
X_2099_ _2099_/A _2099_/B VGND VGND VPWR VPWR _2100_/B sky130_fd_sc_hd__xor2_2
XPHY_EDGE_ROW_17_Right_17 VGND VGND VPWR VPWR sky130_fd_sc_hd__decap_3
XFILLER_0_145 VGND VGND VPWR VPWR sky130_fd_sc_hd__fill_2
XPHY_EDGE_ROW_26_Right_26 VGND VGND VPWR VPWR sky130_fd_sc_hd__decap_3
XFILLER_28_96 VGND VGND VPWR VPWR sky130_fd_sc_hd__decap_3
XFILLER_56_160 VGND VGND VPWR VPWR sky130_fd_sc_hd__decap_3
XPHY_EDGE_ROW_35_Right_35 VGND VGND VPWR VPWR sky130_fd_sc_hd__decap_3
XTAP_TAPCELL_ROW_14_214 VGND VPWR sky130_fd_sc_hd__tapvpwrvgnd_1
XFILLER_60_72 VGND VGND VPWR VPWR sky130_fd_sc_hd__decap_3
XFILLER_8_289 VGND VGND VPWR VPWR sky130_fd_sc_hd__fill_2
XFILLER_39_116 VGND VGND VPWR VPWR sky130_fd_sc_hd__decap_3
XFILLER_39_149 VGND VGND VPWR VPWR sky130_fd_sc_hd__decap_3
XPHY_EDGE_ROW_44_Right_44 VGND VGND VPWR VPWR sky130_fd_sc_hd__decap_3
XFILLER_62_185 VGND VGND VPWR VPWR sky130_fd_sc_hd__decap_3
XPHY_EDGE_ROW_53_Right_53 VGND VGND VPWR VPWR sky130_fd_sc_hd__decap_3
XTAP_TAPCELL_ROW_37_339 VGND VPWR sky130_fd_sc_hd__tapvpwrvgnd_1
XTAP_TAPCELL_ROW_45_383 VGND VPWR sky130_fd_sc_hd__tapvpwrvgnd_1
X_2022_ _2022_/A1 _2086_/A2 _1430_/Y _2553_/B VGND VGND VPWR VPWR _2023_/B sky130_fd_sc_hd__a22o_2
X_1806_ _1762_/A _1762_/B _1767_/A VGND VGND VPWR VPWR _1813_/A sky130_fd_sc_hd__a21o_2
XFILLER_49_29 VGND VGND VPWR VPWR sky130_fd_sc_hd__decap_3
XPHY_EDGE_ROW_37_Left_102 VGND VGND VPWR VPWR sky130_fd_sc_hd__decap_3
XPHY_EDGE_ROW_62_Right_62 VGND VGND VPWR VPWR sky130_fd_sc_hd__decap_3
X_1599_ _1622_/A _1599_/B VGND VGND VPWR VPWR _1664_/A sky130_fd_sc_hd__or2_2
X_1737_ _1737_/A _1737_/B _1737_/C _1737_/D VGND VGND VPWR VPWR _1737_/X sky130_fd_sc_hd__or4_4
X_1668_ _1668_/A _1667_/A VGND VGND VPWR VPWR _1668_/X sky130_fd_sc_hd__or2b_2
XFILLER_38_171 VGND VGND VPWR VPWR sky130_fd_sc_hd__decap_3
XFILLER_38_193 VGND VGND VPWR VPWR sky130_fd_sc_hd__decap_3
XFILLER_53_130 VGND VGND VPWR VPWR sky130_fd_sc_hd__decap_3
XFILLER_14_21 VGND VGND VPWR VPWR sky130_fd_sc_hd__fill_1
XPHY_EDGE_ROW_46_Left_111 VGND VGND VPWR VPWR sky130_fd_sc_hd__decap_3
XFILLER_5_248 VGND VGND VPWR VPWR sky130_fd_sc_hd__decap_3
XPHY_EDGE_ROW_55_Left_120 VGND VGND VPWR VPWR sky130_fd_sc_hd__decap_3
XFILLER_39_40 VGND VGND VPWR VPWR sky130_fd_sc_hd__decap_3
XTAP_TAPCELL_ROW_59_464 VGND VPWR sky130_fd_sc_hd__tapvpwrvgnd_1
Xclkbuf_4_3_0_clk clkbuf_0_clk/X VGND VGND VPWR VPWR clkload2/A sky130_fd_sc_hd__clkbuf_8
XFILLER_17_300 VGND VGND VPWR VPWR sky130_fd_sc_hd__decap_3
XFILLER_55_83 VGND VGND VPWR VPWR sky130_fd_sc_hd__fill_2
XFILLER_55_94 VGND VGND VPWR VPWR sky130_fd_sc_hd__decap_3
X_2640_ clkload1/A _2640_/D VGND VGND VPWR VPWR _2640_/Q sky130_fd_sc_hd__dfxtp_2
XFILLER_4_281 VGND VGND VPWR VPWR sky130_fd_sc_hd__decap_3
X_1522_ _1921_/B2 _1916_/B1 _1411_/X _2628_/Q VGND VGND VPWR VPWR _1523_/B sky130_fd_sc_hd__a22o_2
X_2571_ _2587_/A _2706_/A VGND VGND VPWR VPWR _2571_/X sky130_fd_sc_hd__or2_2
X_1384_ _1604_/A _1384_/B VGND VGND VPWR VPWR _1394_/B sky130_fd_sc_hd__xor2_2
X_2005_ _2005_/A _2005_/B VGND VGND VPWR VPWR _2013_/A sky130_fd_sc_hd__nand2_2
XFILLER_35_196 VGND VGND VPWR VPWR sky130_fd_sc_hd__decap_3
XTAP_TAPCELL_ROW_33_320 VGND VPWR sky130_fd_sc_hd__tapvpwrvgnd_1
XFILLER_58_244 VGND VGND VPWR VPWR sky130_fd_sc_hd__decap_3
XFILLER_26_141 VGND VGND VPWR VPWR sky130_fd_sc_hd__fill_1
XFILLER_26_152 VGND VGND VPWR VPWR sky130_fd_sc_hd__fill_1
XFILLER_26_174 VGND VGND VPWR VPWR sky130_fd_sc_hd__decap_3
XFILLER_41_122 VGND VGND VPWR VPWR sky130_fd_sc_hd__decap_3
XTAP_TAPCELL_ROW_56_445 VGND VPWR sky130_fd_sc_hd__tapvpwrvgnd_1
XFILLER_41_166 VGND VGND VPWR VPWR sky130_fd_sc_hd__fill_2
XFILLER_41_41 VGND VGND VPWR VPWR sky130_fd_sc_hd__decap_3
XFILLER_1_273 VGND VGND VPWR VPWR sky130_fd_sc_hd__fill_2
XFILLER_49_222 VGND VGND VPWR VPWR sky130_fd_sc_hd__fill_2
XFILLER_64_203 VGND VGND VPWR VPWR sky130_fd_sc_hd__decap_3
XFILLER_64_225 VGND VGND VPWR VPWR sky130_fd_sc_hd__decap_3
XFILLER_17_163 VGND VGND VPWR VPWR sky130_fd_sc_hd__decap_3
XFILLER_32_144 VGND VGND VPWR VPWR sky130_fd_sc_hd__decap_3
XTAP_TAPCELL_ROW_30_301 VGND VPWR sky130_fd_sc_hd__tapvpwrvgnd_1
X_2623_ clkload2/A _2623_/D VGND VGND VPWR VPWR _2623_/Q sky130_fd_sc_hd__dfxtp_2
X_2620__402 VGND VGND VPWR VPWR _2620__402/HI _2620_/CIN sky130_fd_sc_hd__conb_1
X_2554_ _2308_/A hold663/X _2554_/B1 _2553_/X VGND VGND VPWR VPWR _2554_/X sky130_fd_sc_hd__o211a_2
X_1367_ _1367_/A _1367_/B VGND VGND VPWR VPWR _1367_/X sky130_fd_sc_hd__or2_2
X_1436_ _1499_/A _1499_/B _1435_/Y VGND VGND VPWR VPWR _1466_/A sky130_fd_sc_hd__a21oi_2
X_1505_ _1500_/A _1500_/B _1504_/Y VGND VGND VPWR VPWR _1741_/B sky130_fd_sc_hd__a21boi_2
X_2485_ _2485_/A _2485_/B VGND VGND VPWR VPWR _2486_/B sky130_fd_sc_hd__nand2_2
XFILLER_23_100 VGND VGND VPWR VPWR sky130_fd_sc_hd__decap_3
XFILLER_23_122 VGND VGND VPWR VPWR sky130_fd_sc_hd__fill_2
XFILLER_55_225 VGND VGND VPWR VPWR sky130_fd_sc_hd__decap_3
XFILLER_55_269 VGND VGND VPWR VPWR sky130_fd_sc_hd__decap_3
XFILLER_62_18 VGND VGND VPWR VPWR sky130_fd_sc_hd__fill_2
XFILLER_11_306 VGND VGND VPWR VPWR sky130_fd_sc_hd__fill_1
XFILLER_23_133 VGND VGND VPWR VPWR sky130_fd_sc_hd__fill_1
XFILLER_23_166 VGND VGND VPWR VPWR sky130_fd_sc_hd__fill_2
XFILLER_23_188 VGND VGND VPWR VPWR sky130_fd_sc_hd__fill_2
XFILLER_23_199 VGND VGND VPWR VPWR sky130_fd_sc_hd__decap_3
XFILLER_62_29 VGND VGND VPWR VPWR sky130_fd_sc_hd__fill_2
Xplace291 _2602_/A1 VGND VGND VPWR VPWR _2588_/A1 sky130_fd_sc_hd__buf_1
Xplace280 _2626_/Q VGND VGND VPWR VPWR _1960_/B2 sky130_fd_sc_hd__buf_1
XFILLER_11_55 VGND VGND VPWR VPWR sky130_fd_sc_hd__fill_1
XFILLER_46_203 VGND VGND VPWR VPWR sky130_fd_sc_hd__fill_2
XFILLER_36_74 VGND VGND VPWR VPWR sky130_fd_sc_hd__decap_3
XFILLER_36_85 VGND VGND VPWR VPWR sky130_fd_sc_hd__decap_3
XFILLER_46_269 VGND VGND VPWR VPWR sky130_fd_sc_hd__decap_3
XFILLER_61_239 VGND VGND VPWR VPWR sky130_fd_sc_hd__decap_3
XFILLER_42_7 VGND VGND VPWR VPWR sky130_fd_sc_hd__fill_2
X_2270_ _2295_/A _2270_/B VGND VGND VPWR VPWR _2271_/B sky130_fd_sc_hd__or2_2
XFILLER_37_225 VGND VGND VPWR VPWR sky130_fd_sc_hd__decap_3
XFILLER_20_136 VGND VGND VPWR VPWR sky130_fd_sc_hd__decap_3
X_1985_ _2003_/A _2003_/B VGND VGND VPWR VPWR _1986_/B sky130_fd_sc_hd__xor2_2
X_2606_ _2606_/A _2606_/B _2606_/C _2606_/D VGND VGND VPWR VPWR _2606_/X sky130_fd_sc_hd__or4_2
XFILLER_28_247 VGND VGND VPWR VPWR sky130_fd_sc_hd__fill_1
X_1419_ _2663_/Q _2132_/A _2664_/Q VGND VGND VPWR VPWR _2125_/C sky130_fd_sc_hd__o21ai_2
X_2468_ _2492_/A _2468_/B _2468_/C VGND VGND VPWR VPWR _2468_/X sky130_fd_sc_hd__or3_2
X_2399_ _2431_/A _2431_/B VGND VGND VPWR VPWR _2437_/C sky130_fd_sc_hd__or2_2
XFILLER_51_272 VGND VGND VPWR VPWR sky130_fd_sc_hd__decap_3
XFILLER_11_169 VGND VGND VPWR VPWR sky130_fd_sc_hd__decap_3
XFILLER_22_65 VGND VGND VPWR VPWR sky130_fd_sc_hd__fill_2
XFILLER_19_203 VGND VGND VPWR VPWR sky130_fd_sc_hd__decap_3
XFILLER_19_225 VGND VGND VPWR VPWR sky130_fd_sc_hd__decap_3
XFILLER_19_247 VGND VGND VPWR VPWR sky130_fd_sc_hd__decap_3
XFILLER_34_206 VGND VGND VPWR VPWR sky130_fd_sc_hd__decap_3
XFILLER_34_228 VGND VGND VPWR VPWR sky130_fd_sc_hd__decap_3
XFILLER_47_95 VGND VGND VPWR VPWR sky130_fd_sc_hd__fill_2
XTAP_TAPCELL_ROW_6_173 VGND VPWR sky130_fd_sc_hd__tapvpwrvgnd_1
XFILLER_42_250 VGND VGND VPWR VPWR sky130_fd_sc_hd__fill_2
XTAP_TAPCELL_ROW_29_297 VGND VPWR sky130_fd_sc_hd__tapvpwrvgnd_1
X_1770_ _1831_/A _1831_/B VGND VGND VPWR VPWR _1773_/A sky130_fd_sc_hd__nand2_2
XFILLER_6_195 VGND VGND VPWR VPWR sky130_fd_sc_hd__fill_1
Xhold608 a_in[2] VGND VGND VPWR VPWR hold608/X sky130_fd_sc_hd__clkbuf_2
Xhold619 _2567_/C VGND VGND VPWR VPWR hold619/X sky130_fd_sc_hd__clkbuf_2
X_2322_ _2654_/Q _2706_/A VGND VGND VPWR VPWR _2322_/X sky130_fd_sc_hd__and2_2
X_2253_ _2255_/A _2228_/B _2255_/B _2220_/A VGND VGND VPWR VPWR _2257_/A sky130_fd_sc_hd__o211a_2
X_2184_ _2192_/A _2192_/B VGND VGND VPWR VPWR _2226_/B sky130_fd_sc_hd__xnor2_2
XFILLER_33_250 VGND VGND VPWR VPWR sky130_fd_sc_hd__decap_3
XFILLER_33_294 VGND VGND VPWR VPWR sky130_fd_sc_hd__fill_1
X_1968_ _2022_/A1 _2019_/A2 _2019_/A3 _1416_/X _2633_/Q VGND VGND VPWR VPWR _1969_/B
+ sky130_fd_sc_hd__a32o_2
X_1899_ _1846_/A _1846_/B _1898_/Y VGND VGND VPWR VPWR _1900_/B sky130_fd_sc_hd__a21oi_2
XFILLER_48_309 VGND VGND VPWR VPWR sky130_fd_sc_hd__fill_2
XTAP_TAPCELL_ROW_3_154 VGND VPWR sky130_fd_sc_hd__tapvpwrvgnd_1
XFILLER_24_261 VGND VGND VPWR VPWR sky130_fd_sc_hd__decap_3
XTAP_TAPCELL_ROW_26_278 VGND VPWR sky130_fd_sc_hd__tapvpwrvgnd_1
XFILLER_3_110 VGND VGND VPWR VPWR sky130_fd_sc_hd__fill_2
XFILLER_62_312 VGND VGND VPWR VPWR sky130_fd_sc_hd__decap_3
XFILLER_15_272 VGND VGND VPWR VPWR sky130_fd_sc_hd__decap_3
XFILLER_30_253 VGND VGND VPWR VPWR sky130_fd_sc_hd__fill_1
XPHY_EDGE_ROW_29_Left_94 VGND VGND VPWR VPWR sky130_fd_sc_hd__decap_3
X_1822_ _2057_/B2 _2086_/A2 _1921_/B1 _2008_/B2 VGND VGND VPWR VPWR _1823_/B sky130_fd_sc_hd__a22o_2
X_1753_ _1754_/A _1754_/B VGND VGND VPWR VPWR _1814_/A sky130_fd_sc_hd__nand2_2
Xhold449 _2548_/X VGND VGND VPWR VPWR _2628_/D sky130_fd_sc_hd__clkbuf_2
Xhold438 hold632/X VGND VGND VPWR VPWR hold633/A sky130_fd_sc_hd__clkbuf_2
Xhold427 hold654/X VGND VGND VPWR VPWR _2569_/B sky130_fd_sc_hd__clkbuf_2
Xhold416 _2533_/X VGND VGND VPWR VPWR _2622_/D sky130_fd_sc_hd__clkbuf_2
Xhold405 _2329_/Y VGND VGND VPWR VPWR _2687_/D sky130_fd_sc_hd__clkbuf_2
X_1684_ _1697_/A _1670_/B _1707_/B _1683_/Y VGND VGND VPWR VPWR _1687_/A sky130_fd_sc_hd__a31o_2
XPHY_EDGE_ROW_13_Left_78 VGND VGND VPWR VPWR sky130_fd_sc_hd__decap_3
XTAP_TAPCELL_ROW_0_135 VGND VPWR sky130_fd_sc_hd__tapvpwrvgnd_1
X_2305_ _2282_/A _2285_/X _2303_/Y _2304_/Y _2286_/B VGND VGND VPWR VPWR _2305_/X
+ sky130_fd_sc_hd__a311o_2
X_2236_ _2313_/A _1469_/Y _1538_/X _2561_/B VGND VGND VPWR VPWR _2237_/B sky130_fd_sc_hd__a22o_2
X_2167_ _2201_/A _2201_/B VGND VGND VPWR VPWR _2212_/B sky130_fd_sc_hd__xor2_2
XFILLER_21_231 VGND VGND VPWR VPWR sky130_fd_sc_hd__decap_3
XFILLER_21_242 VGND VGND VPWR VPWR sky130_fd_sc_hd__decap_3
X_2098_ _2131_/A _2131_/B VGND VGND VPWR VPWR _2099_/B sky130_fd_sc_hd__xor2_2
XFILLER_21_275 VGND VGND VPWR VPWR sky130_fd_sc_hd__decap_3
XFILLER_48_106 VGND VGND VPWR VPWR sky130_fd_sc_hd__decap_3
XFILLER_48_139 VGND VGND VPWR VPWR sky130_fd_sc_hd__fill_1
Xmax_cap680 _1678_/A VGND VGND VPWR VPWR _1706_/A sky130_fd_sc_hd__buf_6
XFILLER_28_64 VGND VGND VPWR VPWR sky130_fd_sc_hd__decap_3
XFILLER_28_75 VGND VGND VPWR VPWR sky130_fd_sc_hd__decap_3
XFILLER_44_312 VGND VGND VPWR VPWR sky130_fd_sc_hd__decap_3
XFILLER_44_41 VGND VGND VPWR VPWR sky130_fd_sc_hd__decap_3
XFILLER_56_172 VGND VGND VPWR VPWR sky130_fd_sc_hd__fill_1
XFILLER_12_253 VGND VGND VPWR VPWR sky130_fd_sc_hd__decap_3
XFILLER_12_297 VGND VGND VPWR VPWR sky130_fd_sc_hd__decap_3
XFILLER_44_85 VGND VGND VPWR VPWR sky130_fd_sc_hd__decap_3
XFILLER_44_96 VGND VGND VPWR VPWR sky130_fd_sc_hd__fill_1
XFILLER_60_51 VGND VGND VPWR VPWR sky130_fd_sc_hd__decap_3
XFILLER_8_268 VGND VGND VPWR VPWR sky130_fd_sc_hd__decap_3
XTAP_TAPCELL_ROW_14_215 VGND VPWR sky130_fd_sc_hd__tapvpwrvgnd_1
XFILLER_5_57 VGND VGND VPWR VPWR sky130_fd_sc_hd__fill_2
XFILLER_39_139 VGND VGND VPWR VPWR sky130_fd_sc_hd__fill_1
XFILLER_47_161 VGND VGND VPWR VPWR sky130_fd_sc_hd__fill_2
X_2021_ _2055_/A _2055_/B VGND VGND VPWR VPWR _2024_/A sky130_fd_sc_hd__xor2_2
XFILLER_50_315 VGND VGND VPWR VPWR sky130_fd_sc_hd__fill_1
XFILLER_62_120 VGND VGND VPWR VPWR sky130_fd_sc_hd__fill_2
XFILLER_62_131 VGND VGND VPWR VPWR sky130_fd_sc_hd__fill_2
XFILLER_62_164 VGND VGND VPWR VPWR sky130_fd_sc_hd__fill_1
XTAP_TAPCELL_ROW_45_384 VGND VPWR sky130_fd_sc_hd__tapvpwrvgnd_1
X_1805_ _1756_/A _1756_/B _1804_/Y VGND VGND VPWR VPWR _1841_/A sky130_fd_sc_hd__a21oi_2
X_1736_ _1736_/A _1736_/B VGND VGND VPWR VPWR _1737_/D sky130_fd_sc_hd__xnor2_2
X_1598_ _1598_/A _1613_/A VGND VGND VPWR VPWR _1599_/B sky130_fd_sc_hd__and2_2
X_1667_ _1667_/A _1668_/A VGND VGND VPWR VPWR _1737_/A sky130_fd_sc_hd__xor2_2
XFILLER_26_301 VGND VGND VPWR VPWR sky130_fd_sc_hd__fill_1
X_2219_ _2219_/A _2219_/B VGND VGND VPWR VPWR _2220_/B sky130_fd_sc_hd__or2_2
XFILLER_39_52 VGND VGND VPWR VPWR sky130_fd_sc_hd__decap_3
XFILLER_32_315 VGND VGND VPWR VPWR sky130_fd_sc_hd__fill_1
X_2570_ _2567_/X _2568_/X _2569_/X hold522/X VGND VGND VPWR VPWR _2570_/X sky130_fd_sc_hd__o31a_2
X_1383_ _1628_/A2 _1603_/A2 _1380_/Y _1709_/B _1600_/A2 VGND VGND VPWR VPWR _1384_/B
+ sky130_fd_sc_hd__a32o_2
X_1452_ _1816_/A _1452_/B VGND VGND VPWR VPWR _1459_/A sky130_fd_sc_hd__xor2_2
X_1521_ _1581_/A _1581_/B VGND VGND VPWR VPWR _1530_/A sky130_fd_sc_hd__xor2_2
X_2004_ _2004_/A _1986_/B VGND VGND VPWR VPWR _2031_/B sky130_fd_sc_hd__nor2b_2
XTAP_TAPCELL_ROW_33_321 VGND VPWR sky130_fd_sc_hd__tapvpwrvgnd_1
X_2699_ _2702_/CLK _2699_/D VGND VGND VPWR VPWR _2699_/Q sky130_fd_sc_hd__dfxtp_2
X_1719_ _1699_/A _1699_/B _1718_/X VGND VGND VPWR VPWR _1725_/C sky130_fd_sc_hd__a21o_2
XPHY_EDGE_ROW_16_Left_81 VGND VGND VPWR VPWR sky130_fd_sc_hd__decap_3
XFILLER_26_131 VGND VGND VPWR VPWR sky130_fd_sc_hd__decap_3
XFILLER_26_197 VGND VGND VPWR VPWR sky130_fd_sc_hd__decap_3
XTAP_TAPCELL_ROW_56_446 VGND VPWR sky130_fd_sc_hd__tapvpwrvgnd_1
XTAP_TAPCELL_ROW_64_490 VGND VPWR sky130_fd_sc_hd__tapvpwrvgnd_1
XFILLER_41_189 VGND VGND VPWR VPWR sky130_fd_sc_hd__decap_3
XFILLER_1_296 VGND VGND VPWR VPWR sky130_fd_sc_hd__decap_3
XFILLER_49_234 VGND VGND VPWR VPWR sky130_fd_sc_hd__fill_1
XFILLER_64_215 VGND VGND VPWR VPWR sky130_fd_sc_hd__decap_3
XFILLER_64_237 VGND VGND VPWR VPWR sky130_fd_sc_hd__decap_3
XFILLER_64_259 VGND VGND VPWR VPWR sky130_fd_sc_hd__decap_3
XFILLER_20_318 VGND VGND VPWR VPWR sky130_fd_sc_hd__fill_2
XFILLER_32_112 VGND VGND VPWR VPWR sky130_fd_sc_hd__decap_3
XFILLER_32_189 VGND VGND VPWR VPWR sky130_fd_sc_hd__fill_2
XTAP_TAPCELL_ROW_30_302 VGND VPWR sky130_fd_sc_hd__tapvpwrvgnd_1
XFILLER_63_3 VGND VGND VPWR VPWR sky130_fd_sc_hd__decap_3
X_1504_ _1620_/B _1620_/A VGND VGND VPWR VPWR _1504_/Y sky130_fd_sc_hd__nand2b_2
X_2622_ clkload9/A _2622_/D VGND VGND VPWR VPWR _2622_/Q sky130_fd_sc_hd__dfxtp_2
X_2553_ _2583_/A _2553_/B VGND VGND VPWR VPWR _2553_/X sky130_fd_sc_hd__or2_2
X_1366_ _2668_/Q _2610_/A hold534/X _2611_/C1 VGND VGND VPWR VPWR _1366_/X sky130_fd_sc_hd__o211a_2
X_1435_ _1435_/A _1435_/B VGND VGND VPWR VPWR _1435_/Y sky130_fd_sc_hd__nor2_2
XFILLER_63_270 VGND VGND VPWR VPWR sky130_fd_sc_hd__decap_3
XFILLER_63_281 VGND VGND VPWR VPWR sky130_fd_sc_hd__fill_1
XTAP_TAPCELL_ROW_53_427 VGND VPWR sky130_fd_sc_hd__tapvpwrvgnd_1
Xplace281 _2625_/Q VGND VGND VPWR VPWR _1908_/B2 sky130_fd_sc_hd__buf_1
Xplace270 _2631_/Q VGND VGND VPWR VPWR _1478_/A2 sky130_fd_sc_hd__buf_1
XTAP_TAPCELL_ROW_61_471 VGND VPWR sky130_fd_sc_hd__tapvpwrvgnd_1
Xplace292 _2592_/A1 VGND VGND VPWR VPWR _2602_/A1 sky130_fd_sc_hd__buf_1
Xclkbuf_4_2_0_clk clkbuf_0_clk/X VGND VGND VPWR VPWR clkload1/A sky130_fd_sc_hd__clkbuf_8
XFILLER_2_7 VGND VGND VPWR VPWR sky130_fd_sc_hd__fill_2
XFILLER_36_53 VGND VGND VPWR VPWR sky130_fd_sc_hd__fill_1
XFILLER_46_215 VGND VGND VPWR VPWR sky130_fd_sc_hd__decap_3
XFILLER_52_41 VGND VGND VPWR VPWR sky130_fd_sc_hd__decap_3
XFILLER_52_85 VGND VGND VPWR VPWR sky130_fd_sc_hd__decap_3
XPHY_EDGE_ROW_1_Left_66 VGND VGND VPWR VPWR sky130_fd_sc_hd__decap_3
XFILLER_6_300 VGND VGND VPWR VPWR sky130_fd_sc_hd__decap_3
XFILLER_20_148 VGND VGND VPWR VPWR sky130_fd_sc_hd__decap_3
XFILLER_60_251 VGND VGND VPWR VPWR sky130_fd_sc_hd__fill_1
XFILLER_60_262 VGND VGND VPWR VPWR sky130_fd_sc_hd__decap_3
XFILLER_60_295 VGND VGND VPWR VPWR sky130_fd_sc_hd__fill_2
X_1984_ _1932_/A _1930_/X _1931_/A VGND VGND VPWR VPWR _2003_/B sky130_fd_sc_hd__a21oi_2
X_2605_ _2605_/A _2605_/B _2605_/C _2605_/D VGND VGND VPWR VPWR _2605_/X sky130_fd_sc_hd__or4_2
X_2467_ _2467_/A _2467_/B VGND VGND VPWR VPWR _2468_/C sky130_fd_sc_hd__nor2_2
XFILLER_43_207 VGND VGND VPWR VPWR sky130_fd_sc_hd__fill_2
XFILLER_57_19 VGND VGND VPWR VPWR sky130_fd_sc_hd__decap_3
X_1349_ _1349_/A _2614_/B VGND VGND VPWR VPWR _1349_/X sky130_fd_sc_hd__or2_2
X_1418_ _2663_/Q _2132_/A _2664_/Q VGND VGND VPWR VPWR _1420_/A sky130_fd_sc_hd__a21o_2
X_2398_ _2422_/A _2491_/A _2422_/B VGND VGND VPWR VPWR _2431_/B sky130_fd_sc_hd__a21boi_2
XFILLER_36_281 VGND VGND VPWR VPWR sky130_fd_sc_hd__decap_3
XFILLER_51_284 VGND VGND VPWR VPWR sky130_fd_sc_hd__decap_3
XFILLER_27_281 VGND VGND VPWR VPWR sky130_fd_sc_hd__decap_3
XFILLER_47_63 VGND VGND VPWR VPWR sky130_fd_sc_hd__decap_3
XTAP_TAPCELL_ROW_29_298 VGND VPWR sky130_fd_sc_hd__tapvpwrvgnd_1
XFILLER_8_46 VGND VGND VPWR VPWR sky130_fd_sc_hd__fill_1
Xhold609 hold609/A VGND VGND VPWR VPWR hold609/X sky130_fd_sc_hd__clkbuf_2
X_2321_ _2654_/Q _2706_/A VGND VGND VPWR VPWR _2321_/Y sky130_fd_sc_hd__nor2_2
X_2252_ _2252_/A VGND VGND VPWR VPWR _2255_/B sky130_fd_sc_hd__inv_4
X_2183_ _2144_/A _2144_/B _2182_/X VGND VGND VPWR VPWR _2192_/B sky130_fd_sc_hd__a21oi_2
XFILLER_18_281 VGND VGND VPWR VPWR sky130_fd_sc_hd__decap_3
XFILLER_18_292 VGND VGND VPWR VPWR sky130_fd_sc_hd__decap_3
XFILLER_25_229 VGND VGND VPWR VPWR sky130_fd_sc_hd__decap_3
XFILLER_33_273 VGND VGND VPWR VPWR sky130_fd_sc_hd__fill_1
X_1967_ _2018_/A _1967_/B VGND VGND VPWR VPWR _2006_/A sky130_fd_sc_hd__xor2_2
X_1898_ _1898_/A _1898_/B VGND VGND VPWR VPWR _1898_/Y sky130_fd_sc_hd__nor2_2
XFILLER_0_306 VGND VGND VPWR VPWR sky130_fd_sc_hd__fill_2
X_2519_ _2523_/B _2519_/B _2519_/C VGND VGND VPWR VPWR _2519_/X sky130_fd_sc_hd__or3_2
XTAP_TAPCELL_ROW_3_155 VGND VPWR sky130_fd_sc_hd__tapvpwrvgnd_1
XFILLER_33_54 VGND VGND VPWR VPWR sky130_fd_sc_hd__fill_2
XTAP_TAPCELL_ROW_26_279 VGND VPWR sky130_fd_sc_hd__tapvpwrvgnd_1
XFILLER_3_166 VGND VGND VPWR VPWR sky130_fd_sc_hd__fill_2
XFILLER_30_221 VGND VGND VPWR VPWR sky130_fd_sc_hd__decap_3
XFILLER_30_298 VGND VGND VPWR VPWR sky130_fd_sc_hd__fill_2
Xhold417 hold616/X VGND VGND VPWR VPWR hold617/A sky130_fd_sc_hd__clkbuf_2
Xhold406 reset VGND VGND VPWR VPWR hold406/X sky130_fd_sc_hd__clkbuf_2
X_1821_ _1821_/A _1821_/B VGND VGND VPWR VPWR _1824_/A sky130_fd_sc_hd__nor2_2
X_1752_ _1910_/A _1752_/B VGND VGND VPWR VPWR _1754_/B sky130_fd_sc_hd__xnor2_2
X_1683_ _1683_/A _1683_/B VGND VGND VPWR VPWR _1683_/Y sky130_fd_sc_hd__nor2_2
Xhold439 hold634/X VGND VGND VPWR VPWR _2568_/C sky130_fd_sc_hd__clkbuf_2
Xhold428 _2544_/X VGND VGND VPWR VPWR _2626_/D sky130_fd_sc_hd__clkbuf_2
X_2304_ _2284_/A _2284_/C _2303_/Y _2284_/B VGND VGND VPWR VPWR _2304_/Y sky130_fd_sc_hd__a211oi_2
XTAP_TAPCELL_ROW_0_136 VGND VPWR sky130_fd_sc_hd__tapvpwrvgnd_1
X_2235_ _2265_/B2 _2290_/A2 _2313_/B _2557_/B VGND VGND VPWR VPWR _2264_/A sky130_fd_sc_hd__a22o_2
X_2166_ _2291_/A _2166_/B VGND VGND VPWR VPWR _2201_/B sky130_fd_sc_hd__xnor2_2
X_2097_ _2291_/A _2097_/B VGND VGND VPWR VPWR _2131_/B sky130_fd_sc_hd__xnor2_2
XFILLER_21_287 VGND VGND VPWR VPWR sky130_fd_sc_hd__decap_3
XPHY_EDGE_ROW_3_Right_3 VGND VGND VPWR VPWR sky130_fd_sc_hd__decap_3
Xmax_cap681 _1829_/A VGND VGND VPWR VPWR _1519_/A sky130_fd_sc_hd__buf_4
XFILLER_44_75 VGND VGND VPWR VPWR sky130_fd_sc_hd__decap_3
XFILLER_56_195 VGND VGND VPWR VPWR sky130_fd_sc_hd__fill_1
XTAP_TAPCELL_ROW_14_216 VGND VPWR sky130_fd_sc_hd__tapvpwrvgnd_1
XFILLER_12_265 VGND VGND VPWR VPWR sky130_fd_sc_hd__fill_1
XFILLER_12_276 VGND VGND VPWR VPWR sky130_fd_sc_hd__decap_3
XFILLER_60_63 VGND VGND VPWR VPWR sky130_fd_sc_hd__decap_3
XFILLER_60_85 VGND VGND VPWR VPWR sky130_fd_sc_hd__decap_3
XPHY_EDGE_ROW_30_Left_95 VGND VGND VPWR VPWR sky130_fd_sc_hd__decap_3
XTAP_TAPCELL_ROW_22_260 VGND VPWR sky130_fd_sc_hd__tapvpwrvgnd_1
X_2020_ _2020_/A _2020_/B VGND VGND VPWR VPWR _2055_/B sky130_fd_sc_hd__xnor2_2
XTAP_TAPCELL_ROW_45_385 VGND VPWR sky130_fd_sc_hd__tapvpwrvgnd_1
XFILLER_7_291 VGND VGND VPWR VPWR sky130_fd_sc_hd__fill_1
X_1804_ _1804_/A _1804_/B VGND VGND VPWR VPWR _1804_/Y sky130_fd_sc_hd__nor2_2
X_1735_ _1735_/A _1735_/B VGND VGND VPWR VPWR _1737_/C sky130_fd_sc_hd__xnor2_2
X_1666_ _1645_/A _1645_/B _1665_/X VGND VGND VPWR VPWR _1668_/A sky130_fd_sc_hd__a21oi_2
X_1597_ _1598_/A _1613_/A VGND VGND VPWR VPWR _1622_/A sky130_fd_sc_hd__nor2_2
XFILLER_38_162 VGND VGND VPWR VPWR sky130_fd_sc_hd__decap_3
XFILLER_38_184 VGND VGND VPWR VPWR sky130_fd_sc_hd__decap_3
XFILLER_53_110 VGND VGND VPWR VPWR sky130_fd_sc_hd__fill_2
X_2218_ _2219_/A _2219_/B VGND VGND VPWR VPWR _2220_/A sky130_fd_sc_hd__nand2_2
X_2149_ _2150_/A _2150_/B VGND VGND VPWR VPWR _2226_/A sky130_fd_sc_hd__nand2_2
XFILLER_30_77 VGND VGND VPWR VPWR sky130_fd_sc_hd__decap_3
XFILLER_30_88 VGND VGND VPWR VPWR sky130_fd_sc_hd__decap_3
XFILLER_29_151 VGND VGND VPWR VPWR sky130_fd_sc_hd__decap_3
XFILLER_39_64 VGND VGND VPWR VPWR sky130_fd_sc_hd__decap_3
XFILLER_44_110 VGND VGND VPWR VPWR sky130_fd_sc_hd__decap_3
XFILLER_55_52 VGND VGND VPWR VPWR sky130_fd_sc_hd__decap_3
XTAP_TAPCELL_ROW_42_366 VGND VPWR sky130_fd_sc_hd__tapvpwrvgnd_1
XFILLER_4_250 VGND VGND VPWR VPWR sky130_fd_sc_hd__fill_2
X_1520_ _1520_/A _1520_/B VGND VGND VPWR VPWR _1581_/B sky130_fd_sc_hd__xnor2_2
X_1451_ _1524_/A1 _2017_/A2 _2017_/A3 _1916_/B1 _2628_/Q VGND VGND VPWR VPWR _1452_/B
+ sky130_fd_sc_hd__a32o_2
XFILLER_35_187 VGND VGND VPWR VPWR sky130_fd_sc_hd__decap_3
X_2003_ _2003_/A _2003_/B VGND VGND VPWR VPWR _2031_/A sky130_fd_sc_hd__nor2_2
X_1649_ _1772_/A _1649_/B VGND VGND VPWR VPWR _1653_/B sky130_fd_sc_hd__xor2_2
X_2698_ _2702_/CLK _2698_/D VGND VGND VPWR VPWR _2698_/Q sky130_fd_sc_hd__dfxtp_2
X_1718_ _1718_/A _1718_/B VGND VGND VPWR VPWR _1718_/X sky130_fd_sc_hd__and2_2
XFILLER_26_110 VGND VGND VPWR VPWR sky130_fd_sc_hd__decap_3
XFILLER_58_235 VGND VGND VPWR VPWR sky130_fd_sc_hd__decap_3
XTAP_TAPCELL_ROW_56_447 VGND VPWR sky130_fd_sc_hd__tapvpwrvgnd_1
XFILLER_26_187 VGND VGND VPWR VPWR sky130_fd_sc_hd__decap_3
XTAP_TAPCELL_ROW_64_491 VGND VPWR sky130_fd_sc_hd__tapvpwrvgnd_1
XFILLER_41_32 VGND VGND VPWR VPWR sky130_fd_sc_hd__decap_3
XFILLER_1_264 VGND VGND VPWR VPWR sky130_fd_sc_hd__decap_3
XFILLER_49_213 VGND VGND VPWR VPWR sky130_fd_sc_hd__decap_3
XFILLER_49_279 VGND VGND VPWR VPWR sky130_fd_sc_hd__fill_1
XFILLER_64_249 VGND VGND VPWR VPWR sky130_fd_sc_hd__decap_3
XTAP_TAPCELL_ROW_30_303 VGND VPWR sky130_fd_sc_hd__tapvpwrvgnd_1
X_1503_ _1501_/Y _1496_/B _1502_/Y VGND VGND VPWR VPWR _1620_/A sky130_fd_sc_hd__o21ai_2
X_2621_ _2621_/A _2656_/Q _2621_/CIN VGND VGND VPWR VPWR _1700_/B2 _2621_/SUM sky130_fd_sc_hd__fa_1
X_2552_ _2308_/A hold667/X _2554_/B1 _2551_/X VGND VGND VPWR VPWR _2552_/X sky130_fd_sc_hd__o211a_2
X_2483_ _2528_/A _2483_/B VGND VGND VPWR VPWR _2693_/D sky130_fd_sc_hd__and2_2
XFILLER_55_205 VGND VGND VPWR VPWR sky130_fd_sc_hd__decap_3
X_1365_ _1365_/A _1367_/B VGND VGND VPWR VPWR _1365_/X sky130_fd_sc_hd__or2_2
X_1434_ _1434_/A _1434_/B VGND VGND VPWR VPWR _1499_/B sky130_fd_sc_hd__xor2_2
XFILLER_48_290 VGND VGND VPWR VPWR sky130_fd_sc_hd__fill_1
XTAP_TAPCELL_ROW_53_428 VGND VPWR sky130_fd_sc_hd__tapvpwrvgnd_1
Xplace293 _2308_/A VGND VGND VPWR VPWR _2592_/A1 sky130_fd_sc_hd__buf_1
Xplace282 _2625_/Q VGND VGND VPWR VPWR _1700_/A2 sky130_fd_sc_hd__buf_1
Xplace271 _2630_/Q VGND VGND VPWR VPWR _2551_/B sky130_fd_sc_hd__buf_1
Xplace260 _2636_/Q VGND VGND VPWR VPWR _2124_/A sky130_fd_sc_hd__buf_1
XFILLER_11_57 VGND VGND VPWR VPWR sky130_fd_sc_hd__fill_2
XTAP_TAPCELL_ROW_61_472 VGND VPWR sky130_fd_sc_hd__tapvpwrvgnd_1
XFILLER_36_65 VGND VGND VPWR VPWR sky130_fd_sc_hd__decap_3
XFILLER_46_249 VGND VGND VPWR VPWR sky130_fd_sc_hd__decap_3
XFILLER_14_124 VGND VGND VPWR VPWR sky130_fd_sc_hd__fill_1
XFILLER_14_157 VGND VGND VPWR VPWR sky130_fd_sc_hd__decap_3
XFILLER_52_53 VGND VGND VPWR VPWR sky130_fd_sc_hd__decap_3
XFILLER_54_282 VGND VGND VPWR VPWR sky130_fd_sc_hd__decap_3
XFILLER_60_274 VGND VGND VPWR VPWR sky130_fd_sc_hd__fill_1
X_2604_ _2604_/A _2604_/B _2604_/C _2604_/D VGND VGND VPWR VPWR _2604_/X sky130_fd_sc_hd__or4_2
X_1983_ _1983_/A _1983_/B VGND VGND VPWR VPWR _2003_/A sky130_fd_sc_hd__xnor2_2
X_2535_ _2602_/A1 hold623/X _2580_/B1 _2534_/X VGND VGND VPWR VPWR _2535_/X sky130_fd_sc_hd__o211a_2
X_2466_ _2467_/A _2467_/B VGND VGND VPWR VPWR _2468_/B sky130_fd_sc_hd__and2_2
XFILLER_28_238 VGND VGND VPWR VPWR sky130_fd_sc_hd__fill_2
X_2397_ _2695_/Q _2397_/B VGND VGND VPWR VPWR _2422_/B sky130_fd_sc_hd__nand2_2
XFILLER_19_216 VGND VGND VPWR VPWR sky130_fd_sc_hd__decap_3
XFILLER_47_42 VGND VGND VPWR VPWR sky130_fd_sc_hd__fill_1
XFILLER_27_271 VGND VGND VPWR VPWR sky130_fd_sc_hd__decap_3
XFILLER_42_230 VGND VGND VPWR VPWR sky130_fd_sc_hd__fill_1
XFILLER_47_75 VGND VGND VPWR VPWR sky130_fd_sc_hd__decap_3
XTAP_TAPCELL_ROW_29_299 VGND VPWR sky130_fd_sc_hd__tapvpwrvgnd_1
XFILLER_42_296 VGND VGND VPWR VPWR sky130_fd_sc_hd__decap_3
XFILLER_6_186 VGND VGND VPWR VPWR sky130_fd_sc_hd__fill_2
XFILLER_6_197 VGND VGND VPWR VPWR sky130_fd_sc_hd__decap_3
X_2320_ _2308_/X _2319_/X _2525_/A VGND VGND VPWR VPWR _2685_/D sky130_fd_sc_hd__o21a_2
X_2251_ _2251_/A _2251_/B VGND VGND VPWR VPWR _2252_/A sky130_fd_sc_hd__xor2_2
XFILLER_19_3 VGND VGND VPWR VPWR sky130_fd_sc_hd__fill_1
Xclkbuf_4_1_0_clk clkbuf_0_clk/X VGND VGND VPWR VPWR clkload0/A sky130_fd_sc_hd__clkbuf_8
X_2182_ _2182_/A _2182_/B VGND VGND VPWR VPWR _2182_/X sky130_fd_sc_hd__and2_2
XFILLER_33_230 VGND VGND VPWR VPWR sky130_fd_sc_hd__decap_3
X_1966_ _2634_/Q _2017_/A2 _2017_/A3 _1670_/B _2635_/Q VGND VGND VPWR VPWR _1967_/B
+ sky130_fd_sc_hd__a32o_2
X_1897_ _1947_/D _1897_/B VGND VGND VPWR VPWR _1900_/A sky130_fd_sc_hd__xnor2_2
XFILLER_0_318 VGND VGND VPWR VPWR sky130_fd_sc_hd__fill_2
X_2518_ _2518_/A _2518_/B VGND VGND VPWR VPWR _2519_/C sky130_fd_sc_hd__nor2_2
X_2449_ _2449_/A _2449_/B VGND VGND VPWR VPWR _2449_/Y sky130_fd_sc_hd__nor2_2
XFILLER_17_67 VGND VGND VPWR VPWR sky130_fd_sc_hd__decap_3
XFILLER_24_230 VGND VGND VPWR VPWR sky130_fd_sc_hd__decap_3
XTAP_TAPCELL_ROW_3_156 VGND VPWR sky130_fd_sc_hd__tapvpwrvgnd_1
XFILLER_24_285 VGND VGND VPWR VPWR sky130_fd_sc_hd__fill_2
XFILLER_33_66 VGND VGND VPWR VPWR sky130_fd_sc_hd__decap_3
XFILLER_58_85 VGND VGND VPWR VPWR sky130_fd_sc_hd__decap_3
XFILLER_59_182 VGND VGND VPWR VPWR sky130_fd_sc_hd__decap_3
X_1820_ _1820_/A _1820_/B VGND VGND VPWR VPWR _1821_/B sky130_fd_sc_hd__nor2_2
Xhold429 hold624/X VGND VGND VPWR VPWR hold625/A sky130_fd_sc_hd__clkbuf_2
Xhold418 hold618/X VGND VGND VPWR VPWR _2567_/C sky130_fd_sc_hd__clkbuf_2
Xhold407 hold407/A VGND VGND VPWR VPWR hold407/X sky130_fd_sc_hd__clkbuf_2
X_1751_ _1908_/B2 _1474_/B _2009_/B1 _1854_/B2 VGND VGND VPWR VPWR _1752_/B sky130_fd_sc_hd__a22o_2
X_1682_ _1683_/A _1683_/B VGND VGND VPWR VPWR _1707_/B sky130_fd_sc_hd__xor2_2
X_2303_ _2303_/A _2303_/B VGND VGND VPWR VPWR _2303_/Y sky130_fd_sc_hd__xnor2_2
X_2234_ _2234_/A _2234_/B VGND VGND VPWR VPWR _2242_/A sky130_fd_sc_hd__and2_2
XTAP_TAPCELL_ROW_0_137 VGND VPWR sky130_fd_sc_hd__tapvpwrvgnd_1
X_2165_ _2265_/B2 _1469_/Y _1538_/X _2557_/B VGND VGND VPWR VPWR _2166_/B sky130_fd_sc_hd__a22o_2
X_2096_ _2555_/B _2096_/A2 _1538_/X _2553_/B VGND VGND VPWR VPWR _2097_/B sky130_fd_sc_hd__a22o_2
XFILLER_21_222 VGND VGND VPWR VPWR sky130_fd_sc_hd__fill_2
XFILLER_21_266 VGND VGND VPWR VPWR sky130_fd_sc_hd__decap_3
X_1949_ _2674_/Q VGND VGND VPWR VPWR _1949_/Y sky130_fd_sc_hd__inv_2
Xmax_cap682 _2045_/A1 VGND VGND VPWR VPWR _2018_/A sky130_fd_sc_hd__buf_6
XFILLER_28_55 VGND VGND VPWR VPWR sky130_fd_sc_hd__fill_2
XFILLER_28_99 VGND VGND VPWR VPWR sky130_fd_sc_hd__fill_2
XFILLER_29_311 VGND VGND VPWR VPWR sky130_fd_sc_hd__decap_3
XFILLER_56_163 VGND VGND VPWR VPWR sky130_fd_sc_hd__decap_3
XTAP_TAPCELL_ROW_39_350 VGND VPWR sky130_fd_sc_hd__tapvpwrvgnd_1
XFILLER_12_200 VGND VGND VPWR VPWR sky130_fd_sc_hd__fill_1
XFILLER_12_211 VGND VGND VPWR VPWR sky130_fd_sc_hd__decap_3
XFILLER_12_222 VGND VGND VPWR VPWR sky130_fd_sc_hd__decap_3
XFILLER_44_32 VGND VGND VPWR VPWR sky130_fd_sc_hd__decap_3
XTAP_TAPCELL_ROW_14_217 VGND VPWR sky130_fd_sc_hd__tapvpwrvgnd_1
XFILLER_60_42 VGND VGND VPWR VPWR sky130_fd_sc_hd__decap_3
XFILLER_60_75 VGND VGND VPWR VPWR sky130_fd_sc_hd__decap_3
XFILLER_8_226 VGND VGND VPWR VPWR sky130_fd_sc_hd__decap_3
XTAP_TAPCELL_ROW_22_261 VGND VPWR sky130_fd_sc_hd__tapvpwrvgnd_1
XFILLER_39_119 VGND VGND VPWR VPWR sky130_fd_sc_hd__fill_1
XFILLER_35_314 VGND VGND VPWR VPWR sky130_fd_sc_hd__fill_2
XFILLER_47_152 VGND VGND VPWR VPWR sky130_fd_sc_hd__decap_3
XPHY_EDGE_ROW_13_Right_13 VGND VGND VPWR VPWR sky130_fd_sc_hd__decap_3
XFILLER_62_188 VGND VGND VPWR VPWR sky130_fd_sc_hd__fill_1
XPHY_EDGE_ROW_22_Right_22 VGND VGND VPWR VPWR sky130_fd_sc_hd__decap_3
XTAP_TAPCELL_ROW_45_386 VGND VPWR sky130_fd_sc_hd__tapvpwrvgnd_1
X_1803_ _1803_/A _1803_/B VGND VGND VPWR VPWR _1843_/B sky130_fd_sc_hd__nor2_2
X_1596_ _1612_/A _1612_/B VGND VGND VPWR VPWR _1613_/A sky130_fd_sc_hd__nand2_2
X_1734_ _1724_/Y _1726_/Y _1732_/Y _1733_/Y VGND VGND VPWR VPWR _1737_/B sky130_fd_sc_hd__a31o_2
X_1665_ _1644_/A _1665_/B VGND VGND VPWR VPWR _1665_/X sky130_fd_sc_hd__and2b_2
XPHY_EDGE_ROW_31_Right_31 VGND VGND VPWR VPWR sky130_fd_sc_hd__decap_3
X_2217_ _2251_/A _2217_/B VGND VGND VPWR VPWR _2219_/B sky130_fd_sc_hd__and2_2
XFILLER_14_35 VGND VGND VPWR VPWR sky130_fd_sc_hd__fill_1
XFILLER_38_174 VGND VGND VPWR VPWR sky130_fd_sc_hd__fill_2
XFILLER_53_133 VGND VGND VPWR VPWR sky130_fd_sc_hd__decap_3
XFILLER_53_166 VGND VGND VPWR VPWR sky130_fd_sc_hd__fill_2
X_2148_ _2161_/A _2161_/B VGND VGND VPWR VPWR _2150_/B sky130_fd_sc_hd__xor2_2
X_2079_ _2326_/A _2079_/B VGND VGND VPWR VPWR _2677_/D sky130_fd_sc_hd__nor2_2
XFILLER_14_79 VGND VGND VPWR VPWR sky130_fd_sc_hd__fill_1
XPHY_EDGE_ROW_40_Right_40 VGND VGND VPWR VPWR sky130_fd_sc_hd__decap_3
XFILLER_17_303 VGND VGND VPWR VPWR sky130_fd_sc_hd__decap_3
XFILLER_29_196 VGND VGND VPWR VPWR sky130_fd_sc_hd__decap_3
XFILLER_44_122 VGND VGND VPWR VPWR sky130_fd_sc_hd__decap_3
XFILLER_55_97 VGND VGND VPWR VPWR sky130_fd_sc_hd__decap_3
XTAP_TAPCELL_ROW_42_367 VGND VPWR sky130_fd_sc_hd__tapvpwrvgnd_1
XFILLER_4_262 VGND VGND VPWR VPWR sky130_fd_sc_hd__decap_3
XFILLER_4_284 VGND VGND VPWR VPWR sky130_fd_sc_hd__decap_3
XFILLER_4_295 VGND VGND VPWR VPWR sky130_fd_sc_hd__decap_3
X_1381_ _2657_/Q _2656_/Q VGND VGND VPWR VPWR _1872_/A sky130_fd_sc_hd__xor2_2
X_2002_ _1912_/A _1912_/B _1965_/B _1964_/B _1964_/A VGND VGND VPWR VPWR _2033_/A
+ sky130_fd_sc_hd__a32o_2
X_1579_ _1781_/B _1579_/B VGND VGND VPWR VPWR _1580_/B sky130_fd_sc_hd__xnor2_2
X_1648_ _1700_/A2 _1379_/X _1702_/A3 _1702_/B1 _2626_/Q VGND VGND VPWR VPWR _1649_/B
+ sky130_fd_sc_hd__a32o_2
X_2697_ _2703_/CLK _2697_/D VGND VGND VPWR VPWR _2697_/Q sky130_fd_sc_hd__dfxtp_2
X_1717_ _1725_/A _1725_/B VGND VGND VPWR VPWR _1720_/A sky130_fd_sc_hd__nand2_2
XFILLER_58_247 VGND VGND VPWR VPWR sky130_fd_sc_hd__decap_3
XTAP_TAPCELL_ROW_56_448 VGND VPWR sky130_fd_sc_hd__tapvpwrvgnd_1
XFILLER_14_306 VGND VGND VPWR VPWR sky130_fd_sc_hd__fill_2
XFILLER_14_317 VGND VGND VPWR VPWR sky130_fd_sc_hd__decap_3
XFILLER_26_177 VGND VGND VPWR VPWR sky130_fd_sc_hd__fill_2
XFILLER_41_125 VGND VGND VPWR VPWR sky130_fd_sc_hd__decap_3
XFILLER_41_169 VGND VGND VPWR VPWR sky130_fd_sc_hd__decap_3
XTAP_TAPCELL_ROW_64_492 VGND VPWR sky130_fd_sc_hd__tapvpwrvgnd_1
XFILLER_41_44 VGND VGND VPWR VPWR sky130_fd_sc_hd__decap_3
XFILLER_41_55 VGND VGND VPWR VPWR sky130_fd_sc_hd__fill_1
XFILLER_41_66 VGND VGND VPWR VPWR sky130_fd_sc_hd__decap_3
XFILLER_1_243 VGND VGND VPWR VPWR sky130_fd_sc_hd__decap_3
XFILLER_2_49 VGND VGND VPWR VPWR sky130_fd_sc_hd__fill_1
XFILLER_49_225 VGND VGND VPWR VPWR sky130_fd_sc_hd__decap_3
XFILLER_64_206 VGND VGND VPWR VPWR sky130_fd_sc_hd__fill_2
Xhold590 _1356_/X VGND VGND VPWR VPWR _2663_/D sky130_fd_sc_hd__clkbuf_2
XFILLER_17_166 VGND VGND VPWR VPWR sky130_fd_sc_hd__fill_2
XFILLER_32_147 VGND VGND VPWR VPWR sky130_fd_sc_hd__decap_3
XFILLER_64_228 VGND VGND VPWR VPWR sky130_fd_sc_hd__decap_3
XFILLER_20_309 VGND VGND VPWR VPWR sky130_fd_sc_hd__decap_3
XTAP_TAPCELL_ROW_30_304 VGND VPWR sky130_fd_sc_hd__tapvpwrvgnd_1
X_2620_ _2668_/Q _2669_/Q _2620_/CIN VGND VGND VPWR VPWR _2313_/B _2095_/A2 sky130_fd_sc_hd__fa_1
X_1433_ _1598_/A _1433_/B VGND VGND VPWR VPWR _1434_/B sky130_fd_sc_hd__xnor2_2
X_1502_ _1502_/A _1502_/B VGND VGND VPWR VPWR _1502_/Y sky130_fd_sc_hd__nand2_2
X_2551_ _2583_/A _2551_/B VGND VGND VPWR VPWR _2551_/X sky130_fd_sc_hd__or2_2
X_2482_ _2693_/Q _2488_/A2 _2450_/Y _2481_/X VGND VGND VPWR VPWR _2483_/B sky130_fd_sc_hd__a22o_2
XFILLER_55_228 VGND VGND VPWR VPWR sky130_fd_sc_hd__fill_1
X_1364_ _2667_/Q _2610_/A _1363_/X _2611_/C1 VGND VGND VPWR VPWR _2667_/D sky130_fd_sc_hd__o211a_2
XFILLER_23_103 VGND VGND VPWR VPWR sky130_fd_sc_hd__decap_3
XFILLER_23_147 VGND VGND VPWR VPWR sky130_fd_sc_hd__decap_3
XFILLER_63_261 VGND VGND VPWR VPWR sky130_fd_sc_hd__decap_3
XTAP_TAPCELL_ROW_53_429 VGND VPWR sky130_fd_sc_hd__tapvpwrvgnd_1
XTAP_TAPCELL_ROW_61_473 VGND VPWR sky130_fd_sc_hd__tapvpwrvgnd_1
Xplace294 _2259_/A VGND VGND VPWR VPWR _2308_/A sky130_fd_sc_hd__buf_1
Xplace283 _1710_/A2 VGND VGND VPWR VPWR _1700_/B1 sky130_fd_sc_hd__buf_1
Xplace272 _2630_/Q VGND VGND VPWR VPWR _1600_/A2 sky130_fd_sc_hd__buf_1
Xplace261 _2635_/Q VGND VGND VPWR VPWR _2561_/B sky130_fd_sc_hd__buf_1
Xplace250 _2015_/A VGND VGND VPWR VPWR _1484_/A sky130_fd_sc_hd__buf_1
XFILLER_36_77 VGND VGND VPWR VPWR sky130_fd_sc_hd__decap_3
XFILLER_36_88 VGND VGND VPWR VPWR sky130_fd_sc_hd__decap_3
XFILLER_54_272 VGND VGND VPWR VPWR sky130_fd_sc_hd__fill_1
XFILLER_52_21 VGND VGND VPWR VPWR sky130_fd_sc_hd__decap_3
XFILLER_52_32 VGND VGND VPWR VPWR sky130_fd_sc_hd__decap_3
XFILLER_37_228 VGND VGND VPWR VPWR sky130_fd_sc_hd__decap_3
XFILLER_20_139 VGND VGND VPWR VPWR sky130_fd_sc_hd__fill_1
XFILLER_45_261 VGND VGND VPWR VPWR sky130_fd_sc_hd__fill_2
XFILLER_60_242 VGND VGND VPWR VPWR sky130_fd_sc_hd__decap_3
XFILLER_60_253 VGND VGND VPWR VPWR sky130_fd_sc_hd__decap_3
XFILLER_60_286 VGND VGND VPWR VPWR sky130_fd_sc_hd__decap_3
X_1982_ _2026_/A _2026_/B VGND VGND VPWR VPWR _1983_/B sky130_fd_sc_hd__xor2_2
X_2603_ _2603_/A _2603_/B _2603_/C _2603_/D VGND VGND VPWR VPWR _2604_/D sky130_fd_sc_hd__or4_2
X_2534_ _2575_/A _2623_/Q VGND VGND VPWR VPWR _2534_/X sky130_fd_sc_hd__or2_2
X_1347_ _2660_/Q _2618_/B hold552/X _1356_/C1 VGND VGND VPWR VPWR _1347_/X sky130_fd_sc_hd__o211a_2
X_1416_ _2663_/Q _2662_/Q VGND VGND VPWR VPWR _1416_/X sky130_fd_sc_hd__xor2_2
X_2465_ _2460_/A _2460_/B _2385_/A VGND VGND VPWR VPWR _2467_/A sky130_fd_sc_hd__a21oi_2
X_2396_ _2486_/A _2485_/A _2485_/B _2370_/B _2694_/Q VGND VGND VPWR VPWR _2491_/A
+ sky130_fd_sc_hd__a32o_2
XFILLER_36_250 VGND VGND VPWR VPWR sky130_fd_sc_hd__fill_2
XFILLER_51_275 VGND VGND VPWR VPWR sky130_fd_sc_hd__decap_3
XFILLER_19_228 VGND VGND VPWR VPWR sky130_fd_sc_hd__fill_2
XFILLER_34_209 VGND VGND VPWR VPWR sky130_fd_sc_hd__decap_3
XFILLER_42_220 VGND VGND VPWR VPWR sky130_fd_sc_hd__decap_3
XFILLER_42_253 VGND VGND VPWR VPWR sky130_fd_sc_hd__fill_1
XFILLER_63_53 VGND VGND VPWR VPWR sky130_fd_sc_hd__decap_3
X_2250_ _2289_/A _2250_/B VGND VGND VPWR VPWR _2251_/B sky130_fd_sc_hd__or2_2
XFILLER_18_250 VGND VGND VPWR VPWR sky130_fd_sc_hd__fill_2
XFILLER_33_220 VGND VGND VPWR VPWR sky130_fd_sc_hd__decap_3
X_2181_ _2181_/A _2194_/B VGND VGND VPWR VPWR _2192_/A sky130_fd_sc_hd__xor2_2
XFILLER_33_253 VGND VGND VPWR VPWR sky130_fd_sc_hd__decap_3
XFILLER_33_264 VGND VGND VPWR VPWR sky130_fd_sc_hd__decap_3
X_1965_ _1965_/A _1965_/B VGND VGND VPWR VPWR _2004_/A sky130_fd_sc_hd__xor2_2
X_2517_ _2518_/A _2518_/B VGND VGND VPWR VPWR _2519_/B sky130_fd_sc_hd__and2_2
X_1896_ _1943_/A _1896_/B VGND VGND VPWR VPWR _1897_/B sky130_fd_sc_hd__nor2_2
XFILLER_56_301 VGND VGND VPWR VPWR sky130_fd_sc_hd__decap_3
XFILLER_56_312 VGND VGND VPWR VPWR sky130_fd_sc_hd__decap_3
X_2448_ _2448_/A VGND VGND VPWR VPWR _2449_/A sky130_fd_sc_hd__inv_2
X_2379_ _2674_/Q _2379_/B VGND VGND VPWR VPWR _2391_/B sky130_fd_sc_hd__xnor2_2
XFILLER_17_57 VGND VGND VPWR VPWR sky130_fd_sc_hd__fill_2
XFILLER_24_220 VGND VGND VPWR VPWR sky130_fd_sc_hd__decap_3
XFILLER_24_253 VGND VGND VPWR VPWR sky130_fd_sc_hd__fill_1
XFILLER_24_264 VGND VGND VPWR VPWR sky130_fd_sc_hd__decap_3
XFILLER_58_97 VGND VGND VPWR VPWR sky130_fd_sc_hd__fill_2
XFILLER_59_172 VGND VGND VPWR VPWR sky130_fd_sc_hd__fill_2
XFILLER_62_315 VGND VGND VPWR VPWR sky130_fd_sc_hd__decap_3
XFILLER_15_242 VGND VGND VPWR VPWR sky130_fd_sc_hd__fill_2
XFILLER_30_212 VGND VGND VPWR VPWR sky130_fd_sc_hd__decap_3
Xhold419 _2564_/X VGND VGND VPWR VPWR _2636_/D sky130_fd_sc_hd__clkbuf_2
Xhold408 hold408/A VGND VGND VPWR VPWR hold408/X sky130_fd_sc_hd__clkbuf_2
X_1681_ _1681_/A _1681_/B VGND VGND VPWR VPWR _1683_/B sky130_fd_sc_hd__xnor2_2
XFILLER_31_3 VGND VGND VPWR VPWR sky130_fd_sc_hd__fill_1
X_2302_ _2310_/A _2310_/B VGND VGND VPWR VPWR _2303_/B sky130_fd_sc_hd__xor2_2
X_2233_ _2233_/A _2233_/B VGND VGND VPWR VPWR _2244_/A sky130_fd_sc_hd__or2_2
X_2164_ _2555_/B _2290_/A2 _2313_/B _2553_/B VGND VGND VPWR VPWR _2201_/A sky130_fd_sc_hd__a22o_2
XTAP_TAPCELL_ROW_0_138 VGND VPWR sky130_fd_sc_hd__tapvpwrvgnd_1
X_2095_ _2551_/B _2095_/A2 _2095_/B1 _2629_/Q VGND VGND VPWR VPWR _2131_/A sky130_fd_sc_hd__a22o_2
XFILLER_21_234 VGND VGND VPWR VPWR sky130_fd_sc_hd__decap_3
XFILLER_21_245 VGND VGND VPWR VPWR sky130_fd_sc_hd__decap_3
XFILLER_21_278 VGND VGND VPWR VPWR sky130_fd_sc_hd__fill_2
X_1948_ _1948_/A _1953_/B VGND VGND VPWR VPWR _1948_/Y sky130_fd_sc_hd__nand2_2
X_1879_ _1880_/A _1880_/B VGND VGND VPWR VPWR _1930_/B sky130_fd_sc_hd__and2_2
Xmax_cap683 _2087_/A VGND VGND VPWR VPWR _2023_/A sky130_fd_sc_hd__buf_6
XFILLER_28_67 VGND VGND VPWR VPWR sky130_fd_sc_hd__decap_3
XFILLER_28_78 VGND VGND VPWR VPWR sky130_fd_sc_hd__decap_3
XFILLER_44_315 VGND VGND VPWR VPWR sky130_fd_sc_hd__fill_1
XFILLER_48_109 VGND VGND VPWR VPWR sky130_fd_sc_hd__decap_3
XFILLER_56_186 VGND VGND VPWR VPWR sky130_fd_sc_hd__decap_3
XFILLER_56_197 VGND VGND VPWR VPWR sky130_fd_sc_hd__decap_3
XTAP_TAPCELL_ROW_39_351 VGND VPWR sky130_fd_sc_hd__tapvpwrvgnd_1
XFILLER_12_256 VGND VGND VPWR VPWR sky130_fd_sc_hd__decap_3
XFILLER_44_44 VGND VGND VPWR VPWR sky130_fd_sc_hd__fill_1
XFILLER_44_88 VGND VGND VPWR VPWR sky130_fd_sc_hd__fill_1
XFILLER_60_21 VGND VGND VPWR VPWR sky130_fd_sc_hd__fill_2
XFILLER_5_38 VGND VGND VPWR VPWR sky130_fd_sc_hd__fill_2
XFILLER_60_54 VGND VGND VPWR VPWR sky130_fd_sc_hd__decap_3
Xclkbuf_4_0_0_clk clkbuf_0_clk/X VGND VGND VPWR VPWR _2668_/CLK sky130_fd_sc_hd__clkbuf_8
XFILLER_47_197 VGND VGND VPWR VPWR sky130_fd_sc_hd__decap_3
XTAP_TAPCELL_ROW_45_387 VGND VPWR sky130_fd_sc_hd__tapvpwrvgnd_1
X_1802_ _1802_/A VGND VGND VPWR VPWR _1803_/A sky130_fd_sc_hd__inv_2
X_1733_ _1733_/A _1733_/B VGND VGND VPWR VPWR _1733_/Y sky130_fd_sc_hd__xnor2_2
XFILLER_7_271 VGND VGND VPWR VPWR sky130_fd_sc_hd__decap_3
X_1595_ _1595_/A _1595_/B VGND VGND VPWR VPWR _1612_/B sky130_fd_sc_hd__xnor2_2
X_1664_ _1664_/A _1664_/B VGND VGND VPWR VPWR _1667_/A sky130_fd_sc_hd__xor2_2
XFILLER_38_153 VGND VGND VPWR VPWR sky130_fd_sc_hd__decap_3
XFILLER_38_197 VGND VGND VPWR VPWR sky130_fd_sc_hd__decap_3
XFILLER_53_101 VGND VGND VPWR VPWR sky130_fd_sc_hd__decap_3
X_2216_ _2216_/A _2216_/B _2216_/C VGND VGND VPWR VPWR _2217_/B sky130_fd_sc_hd__or3_2
X_2147_ _2145_/Y _2106_/B _2146_/Y VGND VGND VPWR VPWR _2161_/B sky130_fd_sc_hd__a21o_2
XFILLER_14_47 VGND VGND VPWR VPWR sky130_fd_sc_hd__fill_1
XFILLER_53_178 VGND VGND VPWR VPWR sky130_fd_sc_hd__decap_3
X_2078_ _2259_/A _2677_/Q _2114_/A _2077_/Y VGND VGND VPWR VPWR _2079_/B sky130_fd_sc_hd__o2bb2a_2
XFILLER_30_57 VGND VGND VPWR VPWR sky130_fd_sc_hd__decap_3
XFILLER_39_22 VGND VGND VPWR VPWR sky130_fd_sc_hd__decap_3
XFILLER_39_55 VGND VGND VPWR VPWR sky130_fd_sc_hd__fill_1
XFILLER_32_307 VGND VGND VPWR VPWR sky130_fd_sc_hd__fill_1
XFILLER_44_178 VGND VGND VPWR VPWR sky130_fd_sc_hd__decap_3
XTAP_TAPCELL_ROW_42_368 VGND VPWR sky130_fd_sc_hd__tapvpwrvgnd_1
X_1380_ _2657_/Q _1768_/A _2658_/Q VGND VGND VPWR VPWR _1380_/Y sky130_fd_sc_hd__o21ai_2
X_2001_ _1990_/A _1990_/B _2000_/X VGND VGND VPWR VPWR _2040_/A sky130_fd_sc_hd__a21o_2
XFILLER_50_115 VGND VGND VPWR VPWR sky130_fd_sc_hd__decap_3
X_2696_ _2696_/CLK _2696_/D VGND VGND VPWR VPWR _2696_/Q sky130_fd_sc_hd__dfxtp_2
X_1716_ _1716_/A _1716_/B VGND VGND VPWR VPWR _1725_/B sky130_fd_sc_hd__or2_2
X_1578_ _1520_/A _1520_/B _1577_/X VGND VGND VPWR VPWR _1579_/B sky130_fd_sc_hd__a21oi_2
X_1647_ _1701_/A _1647_/B VGND VGND VPWR VPWR _1653_/A sky130_fd_sc_hd__xnor2_2
XFILLER_26_134 VGND VGND VPWR VPWR sky130_fd_sc_hd__decap_3
XFILLER_25_57 VGND VGND VPWR VPWR sky130_fd_sc_hd__fill_2
XFILLER_41_12 VGND VGND VPWR VPWR sky130_fd_sc_hd__decap_3
XFILLER_41_23 VGND VGND VPWR VPWR sky130_fd_sc_hd__decap_3
XTAP_TAPCELL_ROW_64_493 VGND VPWR sky130_fd_sc_hd__tapvpwrvgnd_1
Xhold580 b_in[7] VGND VGND VPWR VPWR hold580/X sky130_fd_sc_hd__clkbuf_2
XFILLER_64_218 VGND VGND VPWR VPWR sky130_fd_sc_hd__decap_3
Xhold591 hold677/X VGND VGND VPWR VPWR hold678/A sky130_fd_sc_hd__clkbuf_2
XFILLER_17_189 VGND VGND VPWR VPWR sky130_fd_sc_hd__fill_1
XFILLER_32_115 VGND VGND VPWR VPWR sky130_fd_sc_hd__decap_3
XTAP_TAPCELL_ROW_30_305 VGND VPWR sky130_fd_sc_hd__tapvpwrvgnd_1
X_2550_ _2588_/A1 hold647/X _2550_/B1 _2549_/X VGND VGND VPWR VPWR _2550_/X sky130_fd_sc_hd__o211a_2
X_1363_ _1363_/A _1367_/B VGND VGND VPWR VPWR _1363_/X sky130_fd_sc_hd__or2_2
X_1432_ _1807_/B2 _1494_/B _1921_/B1 _1555_/A VGND VGND VPWR VPWR _1433_/B sky130_fd_sc_hd__a22o_2
X_1501_ _1502_/A _1502_/B VGND VGND VPWR VPWR _1501_/Y sky130_fd_sc_hd__nor2_2
X_2481_ _2481_/A _2492_/A _2480_/Y VGND VGND VPWR VPWR _2481_/X sky130_fd_sc_hd__or3b_2
XFILLER_48_281 VGND VGND VPWR VPWR sky130_fd_sc_hd__decap_3
XFILLER_63_240 VGND VGND VPWR VPWR sky130_fd_sc_hd__decap_3
XFILLER_63_273 VGND VGND VPWR VPWR sky130_fd_sc_hd__decap_3
XPHY_EDGE_ROW_43_Left_108 VGND VGND VPWR VPWR sky130_fd_sc_hd__decap_3
XTAP_TAPCELL_ROW_61_474 VGND VPWR sky130_fd_sc_hd__tapvpwrvgnd_1
Xplace295 _1792_/A VGND VGND VPWR VPWR _2259_/A sky130_fd_sc_hd__buf_1
Xplace284 _1710_/A2 VGND VGND VPWR VPWR _1854_/B2 sky130_fd_sc_hd__buf_1
Xplace273 _2629_/Q VGND VGND VPWR VPWR _1921_/B2 sky130_fd_sc_hd__buf_1
Xplace262 _2635_/Q VGND VGND VPWR VPWR _1926_/A1 sky130_fd_sc_hd__buf_1
Xplace251 _2660_/Q VGND VGND VPWR VPWR _2015_/A sky130_fd_sc_hd__buf_1
Xplace240 _2703_/Q VGND VGND VPWR VPWR _2708_/A sky130_fd_sc_hd__buf_1
XPHY_EDGE_ROW_52_Left_117 VGND VGND VPWR VPWR sky130_fd_sc_hd__decap_3
X_2679_ _2696_/CLK _2679_/D VGND VGND VPWR VPWR _2679_/Q sky130_fd_sc_hd__dfxtp_2
XFILLER_46_218 VGND VGND VPWR VPWR sky130_fd_sc_hd__fill_2
XFILLER_54_251 VGND VGND VPWR VPWR sky130_fd_sc_hd__fill_1
XFILLER_54_262 VGND VGND VPWR VPWR sky130_fd_sc_hd__decap_3
XPHY_EDGE_ROW_61_Left_126 VGND VGND VPWR VPWR sky130_fd_sc_hd__decap_3
XFILLER_22_181 VGND VGND VPWR VPWR sky130_fd_sc_hd__decap_3
XFILLER_22_192 VGND VGND VPWR VPWR sky130_fd_sc_hd__decap_3
XFILLER_52_44 VGND VGND VPWR VPWR sky130_fd_sc_hd__decap_3
XFILLER_6_303 VGND VGND VPWR VPWR sky130_fd_sc_hd__fill_2
XTAP_TAPCELL_ROW_9_185 VGND VPWR sky130_fd_sc_hd__tapvpwrvgnd_1
XFILLER_37_218 VGND VGND VPWR VPWR sky130_fd_sc_hd__decap_3
XFILLER_20_118 VGND VGND VPWR VPWR sky130_fd_sc_hd__decap_3
XFILLER_60_210 VGND VGND VPWR VPWR sky130_fd_sc_hd__fill_2
XFILLER_60_265 VGND VGND VPWR VPWR sky130_fd_sc_hd__decap_3
XFILLER_9_130 VGND VGND VPWR VPWR sky130_fd_sc_hd__fill_1
X_1981_ _1979_/A _1928_/B _1930_/A VGND VGND VPWR VPWR _2026_/B sky130_fd_sc_hd__a21oi_2
X_2602_ _2602_/A1 _1367_/A _2602_/B1 _2601_/X VGND VGND VPWR VPWR _2602_/X sky130_fd_sc_hd__o211a_2
X_2533_ _2580_/A1 hold615/X _2619_/C1 _2532_/X VGND VGND VPWR VPWR _2533_/X sky130_fd_sc_hd__o211a_2
X_1346_ _2606_/A _1352_/B VGND VGND VPWR VPWR _1346_/X sky130_fd_sc_hd__or2_2
X_2395_ _2472_/A _2472_/B _2472_/C _2478_/A _2423_/A VGND VGND VPWR VPWR _2485_/B
+ sky130_fd_sc_hd__a311o_2
XFILLER_36_284 VGND VGND VPWR VPWR sky130_fd_sc_hd__decap_3
XFILLER_51_287 VGND VGND VPWR VPWR sky130_fd_sc_hd__decap_3
XFILLER_47_66 VGND VGND VPWR VPWR sky130_fd_sc_hd__decap_3
XFILLER_27_284 VGND VGND VPWR VPWR sky130_fd_sc_hd__fill_1
XFILLER_63_32 VGND VGND VPWR VPWR sky130_fd_sc_hd__fill_1
XFILLER_63_43 VGND VGND VPWR VPWR sky130_fd_sc_hd__decap_3
X_2180_ _2131_/A _2131_/B _2139_/B _2138_/B _2138_/A VGND VGND VPWR VPWR _2194_/B
+ sky130_fd_sc_hd__a32o_2
XFILLER_18_295 VGND VGND VPWR VPWR sky130_fd_sc_hd__decap_3
XTAP_TAPCELL_ROW_28_290 VGND VPWR sky130_fd_sc_hd__tapvpwrvgnd_1
X_1964_ _1964_/A _1964_/B VGND VGND VPWR VPWR _1965_/B sky130_fd_sc_hd__xor2_2
X_1895_ _1895_/A _1895_/B _1895_/C VGND VGND VPWR VPWR _1896_/B sky130_fd_sc_hd__and3_2
XFILLER_0_309 VGND VGND VPWR VPWR sky130_fd_sc_hd__decap_3
X_1329_ _2699_/Q _1329_/B VGND VGND VPWR VPWR _1329_/Y sky130_fd_sc_hd__xnor2_2
X_2378_ _2692_/Q _2378_/B VGND VGND VPWR VPWR _2472_/A sky130_fd_sc_hd__xnor2_2
XFILLER_24_276 VGND VGND VPWR VPWR sky130_fd_sc_hd__decap_3
XFILLER_33_35 VGND VGND VPWR VPWR sky130_fd_sc_hd__decap_3
XFILLER_3_125 VGND VGND VPWR VPWR sky130_fd_sc_hd__fill_1
XFILLER_15_232 VGND VGND VPWR VPWR sky130_fd_sc_hd__decap_3
XFILLER_30_224 VGND VGND VPWR VPWR sky130_fd_sc_hd__decap_3
Xhold409 hold409/A VGND VGND VPWR VPWR _2446_/A sky130_fd_sc_hd__clkbuf_2
X_2301_ _2295_/A _2274_/B _2275_/A _2300_/X VGND VGND VPWR VPWR _2310_/B sky130_fd_sc_hd__o31ai_2
X_1680_ _1716_/A _1716_/B _1679_/X VGND VGND VPWR VPWR _1683_/A sky130_fd_sc_hd__a21oi_2
X_2232_ _2214_/B _2232_/B VGND VGND VPWR VPWR _2249_/B sky130_fd_sc_hd__and2b_2
X_2163_ _2129_/A _2129_/B _2126_/A VGND VGND VPWR VPWR _2168_/A sky130_fd_sc_hd__a21oi_2
XTAP_TAPCELL_ROW_0_139 VGND VPWR sky130_fd_sc_hd__tapvpwrvgnd_1
X_2094_ _2051_/A _2051_/B _2093_/Y VGND VGND VPWR VPWR _2099_/A sky130_fd_sc_hd__a21bo_2
X_1947_ _1943_/A _1896_/B _1947_/C _1947_/D VGND VGND VPWR VPWR _1953_/B sky130_fd_sc_hd__nand4bb_2
X_1878_ _2015_/A _1878_/B VGND VGND VPWR VPWR _1880_/B sky130_fd_sc_hd__xor2_2
XFILLER_0_139 VGND VGND VPWR VPWR sky130_fd_sc_hd__fill_1
XFILLER_44_23 VGND VGND VPWR VPWR sky130_fd_sc_hd__fill_2
XFILLER_56_110 VGND VGND VPWR VPWR sky130_fd_sc_hd__decap_3
XFILLER_56_154 VGND VGND VPWR VPWR sky130_fd_sc_hd__decap_3
XTAP_TAPCELL_ROW_39_352 VGND VPWR sky130_fd_sc_hd__tapvpwrvgnd_1
XFILLER_12_246 VGND VGND VPWR VPWR sky130_fd_sc_hd__decap_3
XFILLER_12_279 VGND VGND VPWR VPWR sky130_fd_sc_hd__decap_3
XFILLER_44_78 VGND VGND VPWR VPWR sky130_fd_sc_hd__decap_3
XFILLER_47_132 VGND VGND VPWR VPWR sky130_fd_sc_hd__fill_1
XPHY_EDGE_ROW_8_Left_73 VGND VGND VPWR VPWR sky130_fd_sc_hd__decap_3
XFILLER_47_176 VGND VGND VPWR VPWR sky130_fd_sc_hd__fill_2
X_1801_ _1787_/B _1801_/B VGND VGND VPWR VPWR _1843_/A sky130_fd_sc_hd__and2b_2
X_1732_ _1726_/A _1726_/B _1724_/D _1731_/X VGND VGND VPWR VPWR _1732_/Y sky130_fd_sc_hd__o211ai_2
X_1663_ _1735_/A _1735_/B VGND VGND VPWR VPWR _1663_/X sky130_fd_sc_hd__or2_2
XPHY_EDGE_ROW_7_Right_7 VGND VGND VPWR VPWR sky130_fd_sc_hd__decap_3
X_1594_ _1807_/B2 _1625_/B _1420_/X _2622_/Q VGND VGND VPWR VPWR _1595_/B sky130_fd_sc_hd__a22o_2
XFILLER_38_165 VGND VGND VPWR VPWR sky130_fd_sc_hd__decap_3
XFILLER_38_187 VGND VGND VPWR VPWR sky130_fd_sc_hd__decap_3
XFILLER_53_113 VGND VGND VPWR VPWR sky130_fd_sc_hd__decap_3
XFILLER_53_157 VGND VGND VPWR VPWR sky130_fd_sc_hd__fill_2
XTAP_TAPCELL_ROW_36_333 VGND VPWR sky130_fd_sc_hd__tapvpwrvgnd_1
X_2215_ _2216_/A _2216_/B _2216_/C VGND VGND VPWR VPWR _2251_/A sky130_fd_sc_hd__o21ai_2
X_2146_ _2146_/A _2146_/B VGND VGND VPWR VPWR _2146_/Y sky130_fd_sc_hd__nor2_2
X_2077_ _2222_/A _2076_/B _1948_/A VGND VGND VPWR VPWR _2077_/Y sky130_fd_sc_hd__o21ai_2
XFILLER_14_26 VGND VGND VPWR VPWR sky130_fd_sc_hd__fill_2
XFILLER_29_154 VGND VGND VPWR VPWR sky130_fd_sc_hd__fill_1
XFILLER_39_12 VGND VGND VPWR VPWR sky130_fd_sc_hd__fill_1
XFILLER_39_67 VGND VGND VPWR VPWR sky130_fd_sc_hd__fill_1
XFILLER_44_113 VGND VGND VPWR VPWR sky130_fd_sc_hd__decap_3
XFILLER_55_55 VGND VGND VPWR VPWR sky130_fd_sc_hd__fill_1
XPHY_EDGE_ROW_34_Left_99 VGND VGND VPWR VPWR sky130_fd_sc_hd__decap_3
XTAP_TAPCELL_ROW_42_369 VGND VPWR sky130_fd_sc_hd__tapvpwrvgnd_1
XFILLER_4_253 VGND VGND VPWR VPWR sky130_fd_sc_hd__decap_3
X_2000_ _1989_/B _2000_/B VGND VGND VPWR VPWR _2000_/X sky130_fd_sc_hd__and2b_2
XFILLER_35_157 VGND VGND VPWR VPWR sky130_fd_sc_hd__decap_3
XFILLER_50_149 VGND VGND VPWR VPWR sky130_fd_sc_hd__fill_2
XFILLER_6_82 VGND VGND VPWR VPWR sky130_fd_sc_hd__fill_2
X_1646_ _1700_/A1 _1646_/A2 _2627_/Q _1700_/B2 VGND VGND VPWR VPWR _1647_/B sky130_fd_sc_hd__a22o_2
X_2695_ _2696_/CLK _2695_/D VGND VGND VPWR VPWR _2695_/Q sky130_fd_sc_hd__dfxtp_2
X_1715_ _1716_/A _1716_/B VGND VGND VPWR VPWR _1725_/A sky130_fd_sc_hd__nand2_2
XFILLER_58_238 VGND VGND VPWR VPWR sky130_fd_sc_hd__decap_3
X_1577_ _1577_/A _1577_/B VGND VGND VPWR VPWR _1577_/X sky130_fd_sc_hd__and2_2
XFILLER_26_113 VGND VGND VPWR VPWR sky130_fd_sc_hd__decap_3
XFILLER_41_116 VGND VGND VPWR VPWR sky130_fd_sc_hd__decap_3
XTAP_TAPCELL_ROW_64_494 VGND VPWR sky130_fd_sc_hd__tapvpwrvgnd_1
X_2129_ _2129_/A _2129_/B VGND VGND VPWR VPWR _2177_/B sky130_fd_sc_hd__xnor2_2
XFILLER_41_35 VGND VGND VPWR VPWR sky130_fd_sc_hd__decap_3
XFILLER_1_267 VGND VGND VPWR VPWR sky130_fd_sc_hd__decap_3
Xhold570 b_in[4] VGND VGND VPWR VPWR hold570/X sky130_fd_sc_hd__clkbuf_2
Xhold581 hold581/A VGND VGND VPWR VPWR hold581/X sky130_fd_sc_hd__clkbuf_2
Xhold592 hold592/A VGND VGND VPWR VPWR hold592/X sky130_fd_sc_hd__clkbuf_2
XFILLER_17_113 VGND VGND VPWR VPWR sky130_fd_sc_hd__fill_2
XFILLER_49_216 VGND VGND VPWR VPWR sky130_fd_sc_hd__decap_3
XFILLER_57_271 VGND VGND VPWR VPWR sky130_fd_sc_hd__decap_3
XFILLER_57_293 VGND VGND VPWR VPWR sky130_fd_sc_hd__decap_3
X_1500_ _1500_/A _1500_/B VGND VGND VPWR VPWR _1620_/B sky130_fd_sc_hd__xnor2_2
X_2480_ _2480_/A _2480_/B VGND VGND VPWR VPWR _2480_/Y sky130_fd_sc_hd__nand2_2
X_1362_ _2666_/Q _2610_/A _1361_/X _2572_/C1 VGND VGND VPWR VPWR _2666_/D sky130_fd_sc_hd__o211a_2
XFILLER_63_252 VGND VGND VPWR VPWR sky130_fd_sc_hd__decap_3
Xplace263 _2634_/Q VGND VGND VPWR VPWR _2265_/B2 sky130_fd_sc_hd__buf_1
Xplace252 _1772_/A VGND VGND VPWR VPWR _1572_/A sky130_fd_sc_hd__clkbuf_1
Xplace241 _2703_/Q VGND VGND VPWR VPWR _1314_/A sky130_fd_sc_hd__buf_1
Xplace230 _1407_/X VGND VGND VPWR VPWR _1670_/B sky130_fd_sc_hd__buf_1
XTAP_TAPCELL_ROW_61_475 VGND VPWR sky130_fd_sc_hd__tapvpwrvgnd_1
Xplace296 _2550_/B1 VGND VGND VPWR VPWR _2619_/C1 sky130_fd_sc_hd__buf_1
Xplace285 _2624_/Q VGND VGND VPWR VPWR _1710_/A2 sky130_fd_sc_hd__buf_1
Xplace274 _2629_/Q VGND VGND VPWR VPWR _1628_/A2 sky130_fd_sc_hd__buf_1
X_1629_ _1701_/A _1629_/B VGND VGND VPWR VPWR _1635_/A sky130_fd_sc_hd__xnor2_2
X_2678_ clkload9/A _2678_/D VGND VGND VPWR VPWR _2678_/Q sky130_fd_sc_hd__dfxtp_2
XFILLER_39_260 VGND VGND VPWR VPWR sky130_fd_sc_hd__decap_3
XFILLER_36_68 VGND VGND VPWR VPWR sky130_fd_sc_hd__decap_3
XFILLER_52_56 VGND VGND VPWR VPWR sky130_fd_sc_hd__decap_3
XFILLER_54_285 VGND VGND VPWR VPWR sky130_fd_sc_hd__decap_3
XFILLER_22_171 VGND VGND VPWR VPWR sky130_fd_sc_hd__fill_2
XFILLER_52_78 VGND VGND VPWR VPWR sky130_fd_sc_hd__decap_3
XTAP_TAPCELL_ROW_9_186 VGND VPWR sky130_fd_sc_hd__tapvpwrvgnd_1
XFILLER_60_200 VGND VGND VPWR VPWR sky130_fd_sc_hd__decap_3
X_1980_ _2015_/C _1980_/B VGND VGND VPWR VPWR _2026_/A sky130_fd_sc_hd__nand2_2
XPHY_EDGE_ROW_21_Left_86 VGND VGND VPWR VPWR sky130_fd_sc_hd__decap_3
X_2601_ _2608_/A _2652_/Q VGND VGND VPWR VPWR _2601_/X sky130_fd_sc_hd__or2_2
X_2532_ _2579_/A _2622_/Q VGND VGND VPWR VPWR _2532_/X sky130_fd_sc_hd__or2_2
X_2463_ _2528_/A _2463_/B VGND VGND VPWR VPWR _2690_/D sky130_fd_sc_hd__and2_2
X_1414_ _2664_/Q VGND VGND VPWR VPWR _2197_/B sky130_fd_sc_hd__inv_2
X_2394_ _2372_/B _2372_/C _2693_/Q VGND VGND VPWR VPWR _2423_/A sky130_fd_sc_hd__a21boi_2
XFILLER_51_200 VGND VGND VPWR VPWR sky130_fd_sc_hd__decap_3
XFILLER_51_222 VGND VGND VPWR VPWR sky130_fd_sc_hd__fill_2
XFILLER_27_274 VGND VGND VPWR VPWR sky130_fd_sc_hd__decap_3
XFILLER_42_200 VGND VGND VPWR VPWR sky130_fd_sc_hd__decap_3
XFILLER_47_23 VGND VGND VPWR VPWR sky130_fd_sc_hd__decap_3
XFILLER_47_78 VGND VGND VPWR VPWR sky130_fd_sc_hd__fill_1
XFILLER_42_266 VGND VGND VPWR VPWR sky130_fd_sc_hd__decap_3
XFILLER_42_299 VGND VGND VPWR VPWR sky130_fd_sc_hd__fill_1
XFILLER_10_185 VGND VGND VPWR VPWR sky130_fd_sc_hd__decap_3
XFILLER_6_123 VGND VGND VPWR VPWR sky130_fd_sc_hd__fill_2
XFILLER_6_145 VGND VGND VPWR VPWR sky130_fd_sc_hd__decap_3
XFILLER_6_178 VGND VGND VPWR VPWR sky130_fd_sc_hd__decap_3
XFILLER_33_233 VGND VGND VPWR VPWR sky130_fd_sc_hd__decap_3
XTAP_TAPCELL_ROW_28_291 VGND VPWR sky130_fd_sc_hd__tapvpwrvgnd_1
X_1963_ _2005_/A _2005_/B VGND VGND VPWR VPWR _1964_/B sky130_fd_sc_hd__xor2_2
X_1894_ _1895_/A _1895_/B _1895_/C VGND VGND VPWR VPWR _1943_/A sky130_fd_sc_hd__a21oi_2
X_2515_ _2525_/A _2515_/B VGND VGND VPWR VPWR _2700_/D sky130_fd_sc_hd__and2_2
X_2446_ _2446_/A _2446_/B VGND VGND VPWR VPWR _2446_/Y sky130_fd_sc_hd__nor2_2
XFILLER_24_200 VGND VGND VPWR VPWR sky130_fd_sc_hd__fill_1
X_1328_ _2698_/Q _1327_/B _2708_/A VGND VGND VPWR VPWR _1329_/B sky130_fd_sc_hd__o21ai_2
X_2377_ _2377_/A _2377_/B VGND VGND VPWR VPWR _2378_/B sky130_fd_sc_hd__xnor2_2
XFILLER_24_233 VGND VGND VPWR VPWR sky130_fd_sc_hd__decap_3
XFILLER_24_299 VGND VGND VPWR VPWR sky130_fd_sc_hd__decap_3
XFILLER_33_69 VGND VGND VPWR VPWR sky130_fd_sc_hd__fill_1
XFILLER_58_22 VGND VGND VPWR VPWR sky130_fd_sc_hd__decap_3
XFILLER_58_77 VGND VGND VPWR VPWR sky130_fd_sc_hd__fill_2
XFILLER_58_88 VGND VGND VPWR VPWR sky130_fd_sc_hd__fill_2
XFILLER_59_163 VGND VGND VPWR VPWR sky130_fd_sc_hd__decap_3
XFILLER_59_185 VGND VGND VPWR VPWR sky130_fd_sc_hd__decap_3
XFILLER_15_222 VGND VGND VPWR VPWR sky130_fd_sc_hd__fill_2
XFILLER_30_203 VGND VGND VPWR VPWR sky130_fd_sc_hd__decap_3
XFILLER_30_236 VGND VGND VPWR VPWR sky130_fd_sc_hd__decap_3
X_2300_ _2300_/A _2276_/B VGND VGND VPWR VPWR _2300_/X sky130_fd_sc_hd__or2b_2
X_2231_ _2259_/A _2682_/Q VGND VGND VPWR VPWR _2231_/Y sky130_fd_sc_hd__nand2_2
X_2162_ _2162_/A _2162_/B VGND VGND VPWR VPWR _2169_/A sky130_fd_sc_hd__and2_2
X_2093_ _2093_/A _2093_/B VGND VGND VPWR VPWR _2093_/Y sky130_fd_sc_hd__nand2_2
XFILLER_21_225 VGND VGND VPWR VPWR sky130_fd_sc_hd__decap_3
XFILLER_21_269 VGND VGND VPWR VPWR sky130_fd_sc_hd__decap_3
X_1946_ _1946_/A _2071_/B VGND VGND VPWR VPWR _1994_/A sky130_fd_sc_hd__and2_2
X_1877_ _1877_/A1 _1390_/A _1390_/B _1926_/B1 _1926_/A1 VGND VGND VPWR VPWR _1878_/B
+ sky130_fd_sc_hd__a32o_2
XFILLER_29_314 VGND VGND VPWR VPWR sky130_fd_sc_hd__decap_3
XFILLER_56_122 VGND VGND VPWR VPWR sky130_fd_sc_hd__fill_2
X_2429_ _2486_/A _2460_/A _2480_/B _2429_/D VGND VGND VPWR VPWR _2429_/X sky130_fd_sc_hd__and4_2
XFILLER_56_166 VGND VGND VPWR VPWR sky130_fd_sc_hd__decap_3
XTAP_TAPCELL_ROW_39_353 VGND VPWR sky130_fd_sc_hd__tapvpwrvgnd_1
XFILLER_12_214 VGND VGND VPWR VPWR sky130_fd_sc_hd__fill_2
XFILLER_12_225 VGND VGND VPWR VPWR sky130_fd_sc_hd__decap_3
XFILLER_60_45 VGND VGND VPWR VPWR sky130_fd_sc_hd__decap_3
XFILLER_60_78 VGND VGND VPWR VPWR sky130_fd_sc_hd__decap_3
XFILLER_8_229 VGND VGND VPWR VPWR sky130_fd_sc_hd__fill_1
XFILLER_47_155 VGND VGND VPWR VPWR sky130_fd_sc_hd__decap_3
X_1800_ _1800_/A _1789_/B VGND VGND VPWR VPWR _1898_/A sky130_fd_sc_hd__or2b_2
XFILLER_7_240 VGND VGND VPWR VPWR sky130_fd_sc_hd__fill_1
XFILLER_7_262 VGND VGND VPWR VPWR sky130_fd_sc_hd__decap_3
X_1731_ _1723_/A _1723_/B _1730_/X _1724_/A VGND VGND VPWR VPWR _1731_/X sky130_fd_sc_hd__a22o_2
X_1662_ _1689_/B _1689_/C _1689_/A VGND VGND VPWR VPWR _1735_/B sky130_fd_sc_hd__a21o_2
X_1593_ _1671_/A _1593_/B VGND VGND VPWR VPWR _1612_/A sky130_fd_sc_hd__xor2_2
X_2214_ _2232_/B _2214_/B VGND VGND VPWR VPWR _2216_/C sky130_fd_sc_hd__xnor2_2
XFILLER_26_317 VGND VGND VPWR VPWR sky130_fd_sc_hd__decap_3
XFILLER_53_169 VGND VGND VPWR VPWR sky130_fd_sc_hd__decap_3
XTAP_TAPCELL_ROW_36_334 VGND VPWR sky130_fd_sc_hd__tapvpwrvgnd_1
X_2145_ _2146_/A _2146_/B VGND VGND VPWR VPWR _2145_/Y sky130_fd_sc_hd__nand2_2
X_2076_ _2222_/A _2076_/B VGND VGND VPWR VPWR _2114_/A sky130_fd_sc_hd__and2_2
X_1929_ _1930_/A _1930_/B _1930_/D _1930_/C VGND VGND VPWR VPWR _1931_/A sky130_fd_sc_hd__o31a_2
XFILLER_17_306 VGND VGND VPWR VPWR sky130_fd_sc_hd__fill_1
XFILLER_29_100 VGND VGND VPWR VPWR sky130_fd_sc_hd__decap_3
XFILLER_29_122 VGND VGND VPWR VPWR sky130_fd_sc_hd__decap_3
XFILLER_44_125 VGND VGND VPWR VPWR sky130_fd_sc_hd__fill_2
XFILLER_4_232 VGND VGND VPWR VPWR sky130_fd_sc_hd__fill_1
XFILLER_4_265 VGND VGND VPWR VPWR sky130_fd_sc_hd__decap_3
XFILLER_4_287 VGND VGND VPWR VPWR sky130_fd_sc_hd__decap_3
XFILLER_4_298 VGND VGND VPWR VPWR sky130_fd_sc_hd__fill_1
XFILLER_35_169 VGND VGND VPWR VPWR sky130_fd_sc_hd__decap_3
XFILLER_50_139 VGND VGND VPWR VPWR sky130_fd_sc_hd__fill_1
X_1576_ _1576_/A _1576_/B VGND VGND VPWR VPWR _1781_/B sky130_fd_sc_hd__xor2_2
X_1645_ _1645_/A _1645_/B VGND VGND VPWR VPWR _1735_/A sky130_fd_sc_hd__xnor2_2
X_2694_ _2703_/CLK _2694_/D VGND VGND VPWR VPWR _2694_/Q sky130_fd_sc_hd__dfxtp_2
X_1714_ _1714_/A _1714_/B VGND VGND VPWR VPWR _1724_/C sky130_fd_sc_hd__and2_2
XFILLER_34_191 VGND VGND VPWR VPWR sky130_fd_sc_hd__decap_3
XFILLER_41_128 VGND VGND VPWR VPWR sky130_fd_sc_hd__decap_3
XTAP_TAPCELL_ROW_64_495 VGND VPWR sky130_fd_sc_hd__tapvpwrvgnd_1
X_2128_ _2274_/A _2128_/B VGND VGND VPWR VPWR _2129_/B sky130_fd_sc_hd__xnor2_2
X_2059_ _2059_/A _2059_/B VGND VGND VPWR VPWR _2092_/B sky130_fd_sc_hd__xnor2_2
XFILLER_41_69 VGND VGND VPWR VPWR sky130_fd_sc_hd__decap_3
XFILLER_1_246 VGND VGND VPWR VPWR sky130_fd_sc_hd__fill_1
XFILLER_49_228 VGND VGND VPWR VPWR sky130_fd_sc_hd__decap_3
Xhold560 hold560/A VGND VGND VPWR VPWR hold560/X sky130_fd_sc_hd__clkbuf_2
Xhold571 hold571/A VGND VGND VPWR VPWR hold571/X sky130_fd_sc_hd__clkbuf_2
Xhold582 hold582/A VGND VGND VPWR VPWR hold582/X sky130_fd_sc_hd__clkbuf_2
Xhold593 _1373_/X VGND VGND VPWR VPWR _1374_/B sky130_fd_sc_hd__clkbuf_2
XFILLER_17_169 VGND VGND VPWR VPWR sky130_fd_sc_hd__fill_2
XTAP_TAPCELL_ROW_55_440 VGND VPWR sky130_fd_sc_hd__tapvpwrvgnd_1
XFILLER_32_106 VGND VGND VPWR VPWR sky130_fd_sc_hd__decap_3
XFILLER_31_91 VGND VGND VPWR VPWR sky130_fd_sc_hd__decap_3
X_1430_ _1430_/A _1430_/B VGND VGND VPWR VPWR _1430_/Y sky130_fd_sc_hd__nor2_2
XFILLER_48_250 VGND VGND VPWR VPWR sky130_fd_sc_hd__fill_2
X_1361_ _1361_/A _1367_/B VGND VGND VPWR VPWR _1361_/X sky130_fd_sc_hd__or2_2
XFILLER_23_106 VGND VGND VPWR VPWR sky130_fd_sc_hd__decap_3
XFILLER_63_231 VGND VGND VPWR VPWR sky130_fd_sc_hd__decap_3
XFILLER_63_264 VGND VGND VPWR VPWR sky130_fd_sc_hd__decap_3
Xplace297 _2580_/B1 VGND VGND VPWR VPWR _2602_/B1 sky130_fd_sc_hd__buf_1
Xplace286 _2623_/Q VGND VGND VPWR VPWR _1807_/B2 sky130_fd_sc_hd__buf_1
Xplace275 _2628_/Q VGND VGND VPWR VPWR _2057_/B2 sky130_fd_sc_hd__buf_1
Xplace264 _2634_/Q VGND VGND VPWR VPWR _1877_/A1 sky130_fd_sc_hd__buf_1
Xplace253 _2658_/Q VGND VGND VPWR VPWR _1826_/A sky130_fd_sc_hd__clkbuf_1
Xplace242 _2666_/Q VGND VGND VPWR VPWR _2295_/A sky130_fd_sc_hd__buf_1
Xplace231 _1386_/X VGND VGND VPWR VPWR _1926_/B1 sky130_fd_sc_hd__buf_1
Xplace220 _2023_/A VGND VGND VPWR VPWR _1764_/A sky130_fd_sc_hd__clkbuf_1
X_1559_ _1921_/B2 _2017_/A2 _2017_/A3 _1916_/B1 _2630_/Q VGND VGND VPWR VPWR _1560_/B
+ sky130_fd_sc_hd__a32o_2
X_1628_ _1700_/A1 _1628_/A2 _1646_/A2 _1700_/B2 VGND VGND VPWR VPWR _1629_/B sky130_fd_sc_hd__a22o_2
X_2677_ clkload9/A _2677_/D VGND VGND VPWR VPWR _2677_/Q sky130_fd_sc_hd__dfxtp_2
XFILLER_52_24 VGND VGND VPWR VPWR sky130_fd_sc_hd__decap_3
XFILLER_52_35 VGND VGND VPWR VPWR sky130_fd_sc_hd__fill_1
XTAP_TAPCELL_ROW_52_421 VGND VPWR sky130_fd_sc_hd__tapvpwrvgnd_1
XTAP_TAPCELL_ROW_9_187 VGND VPWR sky130_fd_sc_hd__tapvpwrvgnd_1
XFILLER_26_80 VGND VGND VPWR VPWR sky130_fd_sc_hd__decap_3
XFILLER_45_231 VGND VGND VPWR VPWR sky130_fd_sc_hd__fill_2
XFILLER_60_245 VGND VGND VPWR VPWR sky130_fd_sc_hd__decap_3
XFILLER_60_256 VGND VGND VPWR VPWR sky130_fd_sc_hd__decap_3
XFILLER_60_289 VGND VGND VPWR VPWR sky130_fd_sc_hd__decap_3
XFILLER_9_110 VGND VGND VPWR VPWR sky130_fd_sc_hd__fill_2
XFILLER_9_176 VGND VGND VPWR VPWR sky130_fd_sc_hd__decap_3
X_2600_ _2602_/A1 _1365_/A _2602_/B1 _2599_/X VGND VGND VPWR VPWR _2600_/X sky130_fd_sc_hd__o211a_2
XFILLER_47_3 VGND VGND VPWR VPWR sky130_fd_sc_hd__fill_2
X_1413_ _1671_/A _1413_/B VGND VGND VPWR VPWR _1471_/A sky130_fd_sc_hd__xor2_2
X_2462_ _2690_/Q _2488_/A2 _2450_/Y _2461_/X VGND VGND VPWR VPWR _2463_/B sky130_fd_sc_hd__a22o_2
X_2393_ _2378_/B _2692_/Q VGND VGND VPWR VPWR _2478_/A sky130_fd_sc_hd__and2b_2
XFILLER_36_253 VGND VGND VPWR VPWR sky130_fd_sc_hd__decap_3
X_1344_ _2659_/Q _2618_/B _1340_/X _1356_/C1 VGND VGND VPWR VPWR _1344_/X sky130_fd_sc_hd__o211a_2
XFILLER_51_278 VGND VGND VPWR VPWR sky130_fd_sc_hd__fill_2
XTAP_TAPCELL_ROW_6_168 VGND VPWR sky130_fd_sc_hd__tapvpwrvgnd_1
XFILLER_42_212 VGND VGND VPWR VPWR sky130_fd_sc_hd__fill_1
XPHY_EDGE_ROW_29_Right_29 VGND VGND VPWR VPWR sky130_fd_sc_hd__decap_3
XFILLER_8_29 VGND VGND VPWR VPWR sky130_fd_sc_hd__fill_1
XPHY_EDGE_ROW_38_Right_38 VGND VGND VPWR VPWR sky130_fd_sc_hd__decap_3
XFILLER_10_197 VGND VGND VPWR VPWR sky130_fd_sc_hd__decap_3
XFILLER_18_231 VGND VGND VPWR VPWR sky130_fd_sc_hd__fill_2
XPHY_EDGE_ROW_47_Right_47 VGND VGND VPWR VPWR sky130_fd_sc_hd__decap_3
XFILLER_18_253 VGND VGND VPWR VPWR sky130_fd_sc_hd__fill_2
XFILLER_18_264 VGND VGND VPWR VPWR sky130_fd_sc_hd__decap_3
XFILLER_33_223 VGND VGND VPWR VPWR sky130_fd_sc_hd__fill_1
XFILLER_33_256 VGND VGND VPWR VPWR sky130_fd_sc_hd__decap_3
XFILLER_33_267 VGND VGND VPWR VPWR sky130_fd_sc_hd__decap_3
XPHY_EDGE_ROW_56_Right_56 VGND VGND VPWR VPWR sky130_fd_sc_hd__decap_3
XTAP_TAPCELL_ROW_28_292 VGND VPWR sky130_fd_sc_hd__tapvpwrvgnd_1
X_1962_ _1962_/A _1962_/B VGND VGND VPWR VPWR _2005_/B sky130_fd_sc_hd__xnor2_2
X_1893_ _1893_/A _1893_/B VGND VGND VPWR VPWR _1895_/C sky130_fd_sc_hd__xnor2_2
XFILLER_56_304 VGND VGND VPWR VPWR sky130_fd_sc_hd__decap_3
X_2514_ _2700_/Q _2524_/A2 _2524_/B1 _2513_/Y VGND VGND VPWR VPWR _2515_/B sky130_fd_sc_hd__a22o_2
X_2445_ _2707_/A _2488_/A2 _2444_/X VGND VGND VPWR VPWR _2446_/B sky130_fd_sc_hd__a21oi_2
X_2376_ _2368_/A _2674_/Q _2379_/B VGND VGND VPWR VPWR _2377_/B sky130_fd_sc_hd__a21o_2
XFILLER_56_315 VGND VGND VPWR VPWR sky130_fd_sc_hd__decap_3
X_1327_ _2698_/Q _1327_/B VGND VGND VPWR VPWR _1327_/X sky130_fd_sc_hd__xor2_2
XFILLER_24_267 VGND VGND VPWR VPWR sky130_fd_sc_hd__fill_2
XPHY_EDGE_ROW_49_Left_114 VGND VGND VPWR VPWR sky130_fd_sc_hd__decap_3
XPHY_EDGE_ROW_58_Left_123 VGND VGND VPWR VPWR sky130_fd_sc_hd__decap_3
XFILLER_30_215 VGND VGND VPWR VPWR sky130_fd_sc_hd__decap_3
XFILLER_62_318 VGND VGND VPWR VPWR sky130_fd_sc_hd__fill_2
XTAP_TAPCELL_ROW_17_229 VGND VPWR sky130_fd_sc_hd__tapvpwrvgnd_1
XTAP_TAPCELL_ROW_25_273 VGND VPWR sky130_fd_sc_hd__tapvpwrvgnd_1
X_2230_ _2230_/A _2230_/B VGND VGND VPWR VPWR _2681_/D sky130_fd_sc_hd__nor2_2
X_2161_ _2161_/A _2161_/B VGND VGND VPWR VPWR _2186_/A sky130_fd_sc_hd__nand2_2
X_2092_ _2092_/A _2092_/B VGND VGND VPWR VPWR _2100_/A sky130_fd_sc_hd__nand2_2
XFILLER_21_248 VGND VGND VPWR VPWR sky130_fd_sc_hd__fill_2
X_1945_ _1947_/D _1897_/B _1946_/A _2071_/B VGND VGND VPWR VPWR _1945_/Y sky130_fd_sc_hd__a211oi_2
X_1876_ _1976_/D _1872_/Y _1928_/A VGND VGND VPWR VPWR _1880_/A sky130_fd_sc_hd__a21oi_2
XFILLER_28_26 VGND VGND VPWR VPWR sky130_fd_sc_hd__fill_2
XFILLER_56_101 VGND VGND VPWR VPWR sky130_fd_sc_hd__decap_3
X_2428_ _2428_/A _2472_/A _2452_/B _2467_/B VGND VGND VPWR VPWR _2429_/D sky130_fd_sc_hd__and4_2
X_2359_ _2697_/Q _2400_/B VGND VGND VPWR VPWR _2420_/A sky130_fd_sc_hd__and2_2
XFILLER_44_307 VGND VGND VPWR VPWR sky130_fd_sc_hd__fill_1
XFILLER_44_69 VGND VGND VPWR VPWR sky130_fd_sc_hd__decap_3
XFILLER_56_189 VGND VGND VPWR VPWR sky130_fd_sc_hd__decap_3
XTAP_TAPCELL_ROW_39_354 VGND VPWR sky130_fd_sc_hd__tapvpwrvgnd_1
XFILLER_12_237 VGND VGND VPWR VPWR sky130_fd_sc_hd__fill_2
XFILLER_12_259 VGND VGND VPWR VPWR sky130_fd_sc_hd__decap_3
XFILLER_5_19 VGND VGND VPWR VPWR sky130_fd_sc_hd__fill_2
XFILLER_60_57 VGND VGND VPWR VPWR sky130_fd_sc_hd__decap_3
XFILLER_62_148 VGND VGND VPWR VPWR sky130_fd_sc_hd__decap_3
XTAP_TAPCELL_ROW_13_210 VGND VPWR sky130_fd_sc_hd__tapvpwrvgnd_1
XFILLER_7_274 VGND VGND VPWR VPWR sky130_fd_sc_hd__decap_3
X_1592_ _1700_/A2 _1670_/B _1411_/X _1710_/A2 VGND VGND VPWR VPWR _1593_/B sky130_fd_sc_hd__a22o_2
X_1730_ _1714_/A _1714_/B _1729_/X VGND VGND VPWR VPWR _1730_/X sky130_fd_sc_hd__o21ba_2
X_1661_ _1661_/A _1661_/B VGND VGND VPWR VPWR _1689_/A sky130_fd_sc_hd__xnor2_2
XFILLER_38_134 VGND VGND VPWR VPWR sky130_fd_sc_hd__fill_2
X_2213_ _2169_/A _2169_/B _2212_/X VGND VGND VPWR VPWR _2214_/B sky130_fd_sc_hd__a21oi_2
X_2144_ _2144_/A _2144_/B VGND VGND VPWR VPWR _2161_/A sky130_fd_sc_hd__xor2_2
XFILLER_38_156 VGND VGND VPWR VPWR sky130_fd_sc_hd__decap_3
XFILLER_53_104 VGND VGND VPWR VPWR sky130_fd_sc_hd__decap_3
XTAP_TAPCELL_ROW_36_335 VGND VPWR sky130_fd_sc_hd__tapvpwrvgnd_1
X_2075_ _1900_/B _2071_/Y _2072_/X _2074_/Y VGND VGND VPWR VPWR _2076_/B sky130_fd_sc_hd__o211ai_2
XFILLER_30_27 VGND VGND VPWR VPWR sky130_fd_sc_hd__fill_1
X_1928_ _1928_/A _1928_/B VGND VGND VPWR VPWR _1930_/C sky130_fd_sc_hd__xnor2_2
X_1859_ _1915_/A _1859_/B VGND VGND VPWR VPWR _1860_/B sky130_fd_sc_hd__and2_2
XFILLER_39_25 VGND VGND VPWR VPWR sky130_fd_sc_hd__decap_3
XFILLER_55_35 VGND VGND VPWR VPWR sky130_fd_sc_hd__fill_1
XFILLER_44_148 VGND VGND VPWR VPWR sky130_fd_sc_hd__decap_3
XFILLER_52_170 VGND VGND VPWR VPWR sky130_fd_sc_hd__decap_3
XFILLER_4_200 VGND VGND VPWR VPWR sky130_fd_sc_hd__decap_3
Xinput340 hold563/X VGND VGND VPWR VPWR hold564/A sky130_fd_sc_hd__buf_2
XFILLER_35_126 VGND VGND VPWR VPWR sky130_fd_sc_hd__decap_3
XFILLER_50_118 VGND VGND VPWR VPWR sky130_fd_sc_hd__fill_1
X_1713_ _1604_/A _1712_/A _1712_/Y VGND VGND VPWR VPWR _1714_/B sky130_fd_sc_hd__a21o_2
X_1575_ _1829_/A _1575_/B VGND VGND VPWR VPWR _1576_/B sky130_fd_sc_hd__xor2_2
X_1644_ _1644_/A _1665_/B VGND VGND VPWR VPWR _1645_/B sky130_fd_sc_hd__xnor2_2
X_2693_ _2703_/CLK _2693_/D VGND VGND VPWR VPWR _2693_/Q sky130_fd_sc_hd__dfxtp_2
XFILLER_26_137 VGND VGND VPWR VPWR sky130_fd_sc_hd__decap_3
X_2127_ _2561_/B _1426_/X _1430_/Y _2265_/B2 VGND VGND VPWR VPWR _2128_/B sky130_fd_sc_hd__a22o_2
XFILLER_34_170 VGND VGND VPWR VPWR sky130_fd_sc_hd__decap_3
XTAP_TAPCELL_ROW_64_496 VGND VPWR sky130_fd_sc_hd__tapvpwrvgnd_1
X_2058_ _2553_/B _2096_/A2 _1538_/X _2551_/B VGND VGND VPWR VPWR _2059_/B sky130_fd_sc_hd__a22o_2
XFILLER_41_15 VGND VGND VPWR VPWR sky130_fd_sc_hd__decap_3
XFILLER_41_26 VGND VGND VPWR VPWR sky130_fd_sc_hd__decap_3
Xhold550 hold550/A VGND VGND VPWR VPWR _1339_/B sky130_fd_sc_hd__clkbuf_2
Xhold561 _2604_/C VGND VGND VPWR VPWR _1367_/A sky130_fd_sc_hd__clkbuf_2
Xhold572 hold572/A VGND VGND VPWR VPWR hold572/X sky130_fd_sc_hd__clkbuf_2
Xhold583 _2606_/C VGND VGND VPWR VPWR _1352_/A sky130_fd_sc_hd__clkbuf_2
Xhold594 _1374_/Y VGND VGND VPWR VPWR _2670_/D sky130_fd_sc_hd__clkbuf_2
XFILLER_32_118 VGND VGND VPWR VPWR sky130_fd_sc_hd__fill_1
XFILLER_57_240 VGND VGND VPWR VPWR sky130_fd_sc_hd__decap_3
XTAP_TAPCELL_ROW_55_441 VGND VPWR sky130_fd_sc_hd__tapvpwrvgnd_1
X_1360_ _2665_/Q _2610_/A hold547/X _2572_/C1 VGND VGND VPWR VPWR _1360_/X sky130_fd_sc_hd__o211a_2
XFILLER_0_291 VGND VGND VPWR VPWR sky130_fd_sc_hd__decap_3
XFILLER_48_262 VGND VGND VPWR VPWR sky130_fd_sc_hd__decap_3
XFILLER_48_284 VGND VGND VPWR VPWR sky130_fd_sc_hd__decap_3
XFILLER_63_210 VGND VGND VPWR VPWR sky130_fd_sc_hd__fill_1
XFILLER_16_181 VGND VGND VPWR VPWR sky130_fd_sc_hd__decap_3
XFILLER_63_243 VGND VGND VPWR VPWR sky130_fd_sc_hd__decap_3
Xplace210 _2095_/A2 VGND VGND VPWR VPWR _2290_/A2 sky130_fd_sc_hd__buf_1
Xplace298 _2550_/B1 VGND VGND VPWR VPWR _2580_/B1 sky130_fd_sc_hd__buf_1
Xplace287 _2623_/Q VGND VGND VPWR VPWR _1728_/A2 sky130_fd_sc_hd__buf_1
Xplace276 _2628_/Q VGND VGND VPWR VPWR _1646_/A2 sky130_fd_sc_hd__buf_1
Xplace265 _2633_/Q VGND VGND VPWR VPWR _2557_/B sky130_fd_sc_hd__buf_1
Xplace254 _2658_/Q VGND VGND VPWR VPWR _2618_/A sky130_fd_sc_hd__buf_1
Xplace243 _2664_/Q VGND VGND VPWR VPWR _2196_/B sky130_fd_sc_hd__buf_1
Xplace232 _1386_/X VGND VGND VPWR VPWR _1697_/B sky130_fd_sc_hd__buf_1
Xplace221 _2274_/A VGND VGND VPWR VPWR _2087_/A sky130_fd_sc_hd__clkbuf_1
XFILLER_31_162 VGND VGND VPWR VPWR sky130_fd_sc_hd__decap_3
XFILLER_31_184 VGND VGND VPWR VPWR sky130_fd_sc_hd__fill_1
X_2676_ _2703_/CLK _2676_/D VGND VGND VPWR VPWR _2676_/Q sky130_fd_sc_hd__dfxtp_2
X_1489_ _1606_/A1 _1670_/B _1411_/X _1700_/A2 VGND VGND VPWR VPWR _1490_/B sky130_fd_sc_hd__a22o_2
X_1558_ _1747_/A _1558_/B VGND VGND VPWR VPWR _1584_/A sky130_fd_sc_hd__xor2_2
XFILLER_39_251 VGND VGND VPWR VPWR sky130_fd_sc_hd__decap_3
XFILLER_39_273 VGND VGND VPWR VPWR sky130_fd_sc_hd__decap_3
XFILLER_22_162 VGND VGND VPWR VPWR sky130_fd_sc_hd__decap_3
XFILLER_22_184 VGND VGND VPWR VPWR sky130_fd_sc_hd__decap_3
XFILLER_22_195 VGND VGND VPWR VPWR sky130_fd_sc_hd__fill_1
XFILLER_52_47 VGND VGND VPWR VPWR sky130_fd_sc_hd__decap_3
XFILLER_6_317 VGND VGND VPWR VPWR sky130_fd_sc_hd__decap_3
XTAP_TAPCELL_ROW_52_422 VGND VPWR sky130_fd_sc_hd__tapvpwrvgnd_1
XTAP_TAPCELL_ROW_9_188 VGND VPWR sky130_fd_sc_hd__tapvpwrvgnd_1
XFILLER_13_151 VGND VGND VPWR VPWR sky130_fd_sc_hd__fill_2
XFILLER_60_268 VGND VGND VPWR VPWR sky130_fd_sc_hd__decap_3
XFILLER_13_195 VGND VGND VPWR VPWR sky130_fd_sc_hd__decap_3
X_1412_ _1524_/A1 _1916_/B1 _1411_/X _1606_/A1 VGND VGND VPWR VPWR _1413_/B sky130_fd_sc_hd__a22o_2
X_2461_ _2459_/Y _2460_/X _2492_/A VGND VGND VPWR VPWR _2461_/X sky130_fd_sc_hd__a21o_2
X_2392_ _2460_/A _2460_/B _2427_/A _2385_/A VGND VGND VPWR VPWR _2472_/C sky130_fd_sc_hd__a211o_2
XFILLER_36_287 VGND VGND VPWR VPWR sky130_fd_sc_hd__fill_1
X_2659_ clkload2/A _2659_/D VGND VGND VPWR VPWR _2659_/Q sky130_fd_sc_hd__dfxtp_2
XFILLER_47_69 VGND VGND VPWR VPWR sky130_fd_sc_hd__decap_3
XTAP_TAPCELL_ROW_6_169 VGND VPWR sky130_fd_sc_hd__tapvpwrvgnd_1
XFILLER_27_254 VGND VGND VPWR VPWR sky130_fd_sc_hd__fill_1
XFILLER_63_46 VGND VGND VPWR VPWR sky130_fd_sc_hd__fill_1
XFILLER_63_57 VGND VGND VPWR VPWR sky130_fd_sc_hd__decap_3
XFILLER_18_298 VGND VGND VPWR VPWR sky130_fd_sc_hd__fill_1
XFILLER_41_290 VGND VGND VPWR VPWR sky130_fd_sc_hd__fill_2
XTAP_TAPCELL_ROW_28_293 VGND VPWR sky130_fd_sc_hd__tapvpwrvgnd_1
X_1961_ _2629_/Q _1474_/B _2009_/B1 _2057_/B2 VGND VGND VPWR VPWR _1962_/B sky130_fd_sc_hd__a22o_2
X_1892_ _1904_/B _1892_/B VGND VGND VPWR VPWR _1893_/B sky130_fd_sc_hd__xnor2_2
X_2513_ _2410_/Y _2512_/X _2523_/B VGND VGND VPWR VPWR _2513_/Y sky130_fd_sc_hd__o21bai_2
X_1326_ _2697_/Q _1325_/B _2708_/A VGND VGND VPWR VPWR _1327_/B sky130_fd_sc_hd__o21a_2
X_2444_ _2452_/A _2424_/B _2492_/A _1948_/A _2687_/Q VGND VGND VPWR VPWR _2444_/X
+ sky130_fd_sc_hd__o311a_2
X_2375_ _2673_/Q _2382_/B _2368_/A VGND VGND VPWR VPWR _2379_/B sky130_fd_sc_hd__o21a_2
XFILLER_24_279 VGND VGND VPWR VPWR sky130_fd_sc_hd__decap_3
XFILLER_33_38 VGND VGND VPWR VPWR sky130_fd_sc_hd__decap_3
XFILLER_59_154 VGND VGND VPWR VPWR sky130_fd_sc_hd__decap_3
XTAP_TAPCELL_ROW_2_150 VGND VPWR sky130_fd_sc_hd__tapvpwrvgnd_1
XFILLER_15_235 VGND VGND VPWR VPWR sky130_fd_sc_hd__fill_2
XFILLER_30_227 VGND VGND VPWR VPWR sky130_fd_sc_hd__fill_2
XFILLER_30_249 VGND VGND VPWR VPWR sky130_fd_sc_hd__decap_3
XTAP_TAPCELL_ROW_25_274 VGND VPWR sky130_fd_sc_hd__tapvpwrvgnd_1
X_2160_ _2259_/A _2680_/Q VGND VGND VPWR VPWR _2160_/Y sky130_fd_sc_hd__nand2_2
XTAP_TAPCELL_ROW_48_399 VGND VPWR sky130_fd_sc_hd__tapvpwrvgnd_1
X_2091_ _2091_/A _2091_/B VGND VGND VPWR VPWR _2101_/A sky130_fd_sc_hd__nand2_2
X_1944_ _1953_/A _1944_/B VGND VGND VPWR VPWR _2071_/B sky130_fd_sc_hd__and2_2
X_1875_ _2015_/B _1974_/B VGND VGND VPWR VPWR _1928_/A sky130_fd_sc_hd__nand2_2
X_2427_ _2427_/A _2427_/B VGND VGND VPWR VPWR _2467_/B sky130_fd_sc_hd__nor2_2
XFILLER_56_113 VGND VGND VPWR VPWR sky130_fd_sc_hd__decap_3
XFILLER_56_157 VGND VGND VPWR VPWR sky130_fd_sc_hd__decap_3
X_1309_ _2689_/Q _2707_/A _1314_/A VGND VGND VPWR VPWR _1310_/B sky130_fd_sc_hd__o21ai_2
Xclkbuf_4_15_0_clk clkbuf_0_clk/X VGND VGND VPWR VPWR _2692_/CLK sky130_fd_sc_hd__clkbuf_8
X_2358_ _2680_/Q _2358_/B VGND VGND VPWR VPWR _2400_/B sky130_fd_sc_hd__xnor2_2
X_2289_ _2289_/A _2289_/B VGND VGND VPWR VPWR _2289_/X sky130_fd_sc_hd__and2_2
XFILLER_12_249 VGND VGND VPWR VPWR sky130_fd_sc_hd__decap_3
XFILLER_20_271 VGND VGND VPWR VPWR sky130_fd_sc_hd__decap_3
XFILLER_60_36 VGND VGND VPWR VPWR sky130_fd_sc_hd__decap_3
XFILLER_47_113 VGND VGND VPWR VPWR sky130_fd_sc_hd__decap_3
XFILLER_47_146 VGND VGND VPWR VPWR sky130_fd_sc_hd__decap_3
XTAP_TAPCELL_ROW_13_211 VGND VPWR sky130_fd_sc_hd__tapvpwrvgnd_1
XFILLER_7_253 VGND VGND VPWR VPWR sky130_fd_sc_hd__decap_3
X_1591_ _1506_/Y _1546_/X _1790_/A _1590_/Y VGND VGND VPWR VPWR _1591_/X sky130_fd_sc_hd__o211a_2
X_1660_ _1685_/A _1685_/B VGND VGND VPWR VPWR _1689_/C sky130_fd_sc_hd__nand2_2
XFILLER_38_168 VGND VGND VPWR VPWR sky130_fd_sc_hd__decap_3
X_2212_ _2168_/A _2212_/B VGND VGND VPWR VPWR _2212_/X sky130_fd_sc_hd__and2b_2
X_2143_ _2092_/A _2092_/B _2100_/B _2099_/B _2099_/A VGND VGND VPWR VPWR _2144_/B
+ sky130_fd_sc_hd__a32o_2
XFILLER_14_29 VGND VGND VPWR VPWR sky130_fd_sc_hd__fill_2
XFILLER_53_116 VGND VGND VPWR VPWR sky130_fd_sc_hd__decap_3
XFILLER_53_127 VGND VGND VPWR VPWR sky130_fd_sc_hd__decap_3
XFILLER_61_182 VGND VGND VPWR VPWR sky130_fd_sc_hd__decap_3
XTAP_TAPCELL_ROW_36_336 VGND VPWR sky130_fd_sc_hd__tapvpwrvgnd_1
XTAP_TAPCELL_ROW_44_380 VGND VPWR sky130_fd_sc_hd__tapvpwrvgnd_1
X_2074_ _2035_/A _2035_/B _2073_/X VGND VGND VPWR VPWR _2074_/Y sky130_fd_sc_hd__a21oi_2
X_1927_ _2015_/A _1927_/B VGND VGND VPWR VPWR _1928_/B sky130_fd_sc_hd__xor2_2
X_1858_ _1858_/A _1858_/B VGND VGND VPWR VPWR _1859_/B sky130_fd_sc_hd__or2_2
XFILLER_39_37 VGND VGND VPWR VPWR sky130_fd_sc_hd__decap_3
X_1789_ _1800_/A _1789_/B VGND VGND VPWR VPWR _1790_/B sky130_fd_sc_hd__xnor2_2
XFILLER_29_113 VGND VGND VPWR VPWR sky130_fd_sc_hd__decap_3
XFILLER_44_116 VGND VGND VPWR VPWR sky130_fd_sc_hd__decap_3
XFILLER_52_182 VGND VGND VPWR VPWR sky130_fd_sc_hd__decap_3
XFILLER_4_256 VGND VGND VPWR VPWR sky130_fd_sc_hd__decap_3
Xinput330 hold559/X VGND VGND VPWR VPWR hold560/A sky130_fd_sc_hd__buf_2
Xinput341 hold605/X VGND VGND VPWR VPWR hold600/A sky130_fd_sc_hd__buf_2
XTAP_TAPCELL_ROW_33_317 VGND VPWR sky130_fd_sc_hd__tapvpwrvgnd_1
XANTENNA_1 b_in[6] VGND VGND VPWR VPWR sky130_fd_sc_hd__diode_2
XFILLER_61_90 VGND VGND VPWR VPWR sky130_fd_sc_hd__decap_3
XTAP_TAPCELL_ROW_41_361 VGND VPWR sky130_fd_sc_hd__tapvpwrvgnd_1
X_1643_ _1643_/A _1643_/B VGND VGND VPWR VPWR _1665_/B sky130_fd_sc_hd__xnor2_2
X_2692_ _2692_/CLK _2692_/D VGND VGND VPWR VPWR _2692_/Q sky130_fd_sc_hd__dfxtp_2
X_1712_ _1712_/A _1712_/B VGND VGND VPWR VPWR _1712_/Y sky130_fd_sc_hd__nor2_2
X_1574_ _2022_/A1 _1926_/B1 _1390_/X _2631_/Q VGND VGND VPWR VPWR _1575_/B sky130_fd_sc_hd__a22o_2
XFILLER_25_17 VGND VGND VPWR VPWR sky130_fd_sc_hd__fill_1
XFILLER_26_116 VGND VGND VPWR VPWR sky130_fd_sc_hd__decap_3
XFILLER_26_149 VGND VGND VPWR VPWR sky130_fd_sc_hd__decap_3
X_2126_ _2126_/A _2126_/B VGND VGND VPWR VPWR _2129_/A sky130_fd_sc_hd__nor2_2
X_2057_ _2629_/Q _2095_/A2 _2095_/B1 _2057_/B2 VGND VGND VPWR VPWR _2092_/A sky130_fd_sc_hd__a22o_2
XFILLER_41_119 VGND VGND VPWR VPWR sky130_fd_sc_hd__decap_3
XFILLER_41_38 VGND VGND VPWR VPWR sky130_fd_sc_hd__decap_3
XTAP_TAPCELL_ROW_64_497 VGND VPWR sky130_fd_sc_hd__tapvpwrvgnd_1
XFILLER_1_204 VGND VGND VPWR VPWR sky130_fd_sc_hd__fill_1
Xhold540 _2608_/B VGND VGND VPWR VPWR _2610_/B sky130_fd_sc_hd__clkbuf_2
Xhold551 _1339_/Y VGND VGND VPWR VPWR _1352_/B sky130_fd_sc_hd__clkbuf_2
Xhold562 b_in[9] VGND VGND VPWR VPWR hold562/X sky130_fd_sc_hd__clkbuf_2
XFILLER_49_219 VGND VGND VPWR VPWR sky130_fd_sc_hd__decap_3
Xhold573 _2606_/B VGND VGND VPWR VPWR _1340_/A sky130_fd_sc_hd__clkbuf_2
Xhold584 _1352_/X VGND VGND VPWR VPWR hold584/X sky130_fd_sc_hd__clkbuf_2
Xhold595 hold606/X VGND VGND VPWR VPWR hold607/A sky130_fd_sc_hd__clkbuf_2
XFILLER_57_274 VGND VGND VPWR VPWR sky130_fd_sc_hd__decap_3
XFILLER_57_296 VGND VGND VPWR VPWR sky130_fd_sc_hd__fill_1
XTAP_TAPCELL_ROW_55_442 VGND VPWR sky130_fd_sc_hd__tapvpwrvgnd_1
XFILLER_31_60 VGND VGND VPWR VPWR sky130_fd_sc_hd__decap_3
XFILLER_0_281 VGND VGND VPWR VPWR sky130_fd_sc_hd__fill_1
XFILLER_48_241 VGND VGND VPWR VPWR sky130_fd_sc_hd__decap_3
XFILLER_63_255 VGND VGND VPWR VPWR sky130_fd_sc_hd__decap_3
Xplace200 _2523_/B VGND VGND VPWR VPWR _2492_/A sky130_fd_sc_hd__buf_1
Xplace211 _2313_/B VGND VGND VPWR VPWR _2095_/B1 sky130_fd_sc_hd__buf_1
XFILLER_16_160 VGND VGND VPWR VPWR sky130_fd_sc_hd__decap_3
XFILLER_16_193 VGND VGND VPWR VPWR sky130_fd_sc_hd__decap_3
Xplace299 _2611_/C1 VGND VGND VPWR VPWR _2572_/C1 sky130_fd_sc_hd__buf_1
Xplace288 _2622_/Q VGND VGND VPWR VPWR _1697_/A sky130_fd_sc_hd__buf_1
Xplace277 _2008_/B2 VGND VGND VPWR VPWR _1524_/A1 sky130_fd_sc_hd__buf_1
Xplace266 _2633_/Q VGND VGND VPWR VPWR _1916_/A1 sky130_fd_sc_hd__buf_1
Xplace255 _2656_/Q VGND VGND VPWR VPWR _1768_/A sky130_fd_sc_hd__buf_1
Xplace244 _1816_/A VGND VGND VPWR VPWR _1523_/A sky130_fd_sc_hd__clkbuf_1
Xplace233 _1872_/A VGND VGND VPWR VPWR _1709_/B sky130_fd_sc_hd__buf_1
Xplace222 _2125_/C VGND VGND VPWR VPWR _2019_/A3 sky130_fd_sc_hd__buf_1
XFILLER_31_196 VGND VGND VPWR VPWR sky130_fd_sc_hd__fill_2
X_1626_ _1639_/B _2664_/Q _1639_/A VGND VGND VPWR VPWR _1645_/A sky130_fd_sc_hd__mux2_2
X_2675_ _2692_/CLK _2675_/D VGND VGND VPWR VPWR _2675_/Q sky130_fd_sc_hd__dfxtp_2
X_1488_ _1497_/A _1497_/B VGND VGND VPWR VPWR _1616_/A sky130_fd_sc_hd__xor2_2
X_1557_ _1804_/A _1747_/C VGND VGND VPWR VPWR _1558_/B sky130_fd_sc_hd__nand2_2
XFILLER_39_263 VGND VGND VPWR VPWR sky130_fd_sc_hd__decap_3
XFILLER_52_15 VGND VGND VPWR VPWR sky130_fd_sc_hd__decap_3
XFILLER_54_200 VGND VGND VPWR VPWR sky130_fd_sc_hd__fill_2
XFILLER_54_288 VGND VGND VPWR VPWR sky130_fd_sc_hd__fill_1
XTAP_TAPCELL_ROW_52_423 VGND VPWR sky130_fd_sc_hd__tapvpwrvgnd_1
X_2109_ _2110_/A _2110_/B VGND VGND VPWR VPWR _2150_/A sky130_fd_sc_hd__nor2_2
XFILLER_22_130 VGND VGND VPWR VPWR sky130_fd_sc_hd__decap_3
XFILLER_22_141 VGND VGND VPWR VPWR sky130_fd_sc_hd__fill_1
XFILLER_52_59 VGND VGND VPWR VPWR sky130_fd_sc_hd__decap_3
XTAP_TAPCELL_ROW_9_189 VGND VPWR sky130_fd_sc_hd__tapvpwrvgnd_1
XFILLER_45_222 VGND VGND VPWR VPWR sky130_fd_sc_hd__fill_2
XFILLER_13_174 VGND VGND VPWR VPWR sky130_fd_sc_hd__decap_3
XFILLER_26_93 VGND VGND VPWR VPWR sky130_fd_sc_hd__decap_3
XFILLER_60_225 VGND VGND VPWR VPWR sky130_fd_sc_hd__fill_1
XFILLER_42_70 VGND VGND VPWR VPWR sky130_fd_sc_hd__fill_1
XFILLER_61_7 VGND VGND VPWR VPWR sky130_fd_sc_hd__fill_1
XFILLER_9_189 VGND VGND VPWR VPWR sky130_fd_sc_hd__fill_1
X_2460_ _2460_/A _2460_/B VGND VGND VPWR VPWR _2460_/X sky130_fd_sc_hd__or2_2
X_1411_ _1411_/A _1411_/B VGND VGND VPWR VPWR _1411_/X sky130_fd_sc_hd__and2_2
X_2391_ _2691_/Q _2391_/B VGND VGND VPWR VPWR _2427_/A sky130_fd_sc_hd__and2_2
XFILLER_36_244 VGND VGND VPWR VPWR sky130_fd_sc_hd__decap_3
XFILLER_51_225 VGND VGND VPWR VPWR sky130_fd_sc_hd__decap_3
X_1609_ _1637_/A _1637_/B _1608_/X VGND VGND VPWR VPWR _1642_/A sky130_fd_sc_hd__a21oi_2
X_2658_ clkload8/A _2658_/D VGND VGND VPWR VPWR _2658_/Q sky130_fd_sc_hd__dfxtp_2
X_2589_ _2608_/A _2646_/Q VGND VGND VPWR VPWR _2589_/X sky130_fd_sc_hd__or2_2
XFILLER_47_26 VGND VGND VPWR VPWR sky130_fd_sc_hd__decap_3
XFILLER_27_277 VGND VGND VPWR VPWR sky130_fd_sc_hd__decap_3
XFILLER_42_203 VGND VGND VPWR VPWR sky130_fd_sc_hd__decap_3
XFILLER_42_247 VGND VGND VPWR VPWR sky130_fd_sc_hd__decap_3
XFILLER_42_269 VGND VGND VPWR VPWR sky130_fd_sc_hd__fill_1
XFILLER_10_188 VGND VGND VPWR VPWR sky130_fd_sc_hd__decap_3
XFILLER_18_200 VGND VGND VPWR VPWR sky130_fd_sc_hd__decap_3
XFILLER_33_236 VGND VGND VPWR VPWR sky130_fd_sc_hd__decap_3
XTAP_TAPCELL_ROW_28_294 VGND VPWR sky130_fd_sc_hd__tapvpwrvgnd_1
X_1960_ _2008_/B2 _1555_/B _2095_/B1 _1960_/B2 VGND VGND VPWR VPWR _2005_/A sky130_fd_sc_hd__a22o_2
X_1891_ _1837_/A _1837_/B _1890_/X VGND VGND VPWR VPWR _1892_/B sky130_fd_sc_hd__o21a_2
X_2512_ _2512_/A _2512_/B _2512_/C VGND VGND VPWR VPWR _2512_/X sky130_fd_sc_hd__and3_2
X_1325_ _2697_/Q _1325_/B VGND VGND VPWR VPWR _1325_/X sky130_fd_sc_hd__xor2_2
X_2374_ _2675_/Q VGND VGND VPWR VPWR _2377_/A sky130_fd_sc_hd__inv_2
XFILLER_24_214 VGND VGND VPWR VPWR sky130_fd_sc_hd__decap_3
XFILLER_24_236 VGND VGND VPWR VPWR sky130_fd_sc_hd__decap_3
XFILLER_24_258 VGND VGND VPWR VPWR sky130_fd_sc_hd__decap_3
XFILLER_32_280 VGND VGND VPWR VPWR sky130_fd_sc_hd__decap_3
XFILLER_58_25 VGND VGND VPWR VPWR sky130_fd_sc_hd__decap_3
XFILLER_59_122 VGND VGND VPWR VPWR sky130_fd_sc_hd__fill_1
XFILLER_15_225 VGND VGND VPWR VPWR sky130_fd_sc_hd__fill_2
XFILLER_59_166 VGND VGND VPWR VPWR sky130_fd_sc_hd__fill_2
XFILLER_62_309 VGND VGND VPWR VPWR sky130_fd_sc_hd__decap_3
XTAP_TAPCELL_ROW_2_151 VGND VPWR sky130_fd_sc_hd__tapvpwrvgnd_1
XFILLER_15_269 VGND VGND VPWR VPWR sky130_fd_sc_hd__decap_3
XFILLER_30_206 VGND VGND VPWR VPWR sky130_fd_sc_hd__decap_3
XTAP_TAPCELL_ROW_25_275 VGND VPWR sky130_fd_sc_hd__tapvpwrvgnd_1
XFILLER_38_317 VGND VGND VPWR VPWR sky130_fd_sc_hd__decap_3
XFILLER_48_91 VGND VGND VPWR VPWR sky130_fd_sc_hd__fill_2
X_2090_ _2176_/A _2102_/A VGND VGND VPWR VPWR _2091_/B sky130_fd_sc_hd__nand2b_2
XFILLER_0_43 VGND VGND VPWR VPWR sky130_fd_sc_hd__fill_1
XFILLER_21_228 VGND VGND VPWR VPWR sky130_fd_sc_hd__decap_3
X_1943_ _1943_/A _1947_/C VGND VGND VPWR VPWR _1944_/B sky130_fd_sc_hd__or2_2
X_1874_ _2618_/A _2656_/Q VGND VGND VPWR VPWR _1974_/B sky130_fd_sc_hd__nand2_2
X_2426_ _2426_/A _2426_/B VGND VGND VPWR VPWR _2452_/B sky130_fd_sc_hd__nor2_2
XFILLER_28_17 VGND VGND VPWR VPWR sky130_fd_sc_hd__fill_1
XFILLER_29_317 VGND VGND VPWR VPWR sky130_fd_sc_hd__decap_3
XFILLER_44_309 VGND VGND VPWR VPWR sky130_fd_sc_hd__decap_3
XFILLER_56_169 VGND VGND VPWR VPWR sky130_fd_sc_hd__decap_3
X_1308_ _2689_/Q _1308_/B VGND VGND VPWR VPWR _1308_/Y sky130_fd_sc_hd__xnor2_2
X_2357_ _2679_/Q _2360_/B _2368_/A VGND VGND VPWR VPWR _2358_/B sky130_fd_sc_hd__o21a_2
X_2288_ _2308_/A _2684_/Q VGND VGND VPWR VPWR _2288_/X sky130_fd_sc_hd__and2_2
XFILLER_12_228 VGND VGND VPWR VPWR sky130_fd_sc_hd__fill_2
XFILLER_44_38 VGND VGND VPWR VPWR sky130_fd_sc_hd__decap_3
XFILLER_64_191 VGND VGND VPWR VPWR sky130_fd_sc_hd__decap_3
XTAP_TAPCELL_ROW_22_256 VGND VPWR sky130_fd_sc_hd__tapvpwrvgnd_1
XFILLER_60_48 VGND VGND VPWR VPWR sky130_fd_sc_hd__decap_3
XFILLER_47_103 VGND VGND VPWR VPWR sky130_fd_sc_hd__decap_3
XFILLER_18_61 VGND VGND VPWR VPWR sky130_fd_sc_hd__fill_2
XFILLER_47_158 VGND VGND VPWR VPWR sky130_fd_sc_hd__decap_3
XFILLER_62_106 VGND VGND VPWR VPWR sky130_fd_sc_hd__fill_1
XFILLER_7_221 VGND VGND VPWR VPWR sky130_fd_sc_hd__decap_3
XFILLER_7_265 VGND VGND VPWR VPWR sky130_fd_sc_hd__decap_3
XFILLER_50_81 VGND VGND VPWR VPWR sky130_fd_sc_hd__decap_3
XFILLER_7_298 VGND VGND VPWR VPWR sky130_fd_sc_hd__decap_3
X_1590_ _1798_/A _1798_/B VGND VGND VPWR VPWR _1590_/Y sky130_fd_sc_hd__nand2_2
XFILLER_26_309 VGND VGND VPWR VPWR sky130_fd_sc_hd__fill_1
X_2211_ _2211_/A _2249_/A VGND VGND VPWR VPWR _2232_/B sky130_fd_sc_hd__nor2_2
X_2142_ _2182_/A _2182_/B VGND VGND VPWR VPWR _2144_/A sky130_fd_sc_hd__xor2_2
X_2073_ _2035_/A _2035_/B _1998_/B _1998_/A VGND VGND VPWR VPWR _2073_/X sky130_fd_sc_hd__o211a_2
XFILLER_46_180 VGND VGND VPWR VPWR sky130_fd_sc_hd__decap_3
XFILLER_61_150 VGND VGND VPWR VPWR sky130_fd_sc_hd__decap_3
XPHY_EDGE_ROW_28_Left_93 VGND VGND VPWR VPWR sky130_fd_sc_hd__decap_3
XTAP_TAPCELL_ROW_36_337 VGND VPWR sky130_fd_sc_hd__tapvpwrvgnd_1
XTAP_TAPCELL_ROW_44_381 VGND VPWR sky130_fd_sc_hd__tapvpwrvgnd_1
XPHY_EDGE_ROW_12_Left_77 VGND VGND VPWR VPWR sky130_fd_sc_hd__decap_3
X_1926_ _1926_/A1 _1390_/A _1390_/B _1926_/B1 _1976_/D VGND VGND VPWR VPWR _1927_/B
+ sky130_fd_sc_hd__a32o_2
X_1857_ _1858_/A _1858_/B VGND VGND VPWR VPWR _1915_/A sky130_fd_sc_hd__nand2_2
X_1788_ _1802_/A _1803_/B VGND VGND VPWR VPWR _1789_/B sky130_fd_sc_hd__xnor2_2
XFILLER_29_103 VGND VGND VPWR VPWR sky130_fd_sc_hd__decap_3
XFILLER_29_125 VGND VGND VPWR VPWR sky130_fd_sc_hd__decap_3
XFILLER_29_136 VGND VGND VPWR VPWR sky130_fd_sc_hd__decap_3
X_2409_ _2700_/Q _2409_/B VGND VGND VPWR VPWR _2512_/A sky130_fd_sc_hd__xnor2_2
XFILLER_52_161 VGND VGND VPWR VPWR sky130_fd_sc_hd__decap_3
XFILLER_40_312 VGND VGND VPWR VPWR sky130_fd_sc_hd__decap_3
XFILLER_52_194 VGND VGND VPWR VPWR sky130_fd_sc_hd__fill_2
XFILLER_4_224 VGND VGND VPWR VPWR sky130_fd_sc_hd__decap_3
XFILLER_29_60 VGND VGND VPWR VPWR sky130_fd_sc_hd__decap_3
XFILLER_29_71 VGND VGND VPWR VPWR sky130_fd_sc_hd__fill_2
Xinput320 hold625/X VGND VGND VPWR VPWR hold626/A sky130_fd_sc_hd__buf_2
Xinput331 hold537/X VGND VGND VPWR VPWR hold538/A sky130_fd_sc_hd__buf_2
Xinput342 hold678/X VGND VGND VPWR VPWR hold592/A sky130_fd_sc_hd__buf_2
XFILLER_43_172 VGND VGND VPWR VPWR sky130_fd_sc_hd__decap_3
XFILLER_43_183 VGND VGND VPWR VPWR sky130_fd_sc_hd__decap_3
XTAP_TAPCELL_ROW_33_318 VGND VPWR sky130_fd_sc_hd__tapvpwrvgnd_1
XANTENNA_2 b_in[8] VGND VGND VPWR VPWR sky130_fd_sc_hd__diode_2
XTAP_TAPCELL_ROW_41_362 VGND VPWR sky130_fd_sc_hd__tapvpwrvgnd_1
X_1642_ _1642_/A _1642_/B VGND VGND VPWR VPWR _1643_/A sky130_fd_sc_hd__xnor2_2
Xclkbuf_4_14_0_clk clkbuf_0_clk/X VGND VGND VPWR VPWR _2689_/CLK sky130_fd_sc_hd__clkbuf_8
X_2691_ _2692_/CLK _2691_/D VGND VGND VPWR VPWR _2691_/Q sky130_fd_sc_hd__dfxtp_2
X_1711_ _1768_/A _1711_/B VGND VGND VPWR VPWR _1712_/B sky130_fd_sc_hd__xnor2_2
X_1573_ _1777_/A _1777_/B VGND VGND VPWR VPWR _1576_/A sky130_fd_sc_hd__xor2_2
XFILLER_26_128 VGND VGND VPWR VPWR sky130_fd_sc_hd__decap_3
XFILLER_41_109 VGND VGND VPWR VPWR sky130_fd_sc_hd__decap_3
X_2125_ _2124_/X _2132_/A _2125_/C _2125_/D VGND VGND VPWR VPWR _2126_/B sky130_fd_sc_hd__and4b_2
X_2056_ _2024_/A _2024_/B _2055_/X VGND VGND VPWR VPWR _2061_/A sky130_fd_sc_hd__a21o_2
XFILLER_34_194 VGND VGND VPWR VPWR sky130_fd_sc_hd__fill_2
XTAP_TAPCELL_ROW_64_487 VGND VPWR sky130_fd_sc_hd__tapvpwrvgnd_1
X_1909_ _2057_/B2 _2096_/A2 _2009_/B1 _2008_/B2 VGND VGND VPWR VPWR _1910_/B sky130_fd_sc_hd__a22o_2
Xhold530 b_in[13] VGND VGND VPWR VPWR hold530/X sky130_fd_sc_hd__clkbuf_2
Xhold541 _2610_/Y VGND VGND VPWR VPWR hold541/X sky130_fd_sc_hd__clkbuf_2
Xhold552 _1346_/X VGND VGND VPWR VPWR hold552/X sky130_fd_sc_hd__clkbuf_2
Xhold563 hold563/A VGND VGND VPWR VPWR hold563/X sky130_fd_sc_hd__clkbuf_2
Xhold574 _1344_/X VGND VGND VPWR VPWR _2659_/D sky130_fd_sc_hd__clkbuf_2
Xhold585 _1354_/X VGND VGND VPWR VPWR _2662_/D sky130_fd_sc_hd__clkbuf_2
Xhold596 hold596/A VGND VGND VPWR VPWR hold596/X sky130_fd_sc_hd__clkbuf_2
XFILLER_57_231 VGND VGND VPWR VPWR sky130_fd_sc_hd__decap_3
XFILLER_17_139 VGND VGND VPWR VPWR sky130_fd_sc_hd__decap_3
XFILLER_25_172 VGND VGND VPWR VPWR sky130_fd_sc_hd__fill_2
XFILLER_32_109 VGND VGND VPWR VPWR sky130_fd_sc_hd__decap_3
XFILLER_31_94 VGND VGND VPWR VPWR sky130_fd_sc_hd__fill_2
XFILLER_0_271 VGND VGND VPWR VPWR sky130_fd_sc_hd__decap_3
XFILLER_16_150 VGND VGND VPWR VPWR sky130_fd_sc_hd__fill_2
XFILLER_23_109 VGND VGND VPWR VPWR sky130_fd_sc_hd__decap_3
XFILLER_48_253 VGND VGND VPWR VPWR sky130_fd_sc_hd__fill_1
XFILLER_63_234 VGND VGND VPWR VPWR sky130_fd_sc_hd__decap_3
XFILLER_63_267 VGND VGND VPWR VPWR sky130_fd_sc_hd__decap_3
Xplace201 _2442_/Y VGND VGND VPWR VPWR _2523_/B sky130_fd_sc_hd__buf_1
Xplace212 _2330_/Y VGND VGND VPWR VPWR _2524_/A2 sky130_fd_sc_hd__buf_1
Xplace245 _2018_/A VGND VGND VPWR VPWR _1816_/A sky130_fd_sc_hd__buf_1
Xplace234 _1872_/A VGND VGND VPWR VPWR _1702_/B1 sky130_fd_sc_hd__buf_1
Xplace223 _1420_/A VGND VGND VPWR VPWR _2019_/A2 sky130_fd_sc_hd__buf_1
Xplace289 _2622_/Q VGND VGND VPWR VPWR _1555_/A sky130_fd_sc_hd__buf_1
Xplace278 _2627_/Q VGND VGND VPWR VPWR _2008_/B2 sky130_fd_sc_hd__buf_1
Xplace267 _2022_/A1 VGND VGND VPWR VPWR _2555_/B sky130_fd_sc_hd__buf_1
Xplace256 _2655_/Q VGND VGND VPWR VPWR _1727_/A sky130_fd_sc_hd__buf_1
X_1556_ _1555_/A _1555_/B _1555_/C VGND VGND VPWR VPWR _1747_/C sky130_fd_sc_hd__a21o_2
X_1625_ _1697_/A _1625_/B VGND VGND VPWR VPWR _1639_/A sky130_fd_sc_hd__nand2_2
X_2674_ _2692_/CLK _2674_/D VGND VGND VPWR VPWR _2674_/Q sky130_fd_sc_hd__dfxtp_2
XFILLER_39_220 VGND VGND VPWR VPWR sky130_fd_sc_hd__decap_3
X_1487_ _1487_/A _1487_/B VGND VGND VPWR VPWR _1497_/B sky130_fd_sc_hd__xnor2_2
XFILLER_36_39 VGND VGND VPWR VPWR sky130_fd_sc_hd__fill_2
XFILLER_52_27 VGND VGND VPWR VPWR sky130_fd_sc_hd__fill_1
XTAP_TAPCELL_ROW_52_424 VGND VPWR sky130_fd_sc_hd__tapvpwrvgnd_1
X_2108_ _2067_/A _2067_/B _2107_/Y VGND VGND VPWR VPWR _2110_/B sky130_fd_sc_hd__a21oi_2
X_2039_ _2230_/A _2039_/B VGND VGND VPWR VPWR _2676_/D sky130_fd_sc_hd__nor2_2
XPHY_EDGE_ROW_15_Left_80 VGND VGND VPWR VPWR sky130_fd_sc_hd__decap_3
XFILLER_26_83 VGND VGND VPWR VPWR sky130_fd_sc_hd__fill_1
XFILLER_60_248 VGND VGND VPWR VPWR sky130_fd_sc_hd__decap_3
XFILLER_60_259 VGND VGND VPWR VPWR sky130_fd_sc_hd__decap_3
XFILLER_54_7 VGND VGND VPWR VPWR sky130_fd_sc_hd__fill_2
XFILLER_9_179 VGND VGND VPWR VPWR sky130_fd_sc_hd__decap_3
X_1410_ _2661_/Q _2660_/Q _2018_/A VGND VGND VPWR VPWR _1411_/B sky130_fd_sc_hd__o21ai_2
X_1341_ _2326_/A VGND VGND VPWR VPWR _2498_/A sky130_fd_sc_hd__inv_2
X_2390_ _2452_/A _2426_/B _2389_/Y VGND VGND VPWR VPWR _2460_/B sky130_fd_sc_hd__o21ai_2
XFILLER_36_278 VGND VGND VPWR VPWR sky130_fd_sc_hd__decap_3
X_1608_ _1608_/A _1608_/B VGND VGND VPWR VPWR _1608_/X sky130_fd_sc_hd__and2_2
X_2657_ clkload8/A _2657_/D VGND VGND VPWR VPWR _2657_/Q sky130_fd_sc_hd__dfxtp_2
X_2588_ _2588_/A1 _1352_/A _2602_/B1 _2587_/X VGND VGND VPWR VPWR _2588_/X sky130_fd_sc_hd__o211a_2
XFILLER_63_26 VGND VGND VPWR VPWR sky130_fd_sc_hd__fill_1
XFILLER_12_85 VGND VGND VPWR VPWR sky130_fd_sc_hd__fill_2
XFILLER_2_300 VGND VGND VPWR VPWR sky130_fd_sc_hd__decap_3
XPHY_EDGE_ROW_0_Left_65 VGND VGND VPWR VPWR sky130_fd_sc_hd__decap_3
XFILLER_18_267 VGND VGND VPWR VPWR sky130_fd_sc_hd__fill_1
XFILLER_33_259 VGND VGND VPWR VPWR sky130_fd_sc_hd__fill_2
XPHY_EDGE_ROW_16_Right_16 VGND VGND VPWR VPWR sky130_fd_sc_hd__decap_3
XFILLER_41_281 VGND VGND VPWR VPWR sky130_fd_sc_hd__fill_1
XFILLER_53_70 VGND VGND VPWR VPWR sky130_fd_sc_hd__fill_1
XPHY_EDGE_ROW_25_Right_25 VGND VGND VPWR VPWR sky130_fd_sc_hd__decap_3
X_1890_ _1890_/A _1890_/B VGND VGND VPWR VPWR _1890_/X sky130_fd_sc_hd__or2_2
XFILLER_45_3 VGND VGND VPWR VPWR sky130_fd_sc_hd__decap_3
XFILLER_5_182 VGND VGND VPWR VPWR sky130_fd_sc_hd__fill_2
X_2442_ _2449_/B _2439_/Y _2523_/A _2441_/X VGND VGND VPWR VPWR _2442_/Y sky130_fd_sc_hd__o31ai_2
X_2373_ _2423_/B VGND VGND VPWR VPWR _2485_/A sky130_fd_sc_hd__inv_2
XFILLER_56_307 VGND VGND VPWR VPWR sky130_fd_sc_hd__fill_1
XFILLER_56_318 VGND VGND VPWR VPWR sky130_fd_sc_hd__fill_2
XPHY_EDGE_ROW_34_Right_34 VGND VGND VPWR VPWR sky130_fd_sc_hd__decap_3
XTAP_TAPCELL_ROW_19_240 VGND VPWR sky130_fd_sc_hd__tapvpwrvgnd_1
X_1324_ _2696_/Q _1323_/B _2708_/A VGND VGND VPWR VPWR _1325_/B sky130_fd_sc_hd__o21a_2
XFILLER_24_248 VGND VGND VPWR VPWR sky130_fd_sc_hd__fill_1
XPHY_EDGE_ROW_43_Right_43 VGND VGND VPWR VPWR sky130_fd_sc_hd__decap_3
XPHY_EDGE_ROW_52_Right_52 VGND VGND VPWR VPWR sky130_fd_sc_hd__decap_3
XFILLER_15_204 VGND VGND VPWR VPWR sky130_fd_sc_hd__decap_3
XFILLER_23_281 VGND VGND VPWR VPWR sky130_fd_sc_hd__fill_2
XFILLER_30_218 VGND VGND VPWR VPWR sky130_fd_sc_hd__decap_3
XPHY_EDGE_ROW_36_Left_101 VGND VGND VPWR VPWR sky130_fd_sc_hd__decap_3
XPHY_EDGE_ROW_61_Right_61 VGND VGND VPWR VPWR sky130_fd_sc_hd__decap_3
XTAP_TAPCELL_ROW_25_276 VGND VPWR sky130_fd_sc_hd__tapvpwrvgnd_1
XPHY_EDGE_ROW_45_Left_110 VGND VGND VPWR VPWR sky130_fd_sc_hd__decap_3
XFILLER_14_292 VGND VGND VPWR VPWR sky130_fd_sc_hd__decap_3
XFILLER_64_91 VGND VGND VPWR VPWR sky130_fd_sc_hd__decap_3
X_1942_ _1943_/A _1947_/C VGND VGND VPWR VPWR _1953_/A sky130_fd_sc_hd__nand2_2
X_1873_ _2618_/A _2656_/Q VGND VGND VPWR VPWR _2015_/B sky130_fd_sc_hd__or2_2
XFILLER_28_29 VGND VGND VPWR VPWR sky130_fd_sc_hd__fill_1
XFILLER_56_104 VGND VGND VPWR VPWR sky130_fd_sc_hd__decap_3
X_2425_ _2689_/Q _2425_/B VGND VGND VPWR VPWR _2426_/A sky130_fd_sc_hd__and2_2
X_2356_ _2698_/Q _2403_/B VGND VGND VPWR VPWR _2418_/A sky130_fd_sc_hd__and2_2
XFILLER_56_137 VGND VGND VPWR VPWR sky130_fd_sc_hd__decap_3
XFILLER_64_181 VGND VGND VPWR VPWR sky130_fd_sc_hd__decap_3
X_1307_ _1314_/A _2707_/A VGND VGND VPWR VPWR _1308_/B sky130_fd_sc_hd__nand2_2
X_2287_ _2259_/Y _2286_/X _2326_/A VGND VGND VPWR VPWR _2683_/D sky130_fd_sc_hd__a21oi_4
XFILLER_20_251 VGND VGND VPWR VPWR sky130_fd_sc_hd__fill_1
XFILLER_20_262 VGND VGND VPWR VPWR sky130_fd_sc_hd__decap_3
XTAP_TAPCELL_ROW_22_257 VGND VPWR sky130_fd_sc_hd__tapvpwrvgnd_1
XFILLER_34_50 VGND VGND VPWR VPWR sky130_fd_sc_hd__fill_1
XFILLER_43_310 VGND VGND VPWR VPWR sky130_fd_sc_hd__decap_3
X_2210_ _2210_/A _2210_/B VGND VGND VPWR VPWR _2249_/A sky130_fd_sc_hd__and2_2
XFILLER_38_126 VGND VGND VPWR VPWR sky130_fd_sc_hd__decap_3
XFILLER_38_159 VGND VGND VPWR VPWR sky130_fd_sc_hd__decap_3
XFILLER_46_192 VGND VGND VPWR VPWR sky130_fd_sc_hd__decap_3
XFILLER_53_107 VGND VGND VPWR VPWR sky130_fd_sc_hd__decap_3
XTAP_TAPCELL_ROW_36_338 VGND VPWR sky130_fd_sc_hd__tapvpwrvgnd_1
X_2141_ _2101_/A _2101_/B _2091_/B VGND VGND VPWR VPWR _2182_/B sky130_fd_sc_hd__o21ai_2
X_2072_ _1953_/A _1953_/B _2070_/A _2070_/B VGND VGND VPWR VPWR _2072_/X sky130_fd_sc_hd__a211o_2
XFILLER_61_162 VGND VGND VPWR VPWR sky130_fd_sc_hd__decap_3
XTAP_TAPCELL_ROW_44_382 VGND VPWR sky130_fd_sc_hd__tapvpwrvgnd_1
X_1925_ _2657_/Q _2656_/Q _1976_/D VGND VGND VPWR VPWR _1930_/D sky130_fd_sc_hd__and3_2
X_1856_ _1910_/A _1856_/B VGND VGND VPWR VPWR _1858_/B sky130_fd_sc_hd__xnor2_2
X_1787_ _1801_/B _1787_/B VGND VGND VPWR VPWR _1803_/B sky130_fd_sc_hd__xor2_2
XFILLER_29_148 VGND VGND VPWR VPWR sky130_fd_sc_hd__decap_3
XPHY_EDGE_ROW_2_Right_2 VGND VGND VPWR VPWR sky130_fd_sc_hd__decap_3
X_2408_ _2418_/A _2418_/B _2419_/A VGND VGND VPWR VPWR _2512_/C sky130_fd_sc_hd__o21bai_2
X_2339_ _2681_/Q _2354_/B VGND VGND VPWR VPWR _2351_/B sky130_fd_sc_hd__or2_2
XFILLER_40_302 VGND VGND VPWR VPWR sky130_fd_sc_hd__decap_3
XFILLER_52_173 VGND VGND VPWR VPWR sky130_fd_sc_hd__decap_3
XFILLER_55_49 VGND VGND VPWR VPWR sky130_fd_sc_hd__decap_3
XFILLER_4_203 VGND VGND VPWR VPWR sky130_fd_sc_hd__decap_3
XFILLER_4_247 VGND VGND VPWR VPWR sky130_fd_sc_hd__decap_3
Xinput310 hold669/X VGND VGND VPWR VPWR hold670/A sky130_fd_sc_hd__buf_2
Xinput321 hold649/X VGND VGND VPWR VPWR hold650/A sky130_fd_sc_hd__buf_2
XFILLER_35_129 VGND VGND VPWR VPWR sky130_fd_sc_hd__fill_2
Xinput332 hold496/X VGND VGND VPWR VPWR hold497/A sky130_fd_sc_hd__buf_2
Xinput343 hold607/X VGND VGND VPWR VPWR hold596/A sky130_fd_sc_hd__buf_2
XFILLER_43_140 VGND VGND VPWR VPWR sky130_fd_sc_hd__decap_3
XTAP_TAPCELL_ROW_33_319 VGND VPWR sky130_fd_sc_hd__tapvpwrvgnd_1
XTAP_TAPCELL_ROW_41_363 VGND VPWR sky130_fd_sc_hd__tapvpwrvgnd_1
XANTENNA_3 b_in[3] VGND VGND VPWR VPWR sky130_fd_sc_hd__diode_2
X_1572_ _1572_/A _1572_/B VGND VGND VPWR VPWR _1777_/B sky130_fd_sc_hd__xor2_2
X_1641_ _1661_/A _1661_/B _1640_/Y VGND VGND VPWR VPWR _1644_/A sky130_fd_sc_hd__a21oi_2
X_2690_ _2692_/CLK _2690_/D VGND VGND VPWR VPWR _2690_/Q sky130_fd_sc_hd__dfxtp_2
X_1710_ _1727_/A _1710_/A2 _1728_/A2 _1727_/B VGND VGND VPWR VPWR _1711_/B sky130_fd_sc_hd__a22o_2
X_2124_ _2124_/A _2197_/B _2663_/Q _2132_/A VGND VGND VPWR VPWR _2124_/X sky130_fd_sc_hd__and4_2
XFILLER_34_173 VGND VGND VPWR VPWR sky130_fd_sc_hd__decap_3
XTAP_TAPCELL_ROW_64_488 VGND VPWR sky130_fd_sc_hd__tapvpwrvgnd_1
X_2055_ _2055_/A _2055_/B VGND VGND VPWR VPWR _2055_/X sky130_fd_sc_hd__and2_2
XFILLER_41_18 VGND VGND VPWR VPWR sky130_fd_sc_hd__fill_2
XFILLER_41_29 VGND VGND VPWR VPWR sky130_fd_sc_hd__decap_3
X_1908_ _1960_/B2 _1555_/B _2095_/B1 _1908_/B2 VGND VGND VPWR VPWR _1912_/A sky130_fd_sc_hd__a22o_2
X_1839_ _1784_/A _1784_/B _1838_/X VGND VGND VPWR VPWR _1850_/A sky130_fd_sc_hd__o21a_2
Xhold520 _2613_/X VGND VGND VPWR VPWR _2655_/D sky130_fd_sc_hd__clkbuf_2
Xhold531 hold531/A VGND VGND VPWR VPWR hold531/X sky130_fd_sc_hd__clkbuf_2
Xhold542 _2611_/X VGND VGND VPWR VPWR _2654_/D sky130_fd_sc_hd__clkbuf_2
Xhold553 _1347_/X VGND VGND VPWR VPWR _2660_/D sky130_fd_sc_hd__clkbuf_2
Xhold564 hold564/A VGND VGND VPWR VPWR hold564/X sky130_fd_sc_hd__clkbuf_2
Xhold575 b_in[6] VGND VGND VPWR VPWR hold575/X sky130_fd_sc_hd__clkbuf_2
Xhold586 b_in[8] VGND VGND VPWR VPWR hold586/X sky130_fd_sc_hd__clkbuf_2
Xhold597 _2325_/X VGND VGND VPWR VPWR _2326_/B sky130_fd_sc_hd__clkbuf_2
XFILLER_57_210 VGND VGND VPWR VPWR sky130_fd_sc_hd__decap_3
XFILLER_57_243 VGND VGND VPWR VPWR sky130_fd_sc_hd__decap_3
XFILLER_40_154 VGND VGND VPWR VPWR sky130_fd_sc_hd__fill_1
XFILLER_31_73 VGND VGND VPWR VPWR sky130_fd_sc_hd__decap_3
XFILLER_0_250 VGND VGND VPWR VPWR sky130_fd_sc_hd__fill_2
XFILLER_0_294 VGND VGND VPWR VPWR sky130_fd_sc_hd__decap_3
XFILLER_16_184 VGND VGND VPWR VPWR sky130_fd_sc_hd__fill_2
XFILLER_48_265 VGND VGND VPWR VPWR sky130_fd_sc_hd__decap_3
XFILLER_48_287 VGND VGND VPWR VPWR sky130_fd_sc_hd__decap_3
XFILLER_48_298 VGND VGND VPWR VPWR sky130_fd_sc_hd__fill_2
XFILLER_63_246 VGND VGND VPWR VPWR sky130_fd_sc_hd__decap_3
Xplace202 _1727_/B VGND VGND VPWR VPWR _1768_/C sky130_fd_sc_hd__buf_1
Xplace279 _1960_/B2 VGND VGND VPWR VPWR _1606_/A1 sky130_fd_sc_hd__buf_1
Xplace268 _2632_/Q VGND VGND VPWR VPWR _2022_/A1 sky130_fd_sc_hd__buf_1
Xplace257 _2655_/Q VGND VGND VPWR VPWR _1700_/A1 sky130_fd_sc_hd__buf_1
Xplace246 _2132_/A VGND VGND VPWR VPWR _2045_/A1 sky130_fd_sc_hd__clkbuf_1
Xplace235 _1380_/Y VGND VGND VPWR VPWR _1702_/A3 sky130_fd_sc_hd__buf_1
Xplace224 _1416_/X VGND VGND VPWR VPWR _1625_/B sky130_fd_sc_hd__buf_1
Xplace213 _2330_/Y VGND VGND VPWR VPWR _2488_/A2 sky130_fd_sc_hd__buf_1
XFILLER_31_165 VGND VGND VPWR VPWR sky130_fd_sc_hd__decap_3
X_1555_ _1555_/A _1555_/B _1555_/C VGND VGND VPWR VPWR _1804_/A sky130_fd_sc_hd__nand3_2
X_1624_ _1671_/A _1624_/B VGND VGND VPWR VPWR _1639_/B sky130_fd_sc_hd__xor2_2
X_2673_ _2689_/CLK _2673_/D VGND VGND VPWR VPWR _2673_/Q sky130_fd_sc_hd__dfxtp_2
XFILLER_39_254 VGND VGND VPWR VPWR sky130_fd_sc_hd__decap_3
XFILLER_39_276 VGND VGND VPWR VPWR sky130_fd_sc_hd__decap_3
X_1486_ _1610_/A _1610_/B _1485_/X VGND VGND VPWR VPWR _1497_/A sky130_fd_sc_hd__a21oi_2
X_2107_ _2107_/A _2107_/B VGND VGND VPWR VPWR _2107_/Y sky130_fd_sc_hd__nor2_2
XFILLER_10_305 VGND VGND VPWR VPWR sky130_fd_sc_hd__decap_3
XFILLER_22_110 VGND VGND VPWR VPWR sky130_fd_sc_hd__fill_1
XFILLER_22_165 VGND VGND VPWR VPWR sky130_fd_sc_hd__decap_3
XFILLER_54_279 VGND VGND VPWR VPWR sky130_fd_sc_hd__decap_3
XTAP_TAPCELL_ROW_52_425 VGND VPWR sky130_fd_sc_hd__tapvpwrvgnd_1
X_2038_ _1792_/A _2676_/Q _2036_/Y _2037_/X VGND VGND VPWR VPWR _2039_/B sky130_fd_sc_hd__o2bb2a_2
Xclkbuf_4_13_0_clk clkbuf_0_clk/X VGND VGND VPWR VPWR _2702_/CLK sky130_fd_sc_hd__clkbuf_8
XFILLER_45_213 VGND VGND VPWR VPWR sky130_fd_sc_hd__decap_3
XFILLER_45_246 VGND VGND VPWR VPWR sky130_fd_sc_hd__decap_3
XFILLER_53_290 VGND VGND VPWR VPWR sky130_fd_sc_hd__fill_1
X_1340_ _1340_/A _2614_/B VGND VGND VPWR VPWR _1340_/X sky130_fd_sc_hd__or2_2
XTAP_TAPCELL_ROW_8_180 VGND VPWR sky130_fd_sc_hd__tapvpwrvgnd_1
XFILLER_51_216 VGND VGND VPWR VPWR sky130_fd_sc_hd__decap_3
X_2656_ clkload8/A _2656_/D VGND VGND VPWR VPWR _2656_/Q sky130_fd_sc_hd__dfxtp_2
X_1469_ _1469_/A _1469_/B VGND VGND VPWR VPWR _1469_/Y sky130_fd_sc_hd__nor2_2
X_1538_ _2668_/Q _1469_/B _1537_/X VGND VGND VPWR VPWR _1538_/X sky130_fd_sc_hd__a21o_2
X_1607_ _1706_/A _1607_/B VGND VGND VPWR VPWR _1637_/B sky130_fd_sc_hd__xor2_2
X_2587_ _2587_/A _2645_/Q VGND VGND VPWR VPWR _2587_/X sky130_fd_sc_hd__or2_2
XFILLER_10_102 VGND VGND VPWR VPWR sky130_fd_sc_hd__fill_1
XFILLER_10_157 VGND VGND VPWR VPWR sky130_fd_sc_hd__fill_2
XFILLER_35_290 VGND VGND VPWR VPWR sky130_fd_sc_hd__fill_1
XFILLER_2_312 VGND VGND VPWR VPWR sky130_fd_sc_hd__decap_3
XFILLER_53_82 VGND VGND VPWR VPWR sky130_fd_sc_hd__decap_3
XTAP_TAPCELL_ROW_11_196 VGND VPWR sky130_fd_sc_hd__tapvpwrvgnd_1
X_2510_ _2525_/A _2510_/B VGND VGND VPWR VPWR _2699_/D sky130_fd_sc_hd__and2_2
XFILLER_38_3 VGND VGND VPWR VPWR sky130_fd_sc_hd__decap_3
XFILLER_5_161 VGND VGND VPWR VPWR sky130_fd_sc_hd__fill_1
X_1323_ _2696_/Q _1323_/B VGND VGND VPWR VPWR _1323_/X sky130_fd_sc_hd__xor2_2
X_2441_ _2448_/A _2416_/X _2441_/S VGND VGND VPWR VPWR _2441_/X sky130_fd_sc_hd__mux2_2
X_2372_ _2693_/Q _2372_/B _2372_/C VGND VGND VPWR VPWR _2423_/B sky130_fd_sc_hd__and3b_2
XTAP_TAPCELL_ROW_19_241 VGND VPWR sky130_fd_sc_hd__tapvpwrvgnd_1
X_2708_ _2708_/A VGND VGND VPWR VPWR _2708_/X sky130_fd_sc_hd__buf_2
X_2639_ clkload8/A _2639_/D VGND VGND VPWR VPWR _2639_/Q sky130_fd_sc_hd__dfxtp_2
XFILLER_59_157 VGND VGND VPWR VPWR sky130_fd_sc_hd__fill_1
XFILLER_59_179 VGND VGND VPWR VPWR sky130_fd_sc_hd__decap_3
XFILLER_15_216 VGND VGND VPWR VPWR sky130_fd_sc_hd__decap_3
XTAP_TAPCELL_ROW_25_277 VGND VPWR sky130_fd_sc_hd__tapvpwrvgnd_1
XFILLER_0_34 VGND VGND VPWR VPWR sky130_fd_sc_hd__fill_1
XFILLER_0_78 VGND VGND VPWR VPWR sky130_fd_sc_hd__fill_2
XFILLER_48_60 VGND VGND VPWR VPWR sky130_fd_sc_hd__decap_3
XFILLER_61_311 VGND VGND VPWR VPWR sky130_fd_sc_hd__decap_3
XFILLER_64_70 VGND VGND VPWR VPWR sky130_fd_sc_hd__decap_3
X_1941_ _1941_/A _1954_/B VGND VGND VPWR VPWR _1947_/C sky130_fd_sc_hd__xnor2_2
X_1872_ _1872_/A VGND VGND VPWR VPWR _1872_/Y sky130_fd_sc_hd__inv_2
Xmax_cap679 _1523_/A VGND VGND VPWR VPWR _1671_/A sky130_fd_sc_hd__buf_6
XFILLER_29_308 VGND VGND VPWR VPWR sky130_fd_sc_hd__decap_3
XFILLER_56_116 VGND VGND VPWR VPWR sky130_fd_sc_hd__decap_3
X_1306_ _2655_/Q VGND VGND VPWR VPWR _2621_/A sky130_fd_sc_hd__inv_2
X_2424_ _2452_/A _2424_/B VGND VGND VPWR VPWR _2428_/A sky130_fd_sc_hd__nor2_2
X_2355_ _2681_/Q _2355_/B VGND VGND VPWR VPWR _2403_/B sky130_fd_sc_hd__xnor2_2
X_2286_ _2286_/A _2286_/B _2285_/X VGND VGND VPWR VPWR _2286_/X sky130_fd_sc_hd__or3b_4
XFILLER_12_208 VGND VGND VPWR VPWR sky130_fd_sc_hd__decap_3
XFILLER_44_29 VGND VGND VPWR VPWR sky130_fd_sc_hd__decap_3
XFILLER_60_39 VGND VGND VPWR VPWR sky130_fd_sc_hd__decap_3
XTAP_TAPCELL_ROW_22_258 VGND VPWR sky130_fd_sc_hd__tapvpwrvgnd_1
XFILLER_47_116 VGND VGND VPWR VPWR sky130_fd_sc_hd__fill_1
XFILLER_47_149 VGND VGND VPWR VPWR sky130_fd_sc_hd__decap_3
XFILLER_55_160 VGND VGND VPWR VPWR sky130_fd_sc_hd__decap_3
XFILLER_50_72 VGND VGND VPWR VPWR sky130_fd_sc_hd__decap_3
XFILLER_7_256 VGND VGND VPWR VPWR sky130_fd_sc_hd__decap_3
XFILLER_59_70 VGND VGND VPWR VPWR sky130_fd_sc_hd__decap_3
X_2140_ _2140_/A _2140_/B VGND VGND VPWR VPWR _2182_/A sky130_fd_sc_hd__xor2_2
XFILLER_61_141 VGND VGND VPWR VPWR sky130_fd_sc_hd__decap_3
X_2071_ _1900_/A _2071_/B _2071_/C VGND VGND VPWR VPWR _2071_/Y sky130_fd_sc_hd__nand3b_2
X_1924_ _2618_/A _2656_/Q VGND VGND VPWR VPWR _1930_/A sky130_fd_sc_hd__and2_2
X_1855_ _2008_/B2 _1474_/B _2009_/B1 _1960_/B2 VGND VGND VPWR VPWR _1856_/B sky130_fd_sc_hd__a22o_2
X_1786_ _1584_/A _1584_/B _1785_/X VGND VGND VPWR VPWR _1787_/B sky130_fd_sc_hd__o21a_2
XFILLER_29_116 VGND VGND VPWR VPWR sky130_fd_sc_hd__decap_3
XFILLER_44_119 VGND VGND VPWR VPWR sky130_fd_sc_hd__decap_3
X_2407_ _2512_/B _2407_/B VGND VGND VPWR VPWR _2419_/A sky130_fd_sc_hd__nand2_2
X_2338_ _2680_/Q _2679_/Q _2360_/B VGND VGND VPWR VPWR _2354_/B sky130_fd_sc_hd__or3_2
X_2269_ _2295_/A _2270_/B VGND VGND VPWR VPWR _2271_/A sky130_fd_sc_hd__nand2_2
XFILLER_52_141 VGND VGND VPWR VPWR sky130_fd_sc_hd__decap_3
XFILLER_52_185 VGND VGND VPWR VPWR sky130_fd_sc_hd__decap_3
XPHY_EDGE_ROW_64_Left_129 VGND VGND VPWR VPWR sky130_fd_sc_hd__decap_3
XFILLER_4_259 VGND VGND VPWR VPWR sky130_fd_sc_hd__decap_3
Xinput311 hold641/X VGND VGND VPWR VPWR hold642/A sky130_fd_sc_hd__buf_2
Xinput322 hold645/X VGND VGND VPWR VPWR hold646/A sky130_fd_sc_hd__buf_2
Xinput333 hold501/X VGND VGND VPWR VPWR hold502/A sky130_fd_sc_hd__buf_2
Xinput344 hold676/X VGND VGND VPWR VPWR hold550/A sky130_fd_sc_hd__buf_2
XFILLER_16_300 VGND VGND VPWR VPWR sky130_fd_sc_hd__decap_3
XFILLER_45_72 VGND VGND VPWR VPWR sky130_fd_sc_hd__fill_1
XFILLER_61_60 VGND VGND VPWR VPWR sky130_fd_sc_hd__decap_3
XFILLER_61_93 VGND VGND VPWR VPWR sky130_fd_sc_hd__decap_3
XTAP_TAPCELL_ROW_41_364 VGND VPWR sky130_fd_sc_hd__tapvpwrvgnd_1
XANTENNA_4 a_in[7] VGND VGND VPWR VPWR sky130_fd_sc_hd__diode_2
XFILLER_3_281 VGND VGND VPWR VPWR sky130_fd_sc_hd__fill_1
X_1571_ _1916_/A1 _1603_/A2 _1380_/Y _1709_/B _1877_/A1 VGND VGND VPWR VPWR _1572_/B
+ sky130_fd_sc_hd__a32o_2
X_1640_ _1640_/A _1640_/B VGND VGND VPWR VPWR _1640_/Y sky130_fd_sc_hd__nor2_2
XFILLER_20_3 VGND VGND VPWR VPWR sky130_fd_sc_hd__fill_2
XFILLER_26_119 VGND VGND VPWR VPWR sky130_fd_sc_hd__decap_3
X_2123_ _2125_/C _2125_/D _2132_/A VGND VGND VPWR VPWR _2126_/A sky130_fd_sc_hd__a21oi_2
XFILLER_19_182 VGND VGND VPWR VPWR sky130_fd_sc_hd__decap_3
XFILLER_34_141 VGND VGND VPWR VPWR sky130_fd_sc_hd__fill_1
XFILLER_34_152 VGND VGND VPWR VPWR sky130_fd_sc_hd__decap_3
XFILLER_34_185 VGND VGND VPWR VPWR sky130_fd_sc_hd__decap_3
XTAP_TAPCELL_ROW_64_489 VGND VPWR sky130_fd_sc_hd__tapvpwrvgnd_1
X_2054_ _2054_/A _2054_/B VGND VGND VPWR VPWR _2062_/A sky130_fd_sc_hd__nand2_2
Xhold510 _2580_/X VGND VGND VPWR VPWR _2641_/D sky130_fd_sc_hd__clkbuf_2
X_1907_ _1871_/A _1871_/B _1868_/A VGND VGND VPWR VPWR _1914_/A sky130_fd_sc_hd__a21o_2
X_1838_ _1838_/A _1838_/B VGND VGND VPWR VPWR _1838_/X sky130_fd_sc_hd__or2_2
Xhold521 hold672/X VGND VGND VPWR VPWR hold673/A sky130_fd_sc_hd__clkbuf_2
Xhold532 hold532/A VGND VGND VPWR VPWR hold532/X sky130_fd_sc_hd__clkbuf_2
Xhold543 b_in[10] VGND VGND VPWR VPWR hold543/X sky130_fd_sc_hd__clkbuf_2
Xhold554 b_in[12] VGND VGND VPWR VPWR hold554/X sky130_fd_sc_hd__clkbuf_2
Xhold565 _2603_/A VGND VGND VPWR VPWR _1357_/A sky130_fd_sc_hd__clkbuf_2
Xhold576 hold576/A VGND VGND VPWR VPWR hold576/X sky130_fd_sc_hd__clkbuf_2
Xhold587 hold587/A VGND VGND VPWR VPWR hold587/X sky130_fd_sc_hd__clkbuf_2
Xhold598 _2326_/Y VGND VGND VPWR VPWR _2686_/D sky130_fd_sc_hd__clkbuf_2
X_1769_ _1976_/D _1768_/C _1768_/A VGND VGND VPWR VPWR _1831_/B sky130_fd_sc_hd__a21o_2
XFILLER_25_130 VGND VGND VPWR VPWR sky130_fd_sc_hd__fill_1
XFILLER_25_141 VGND VGND VPWR VPWR sky130_fd_sc_hd__fill_1
XFILLER_57_277 VGND VGND VPWR VPWR sky130_fd_sc_hd__decap_3
XFILLER_25_163 VGND VGND VPWR VPWR sky130_fd_sc_hd__decap_3
XFILLER_40_111 VGND VGND VPWR VPWR sky130_fd_sc_hd__decap_3
XFILLER_9_318 VGND VGND VPWR VPWR sky130_fd_sc_hd__fill_2
XFILLER_31_63 VGND VGND VPWR VPWR sky130_fd_sc_hd__fill_1
XFILLER_31_85 VGND VGND VPWR VPWR sky130_fd_sc_hd__decap_3
XFILLER_0_262 VGND VGND VPWR VPWR sky130_fd_sc_hd__decap_3
XFILLER_48_244 VGND VGND VPWR VPWR sky130_fd_sc_hd__decap_3
XFILLER_16_141 VGND VGND VPWR VPWR sky130_fd_sc_hd__decap_3
XFILLER_16_163 VGND VGND VPWR VPWR sky130_fd_sc_hd__decap_3
XFILLER_63_225 VGND VGND VPWR VPWR sky130_fd_sc_hd__decap_3
XFILLER_63_258 VGND VGND VPWR VPWR sky130_fd_sc_hd__decap_3
Xplace203 _1700_/B2 VGND VGND VPWR VPWR _1727_/B sky130_fd_sc_hd__buf_1
Xplace269 _2631_/Q VGND VGND VPWR VPWR _2553_/B sky130_fd_sc_hd__buf_1
Xplace258 _2636_/Q VGND VGND VPWR VPWR _2313_/A sky130_fd_sc_hd__buf_1
Xplace247 _2662_/Q VGND VGND VPWR VPWR _2132_/A sky130_fd_sc_hd__buf_1
Xplace236 _1379_/X VGND VGND VPWR VPWR _1603_/A2 sky130_fd_sc_hd__buf_1
Xplace225 _1919_/A VGND VGND VPWR VPWR _1595_/A sky130_fd_sc_hd__buf_1
Xplace214 _2368_/A VGND VGND VPWR VPWR _2354_/A sky130_fd_sc_hd__buf_1
X_2672_ _2689_/CLK _2672_/D VGND VGND VPWR VPWR _2672_/Q sky130_fd_sc_hd__dfxtp_2
X_1485_ _1485_/A _1485_/B VGND VGND VPWR VPWR _1485_/X sky130_fd_sc_hd__and2_2
X_1554_ _1910_/A _1554_/B VGND VGND VPWR VPWR _1555_/C sky130_fd_sc_hd__xnor2_2
X_1623_ _1710_/A2 _1670_/B _1411_/X _1728_/A2 VGND VGND VPWR VPWR _1624_/B sky130_fd_sc_hd__a22o_2
.ends
